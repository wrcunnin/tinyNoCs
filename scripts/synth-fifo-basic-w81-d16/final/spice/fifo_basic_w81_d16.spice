* NGSPICE file created from fifo_basic_w81_d16.ext - technology: sky130A

* Black-box entry subcircuit for sky130_fd_sc_hd__fill_1 abstract view
.subckt sky130_fd_sc_hd__fill_1 VGND VNB VPB VPWR
.ends

* Black-box entry subcircuit for sky130_fd_sc_hd__decap_3 abstract view
.subckt sky130_fd_sc_hd__decap_3 VGND VNB VPB VPWR
.ends

* Black-box entry subcircuit for sky130_fd_sc_hd__fill_2 abstract view
.subckt sky130_fd_sc_hd__fill_2 VGND VNB VPB VPWR
.ends

* Black-box entry subcircuit for sky130_fd_sc_hd__dfrtp_2 abstract view
.subckt sky130_fd_sc_hd__dfrtp_2 CLK D RESET_B VGND VNB VPB VPWR Q
.ends

* Black-box entry subcircuit for sky130_fd_sc_hd__mux2_4 abstract view
.subckt sky130_fd_sc_hd__mux2_4 A0 A1 S VGND VNB VPB VPWR X
.ends

* Black-box entry subcircuit for sky130_fd_sc_hd__or2_2 abstract view
.subckt sky130_fd_sc_hd__or2_2 A B VGND VNB VPB VPWR X
.ends

* Black-box entry subcircuit for sky130_fd_sc_hd__mux2_2 abstract view
.subckt sky130_fd_sc_hd__mux2_2 A0 A1 S VGND VNB VPB VPWR X
.ends

* Black-box entry subcircuit for sky130_fd_sc_hd__buf_1 abstract view
.subckt sky130_fd_sc_hd__buf_1 A VGND VNB VPB VPWR X
.ends

* Black-box entry subcircuit for sky130_fd_sc_hd__tapvpwrvgnd_1 abstract view
.subckt sky130_fd_sc_hd__tapvpwrvgnd_1 VGND VPWR
.ends

* Black-box entry subcircuit for sky130_fd_sc_hd__o21a_2 abstract view
.subckt sky130_fd_sc_hd__o21a_2 A1 A2 B1 VGND VNB VPB VPWR X
.ends

* Black-box entry subcircuit for sky130_fd_sc_hd__a32o_2 abstract view
.subckt sky130_fd_sc_hd__a32o_2 A1 A2 A3 B1 B2 VGND VNB VPB VPWR X
.ends

* Black-box entry subcircuit for sky130_fd_sc_hd__dlygate4sd3_1 abstract view
.subckt sky130_fd_sc_hd__dlygate4sd3_1 A VGND VNB VPB VPWR X
.ends

* Black-box entry subcircuit for sky130_fd_sc_hd__clkbuf_8 abstract view
.subckt sky130_fd_sc_hd__clkbuf_8 A VGND VNB VPB VPWR X
.ends

* Black-box entry subcircuit for sky130_fd_sc_hd__and2_2 abstract view
.subckt sky130_fd_sc_hd__and2_2 A B VGND VNB VPB VPWR X
.ends

* Black-box entry subcircuit for sky130_fd_sc_hd__o22a_2 abstract view
.subckt sky130_fd_sc_hd__o22a_2 A1 A2 B1 B2 VGND VNB VPB VPWR X
.ends

* Black-box entry subcircuit for sky130_fd_sc_hd__buf_2 abstract view
.subckt sky130_fd_sc_hd__buf_2 A VGND VNB VPB VPWR X
.ends

* Black-box entry subcircuit for sky130_fd_sc_hd__mux4_2 abstract view
.subckt sky130_fd_sc_hd__mux4_2 A0 A1 A2 A3 S0 S1 VGND VNB VPB VPWR X
.ends

* Black-box entry subcircuit for sky130_fd_sc_hd__o32a_2 abstract view
.subckt sky130_fd_sc_hd__o32a_2 A1 A2 A3 B1 B2 VGND VNB VPB VPWR X
.ends

* Black-box entry subcircuit for sky130_fd_sc_hd__clkbuf_16 abstract view
.subckt sky130_fd_sc_hd__clkbuf_16 A VGND VNB VPB VPWR X
.ends

* Black-box entry subcircuit for sky130_fd_sc_hd__clkdlybuf4s25_1 abstract view
.subckt sky130_fd_sc_hd__clkdlybuf4s25_1 A VGND VNB VPB VPWR X
.ends

* Black-box entry subcircuit for sky130_fd_sc_hd__a221o_2 abstract view
.subckt sky130_fd_sc_hd__a221o_2 A1 A2 B1 B2 C1 VGND VNB VPB VPWR X
.ends

* Black-box entry subcircuit for sky130_fd_sc_hd__buf_4 abstract view
.subckt sky130_fd_sc_hd__buf_4 A VGND VNB VPB VPWR X
.ends

* Black-box entry subcircuit for sky130_fd_sc_hd__clkbuf_4 abstract view
.subckt sky130_fd_sc_hd__clkbuf_4 A VGND VNB VPB VPWR X
.ends

* Black-box entry subcircuit for sky130_fd_sc_hd__o221a_2 abstract view
.subckt sky130_fd_sc_hd__o221a_2 A1 A2 B1 B2 C1 VGND VNB VPB VPWR X
.ends

* Black-box entry subcircuit for sky130_fd_sc_hd__nand2_2 abstract view
.subckt sky130_fd_sc_hd__nand2_2 A B VGND VNB VPB VPWR Y
.ends

* Black-box entry subcircuit for sky130_fd_sc_hd__clkbuf_2 abstract view
.subckt sky130_fd_sc_hd__clkbuf_2 A VGND VNB VPB VPWR X
.ends

* Black-box entry subcircuit for sky130_fd_sc_hd__diode_2 abstract view
.subckt sky130_fd_sc_hd__diode_2 DIODE VGND VNB VPB VPWR
.ends

* Black-box entry subcircuit for sky130_fd_sc_hd__buf_6 abstract view
.subckt sky130_fd_sc_hd__buf_6 A VGND VNB VPB VPWR X
.ends

* Black-box entry subcircuit for sky130_fd_sc_hd__mux2_1 abstract view
.subckt sky130_fd_sc_hd__mux2_1 A0 A1 S VGND VNB VPB VPWR X
.ends

* Black-box entry subcircuit for sky130_fd_sc_hd__a21o_2 abstract view
.subckt sky130_fd_sc_hd__a21o_2 A1 A2 B1 VGND VNB VPB VPWR X
.ends

* Black-box entry subcircuit for sky130_fd_sc_hd__a22o_2 abstract view
.subckt sky130_fd_sc_hd__a22o_2 A1 A2 B1 B2 VGND VNB VPB VPWR X
.ends

* Black-box entry subcircuit for sky130_fd_sc_hd__clkbuf_1 abstract view
.subckt sky130_fd_sc_hd__clkbuf_1 A VGND VNB VPB VPWR X
.ends

* Black-box entry subcircuit for sky130_fd_sc_hd__a31o_2 abstract view
.subckt sky130_fd_sc_hd__a31o_2 A1 A2 A3 B1 VGND VNB VPB VPWR X
.ends

* Black-box entry subcircuit for sky130_fd_sc_hd__o211a_2 abstract view
.subckt sky130_fd_sc_hd__o211a_2 A1 A2 B1 C1 VGND VNB VPB VPWR X
.ends

* Black-box entry subcircuit for sky130_fd_sc_hd__bufinv_16 abstract view
.subckt sky130_fd_sc_hd__bufinv_16 A VGND VNB VPB VPWR Y
.ends

* Black-box entry subcircuit for sky130_fd_sc_hd__and3b_2 abstract view
.subckt sky130_fd_sc_hd__and3b_2 A_N B C VGND VNB VPB VPWR X
.ends

* Black-box entry subcircuit for sky130_fd_sc_hd__clkinv_2 abstract view
.subckt sky130_fd_sc_hd__clkinv_2 A VGND VNB VPB VPWR Y
.ends

* Black-box entry subcircuit for sky130_fd_sc_hd__xnor2_2 abstract view
.subckt sky130_fd_sc_hd__xnor2_2 A B VGND VNB VPB VPWR Y
.ends

* Black-box entry subcircuit for sky130_fd_sc_hd__nand4_2 abstract view
.subckt sky130_fd_sc_hd__nand4_2 A B C D VGND VNB VPB VPWR Y
.ends

* Black-box entry subcircuit for sky130_fd_sc_hd__nor2_2 abstract view
.subckt sky130_fd_sc_hd__nor2_2 A B VGND VNB VPB VPWR Y
.ends

* Black-box entry subcircuit for sky130_fd_sc_hd__and4b_2 abstract view
.subckt sky130_fd_sc_hd__and4b_2 A_N B C D VGND VNB VPB VPWR X
.ends

* Black-box entry subcircuit for sky130_fd_sc_hd__nand2b_2 abstract view
.subckt sky130_fd_sc_hd__nand2b_2 A_N B VGND VNB VPB VPWR Y
.ends

* Black-box entry subcircuit for sky130_fd_sc_hd__inv_2 abstract view
.subckt sky130_fd_sc_hd__inv_2 A VGND VNB VPB VPWR Y
.ends

* Black-box entry subcircuit for sky130_fd_sc_hd__dfstp_2 abstract view
.subckt sky130_fd_sc_hd__dfstp_2 CLK D SET_B VGND VNB VPB VPWR Q
.ends

* Black-box entry subcircuit for sky130_fd_sc_hd__or4_4 abstract view
.subckt sky130_fd_sc_hd__or4_4 A B C D VGND VNB VPB VPWR X
.ends

* Black-box entry subcircuit for sky130_fd_sc_hd__o31a_2 abstract view
.subckt sky130_fd_sc_hd__o31a_2 A1 A2 A3 B1 VGND VNB VPB VPWR X
.ends

* Black-box entry subcircuit for sky130_fd_sc_hd__or2b_2 abstract view
.subckt sky130_fd_sc_hd__or2b_2 A B_N VGND VNB VPB VPWR X
.ends

* Black-box entry subcircuit for sky130_fd_sc_hd__and2_4 abstract view
.subckt sky130_fd_sc_hd__and2_4 A B VGND VNB VPB VPWR X
.ends

* Black-box entry subcircuit for sky130_fd_sc_hd__a211o_2 abstract view
.subckt sky130_fd_sc_hd__a211o_2 A1 A2 B1 C1 VGND VNB VPB VPWR X
.ends

* Black-box entry subcircuit for sky130_fd_sc_hd__clkinv_4 abstract view
.subckt sky130_fd_sc_hd__clkinv_4 A VGND VNB VPB VPWR Y
.ends

* Black-box entry subcircuit for sky130_fd_sc_hd__a21oi_2 abstract view
.subckt sky130_fd_sc_hd__a21oi_2 A1 A2 B1 VGND VNB VPB VPWR Y
.ends

* Black-box entry subcircuit for sky130_fd_sc_hd__inv_4 abstract view
.subckt sky130_fd_sc_hd__inv_4 A VGND VNB VPB VPWR Y
.ends

* Black-box entry subcircuit for sky130_fd_sc_hd__inv_6 abstract view
.subckt sky130_fd_sc_hd__inv_6 A VGND VNB VPB VPWR Y
.ends

* Black-box entry subcircuit for sky130_fd_sc_hd__and3_2 abstract view
.subckt sky130_fd_sc_hd__and3_2 A B C VGND VNB VPB VPWR X
.ends

* Black-box entry subcircuit for sky130_fd_sc_hd__nor2b_2 abstract view
.subckt sky130_fd_sc_hd__nor2b_2 A B_N VGND VNB VPB VPWR Y
.ends

* Black-box entry subcircuit for sky130_fd_sc_hd__and4_2 abstract view
.subckt sky130_fd_sc_hd__and4_2 A B C D VGND VNB VPB VPWR X
.ends

* Black-box entry subcircuit for sky130_fd_sc_hd__or3_2 abstract view
.subckt sky130_fd_sc_hd__or3_2 A B C VGND VNB VPB VPWR X
.ends

* Black-box entry subcircuit for sky130_fd_sc_hd__o2111a_2 abstract view
.subckt sky130_fd_sc_hd__o2111a_2 A1 A2 B1 C1 D1 VGND VNB VPB VPWR X
.ends

* Black-box entry subcircuit for sky130_fd_sc_hd__nor2_4 abstract view
.subckt sky130_fd_sc_hd__nor2_4 A B VGND VNB VPB VPWR Y
.ends

* Black-box entry subcircuit for sky130_fd_sc_hd__xor2_2 abstract view
.subckt sky130_fd_sc_hd__xor2_2 A B VGND VNB VPB VPWR X
.ends

* Black-box entry subcircuit for sky130_fd_sc_hd__or4b_4 abstract view
.subckt sky130_fd_sc_hd__or4b_4 A B C D_N VGND VNB VPB VPWR X
.ends

* Black-box entry subcircuit for sky130_fd_sc_hd__or3b_2 abstract view
.subckt sky130_fd_sc_hd__or3b_2 A B C_N VGND VNB VPB VPWR X
.ends

* Black-box entry subcircuit for sky130_fd_sc_hd__nor4_2 abstract view
.subckt sky130_fd_sc_hd__nor4_2 A B C D VGND VNB VPB VPWR Y
.ends

* Black-box entry subcircuit for sky130_fd_sc_hd__o21ba_2 abstract view
.subckt sky130_fd_sc_hd__o21ba_2 A1 A2 B1_N VGND VNB VPB VPWR X
.ends

* Black-box entry subcircuit for sky130_fd_sc_hd__or3_4 abstract view
.subckt sky130_fd_sc_hd__or3_4 A B C VGND VNB VPB VPWR X
.ends

* Black-box entry subcircuit for sky130_fd_sc_hd__or4b_2 abstract view
.subckt sky130_fd_sc_hd__or4b_2 A B C D_N VGND VNB VPB VPWR X
.ends

* Black-box entry subcircuit for sky130_fd_sc_hd__buf_8 abstract view
.subckt sky130_fd_sc_hd__buf_8 A VGND VNB VPB VPWR X
.ends

.subckt fifo_basic_w81_d16 CLK VGND VPWR empty full nRST rdata[0] rdata[10] rdata[11]
+ rdata[12] rdata[13] rdata[14] rdata[15] rdata[16] rdata[17] rdata[18] rdata[19]
+ rdata[1] rdata[20] rdata[21] rdata[22] rdata[23] rdata[24] rdata[25] rdata[26] rdata[27]
+ rdata[28] rdata[29] rdata[2] rdata[30] rdata[31] rdata[32] rdata[33] rdata[34] rdata[35]
+ rdata[36] rdata[37] rdata[38] rdata[39] rdata[3] rdata[40] rdata[41] rdata[42] rdata[43]
+ rdata[44] rdata[45] rdata[46] rdata[47] rdata[48] rdata[49] rdata[4] rdata[50] rdata[51]
+ rdata[52] rdata[53] rdata[54] rdata[55] rdata[56] rdata[57] rdata[58] rdata[59]
+ rdata[5] rdata[60] rdata[61] rdata[62] rdata[63] rdata[64] rdata[65] rdata[66] rdata[67]
+ rdata[68] rdata[69] rdata[6] rdata[70] rdata[71] rdata[72] rdata[73] rdata[74] rdata[75]
+ rdata[76] rdata[77] rdata[78] rdata[79] rdata[7] rdata[80] rdata[8] rdata[9] ren
+ wdata[0] wdata[10] wdata[11] wdata[12] wdata[13] wdata[14] wdata[15] wdata[16] wdata[17]
+ wdata[18] wdata[19] wdata[1] wdata[20] wdata[21] wdata[22] wdata[23] wdata[24] wdata[25]
+ wdata[26] wdata[27] wdata[28] wdata[29] wdata[2] wdata[30] wdata[31] wdata[32] wdata[33]
+ wdata[34] wdata[35] wdata[36] wdata[37] wdata[38] wdata[39] wdata[3] wdata[40] wdata[41]
+ wdata[42] wdata[43] wdata[44] wdata[45] wdata[46] wdata[47] wdata[48] wdata[49]
+ wdata[4] wdata[50] wdata[51] wdata[52] wdata[53] wdata[54] wdata[55] wdata[56] wdata[57]
+ wdata[58] wdata[59] wdata[5] wdata[60] wdata[61] wdata[62] wdata[63] wdata[64] wdata[65]
+ wdata[66] wdata[67] wdata[68] wdata[69] wdata[6] wdata[70] wdata[71] wdata[72] wdata[73]
+ wdata[74] wdata[75] wdata[76] wdata[77] wdata[78] wdata[79] wdata[7] wdata[80] wdata[8]
+ wdata[9] wen
XFILLER_100_127 VGND VGND VPWR VPWR sky130_fd_sc_hd__fill_1
XFILLER_67_531 VGND VGND VPWR VPWR sky130_fd_sc_hd__decap_3
XFILLER_55_726 VGND VGND VPWR VPWR sky130_fd_sc_hd__fill_2
XFILLER_54_214 VGND VGND VPWR VPWR sky130_fd_sc_hd__decap_3
XFILLER_55_759 VGND VGND VPWR VPWR sky130_fd_sc_hd__decap_3
XFILLER_82_523 VGND VGND VPWR VPWR sky130_fd_sc_hd__decap_3
XFILLER_82_545 VGND VGND VPWR VPWR sky130_fd_sc_hd__decap_3
X_7963_ _8621_/CLK _7963_/D wire680/X VGND VGND VPWR VPWR _7963_/Q sky130_fd_sc_hd__dfrtp_2
X_6914_ _4765_/X _8497_/Q _6916_/S VGND VGND VPWR VPWR _6915_/A sky130_fd_sc_hd__mux2_4
XFILLER_23_612 VGND VGND VPWR VPWR sky130_fd_sc_hd__decap_3
XFILLER_23_623 VGND VGND VPWR VPWR sky130_fd_sc_hd__decap_3
XFILLER_82_589 VGND VGND VPWR VPWR sky130_fd_sc_hd__decap_3
X_7894_ _8639_/CLK _7894_/D wire603/X VGND VGND VPWR VPWR _7894_/Q sky130_fd_sc_hd__dfrtp_2
X_6845_ _4969_/X _8464_/Q _6853_/S VGND VGND VPWR VPWR _6846_/A sky130_fd_sc_hd__mux2_4
X_3988_ _3988_/A _3988_/B VGND VGND VPWR VPWR _3988_/X sky130_fd_sc_hd__or2_2
X_6776_ _8432_/Q _4832_/A _6786_/S VGND VGND VPWR VPWR _6777_/A sky130_fd_sc_hd__mux2_2
XFILLER_109_706 VGND VGND VPWR VPWR sky130_fd_sc_hd__decap_3
X_8515_ _8676_/CLK _8515_/D load_slew699/X VGND VGND VPWR VPWR _8515_/Q sky130_fd_sc_hd__dfrtp_2
X_5727_ _5727_/A VGND VGND VPWR VPWR _7903_/D sky130_fd_sc_hd__buf_1
X_8446_ _8608_/CLK _8446_/D fanout548/X VGND VGND VPWR VPWR _8446_/Q sky130_fd_sc_hd__dfrtp_2
XFILLER_108_238 VGND VGND VPWR VPWR sky130_fd_sc_hd__decap_3
XTAP_TAPCELL_ROW_94_1609 VGND VPWR sky130_fd_sc_hd__tapvpwrvgnd_1
X_5658_ _5658_/A VGND VGND VPWR VPWR _7871_/D sky130_fd_sc_hd__buf_1
X_8377_ _8547_/CLK _8377_/D fanout648/A VGND VGND VPWR VPWR _8377_/Q sky130_fd_sc_hd__dfrtp_2
X_5589_ _7839_/Q _4765_/A _5591_/S VGND VGND VPWR VPWR _5590_/A sky130_fd_sc_hd__mux2_2
X_4609_ _8371_/Q _3969_/X _4608_/X VGND VGND VPWR VPWR _4609_/X sky130_fd_sc_hd__o21a_2
XFILLER_117_794 VGND VGND VPWR VPWR sky130_fd_sc_hd__decap_3
XFILLER_132_731 VGND VGND VPWR VPWR sky130_fd_sc_hd__decap_3
X_7328_ _8723_/Q _5035_/A _7344_/S VGND VGND VPWR VPWR _7329_/A sky130_fd_sc_hd__mux2_2
XFILLER_104_444 VGND VGND VPWR VPWR sky130_fd_sc_hd__decap_3
XFILLER_117_66 VGND VGND VPWR VPWR sky130_fd_sc_hd__decap_3
XFILLER_77_26 VGND VGND VPWR VPWR sky130_fd_sc_hd__decap_3
X_7259_ _7254_/X _4861_/X _7256_/X _7257_/X hold911/X VGND VGND VPWR VPWR _8682_/D
+ sky130_fd_sc_hd__a32o_2
XFILLER_104_477 VGND VGND VPWR VPWR sky130_fd_sc_hd__fill_1
XFILLER_131_252 VGND VGND VPWR VPWR sky130_fd_sc_hd__decap_3
XFILLER_132_775 VGND VGND VPWR VPWR sky130_fd_sc_hd__decap_3
XFILLER_77_317 VGND VGND VPWR VPWR sky130_fd_sc_hd__fill_2
XFILLER_77_328 VGND VGND VPWR VPWR sky130_fd_sc_hd__decap_3
XFILLER_131_296 VGND VGND VPWR VPWR sky130_fd_sc_hd__decap_3
XFILLER_133_21 VGND VGND VPWR VPWR sky130_fd_sc_hd__decap_3
XFILLER_133_54 VGND VGND VPWR VPWR sky130_fd_sc_hd__fill_2
XFILLER_58_564 VGND VGND VPWR VPWR sky130_fd_sc_hd__decap_3
XFILLER_92_309 VGND VGND VPWR VPWR sky130_fd_sc_hd__fill_1
XTAP_TAPCELL_ROW_5_365 VGND VPWR sky130_fd_sc_hd__tapvpwrvgnd_1
Xhold1040 _7635_/Q VGND VGND VPWR VPWR _5154_/A1 sky130_fd_sc_hd__dlygate4sd3_1
Xhold1051 _7605_/Q VGND VGND VPWR VPWR _5091_/A1 sky130_fd_sc_hd__dlygate4sd3_1
XFILLER_133_87 VGND VGND VPWR VPWR sky130_fd_sc_hd__decap_3
XFILLER_85_383 VGND VGND VPWR VPWR sky130_fd_sc_hd__decap_3
XFILLER_93_47 VGND VGND VPWR VPWR sky130_fd_sc_hd__decap_3
Xhold1062 _8794_/Q VGND VGND VPWR VPWR _7477_/A1 sky130_fd_sc_hd__dlygate4sd3_1
XFILLER_26_41 VGND VGND VPWR VPWR sky130_fd_sc_hd__decap_3
XFILLER_61_718 VGND VGND VPWR VPWR sky130_fd_sc_hd__fill_1
XFILLER_73_556 VGND VGND VPWR VPWR sky130_fd_sc_hd__decap_3
XFILLER_73_567 VGND VGND VPWR VPWR sky130_fd_sc_hd__decap_3
XTAP_TAPCELL_ROW_44_905 VGND VPWR sky130_fd_sc_hd__tapvpwrvgnd_1
XFILLER_26_74 VGND VGND VPWR VPWR sky130_fd_sc_hd__decap_3
XFILLER_60_206 VGND VGND VPWR VPWR sky130_fd_sc_hd__fill_2
XFILLER_61_729 VGND VGND VPWR VPWR sky130_fd_sc_hd__fill_2
XFILLER_13_111 VGND VGND VPWR VPWR sky130_fd_sc_hd__fill_1
XFILLER_14_634 VGND VGND VPWR VPWR sky130_fd_sc_hd__decap_3
XFILLER_14_656 VGND VGND VPWR VPWR sky130_fd_sc_hd__fill_1
XFILLER_41_431 VGND VGND VPWR VPWR sky130_fd_sc_hd__decap_3
XTAP_TAPCELL_ROW_103_1738 VGND VPWR sky130_fd_sc_hd__tapvpwrvgnd_1
XFILLER_14_678 VGND VGND VPWR VPWR sky130_fd_sc_hd__fill_1
XFILLER_127_503 VGND VGND VPWR VPWR sky130_fd_sc_hd__fill_1
XFILLER_127_514 VGND VGND VPWR VPWR sky130_fd_sc_hd__decap_3
XFILLER_127_547 VGND VGND VPWR VPWR sky130_fd_sc_hd__decap_3
XFILLER_5_343 VGND VGND VPWR VPWR sky130_fd_sc_hd__fill_1
XFILLER_108_794 VGND VGND VPWR VPWR sky130_fd_sc_hd__fill_2
XFILLER_123_753 VGND VGND VPWR VPWR sky130_fd_sc_hd__decap_3
XFILLER_3_12 VGND VGND VPWR VPWR sky130_fd_sc_hd__decap_3
XTAP_TAPCELL_ROW_114_1889 VGND VPWR sky130_fd_sc_hd__tapvpwrvgnd_1
XFILLER_110_414 VGND VGND VPWR VPWR sky130_fd_sc_hd__decap_3
XFILLER_3_45 VGND VGND VPWR VPWR sky130_fd_sc_hd__decap_3
XFILLER_3_78 VGND VGND VPWR VPWR sky130_fd_sc_hd__decap_3
XFILLER_68_339 VGND VGND VPWR VPWR sky130_fd_sc_hd__fill_2
XFILLER_95_125 VGND VGND VPWR VPWR sky130_fd_sc_hd__decap_3
XFILLER_95_136 VGND VGND VPWR VPWR sky130_fd_sc_hd__decap_3
XFILLER_49_564 VGND VGND VPWR VPWR sky130_fd_sc_hd__fill_1
XFILLER_76_350 VGND VGND VPWR VPWR sky130_fd_sc_hd__fill_2
XFILLER_76_361 VGND VGND VPWR VPWR sky130_fd_sc_hd__decap_3
XFILLER_95_169 VGND VGND VPWR VPWR sky130_fd_sc_hd__decap_3
XFILLER_37_737 VGND VGND VPWR VPWR sky130_fd_sc_hd__fill_2
XFILLER_64_512 VGND VGND VPWR VPWR sky130_fd_sc_hd__decap_3
Xclkbuf_leaf_6_CLK clkbuf_leaf_8_CLK/A VGND VGND VPWR VPWR _8569_/CLK sky130_fd_sc_hd__clkbuf_8
XFILLER_51_206 VGND VGND VPWR VPWR sky130_fd_sc_hd__decap_3
XFILLER_64_589 VGND VGND VPWR VPWR sky130_fd_sc_hd__decap_3
XFILLER_91_364 VGND VGND VPWR VPWR sky130_fd_sc_hd__fill_1
XFILLER_91_386 VGND VGND VPWR VPWR sky130_fd_sc_hd__decap_3
X_4960_ _4960_/A _4984_/B VGND VGND VPWR VPWR _4961_/A sky130_fd_sc_hd__and2_2
XFILLER_44_280 VGND VGND VPWR VPWR sky130_fd_sc_hd__fill_2
X_3911_ _7974_/Q _4326_/B _4551_/B1 _7893_/Q VGND VGND VPWR VPWR _3911_/X sky130_fd_sc_hd__o22a_2
X_4891_ _4891_/A VGND VGND VPWR VPWR _4891_/X sky130_fd_sc_hd__buf_1
XFILLER_20_615 VGND VGND VPWR VPWR sky130_fd_sc_hd__fill_1
X_3842_ _7726_/Q _7807_/Q _3845_/S VGND VGND VPWR VPWR _3842_/X sky130_fd_sc_hd__mux2_2
X_6630_ _6630_/A VGND VGND VPWR VPWR _8364_/D sky130_fd_sc_hd__buf_2
XFILLER_32_486 VGND VGND VPWR VPWR sky130_fd_sc_hd__decap_3
X_6561_ _6561_/A VGND VGND VPWR VPWR _8331_/D sky130_fd_sc_hd__buf_2
XFILLER_9_671 VGND VGND VPWR VPWR sky130_fd_sc_hd__fill_1
X_3773_ _8379_/Q _8460_/Q _8541_/Q _8622_/Q _3887_/S _3835_/S1 VGND VGND VPWR VPWR
+ _3773_/X sky130_fd_sc_hd__mux4_2
X_8300_ _8624_/CLK _8300_/D load_slew647/X VGND VGND VPWR VPWR _8300_/Q sky130_fd_sc_hd__dfrtp_2
X_5512_ _7802_/Q _4953_/A _5528_/S VGND VGND VPWR VPWR _5513_/A sky130_fd_sc_hd__mux2_2
XFILLER_118_536 VGND VGND VPWR VPWR sky130_fd_sc_hd__decap_3
XFILLER_8_181 VGND VGND VPWR VPWR sky130_fd_sc_hd__decap_3
XFILLER_9_682 VGND VGND VPWR VPWR sky130_fd_sc_hd__decap_3
X_6492_ _6492_/A VGND VGND VPWR VPWR _8298_/D sky130_fd_sc_hd__buf_2
XFILLER_133_517 VGND VGND VPWR VPWR sky130_fd_sc_hd__decap_3
X_8231_ _8798_/CLK _8231_/D wire600/X VGND VGND VPWR VPWR _8231_/Q sky130_fd_sc_hd__dfrtp_2
X_5443_ _7770_/Q _4814_/A _5461_/S VGND VGND VPWR VPWR _5444_/A sky130_fd_sc_hd__mux2_2
XFILLER_126_580 VGND VGND VPWR VPWR sky130_fd_sc_hd__decap_3
X_8162_ _8328_/CLK _8162_/D wire476/X VGND VGND VPWR VPWR _8162_/Q sky130_fd_sc_hd__dfrtp_2
X_5374_ _5374_/A VGND VGND VPWR VPWR _7737_/D sky130_fd_sc_hd__buf_1
X_7113_ _7113_/A VGND VGND VPWR VPWR _8590_/D sky130_fd_sc_hd__buf_2
X_4325_ _4684_/B2 _4316_/X _4319_/X _4322_/X _4324_/X VGND VGND VPWR VPWR _4325_/X
+ sky130_fd_sc_hd__o32a_2
XFILLER_113_274 VGND VGND VPWR VPWR sky130_fd_sc_hd__decap_3
XFILLER_114_775 VGND VGND VPWR VPWR sky130_fd_sc_hd__fill_1
XFILLER_87_615 VGND VGND VPWR VPWR sky130_fd_sc_hd__fill_1
XFILLER_99_497 VGND VGND VPWR VPWR sky130_fd_sc_hd__decap_3
X_8093_ _8737_/CLK _8093_/D load_slew521/X VGND VGND VPWR VPWR _8093_/Q sky130_fd_sc_hd__dfrtp_2
X_7044_ _5023_/X _8558_/Q _7046_/S VGND VGND VPWR VPWR _7045_/A sky130_fd_sc_hd__mux2_2
X_4256_ _4261_/A _4256_/B VGND VGND VPWR VPWR _4256_/X sky130_fd_sc_hd__or2_2
XFILLER_28_704 VGND VGND VPWR VPWR sky130_fd_sc_hd__decap_3
XFILLER_74_309 VGND VGND VPWR VPWR sky130_fd_sc_hd__decap_3
X_4187_ _7756_/Q _7837_/Q _7918_/Q _7999_/Q _4183_/S _4198_/A VGND VGND VPWR VPWR
+ _4187_/X sky130_fd_sc_hd__mux4_2
XFILLER_27_225 VGND VGND VPWR VPWR sky130_fd_sc_hd__fill_2
XTAP_TAPCELL_ROW_2_324 VGND VPWR sky130_fd_sc_hd__tapvpwrvgnd_1
XFILLER_103_57 VGND VGND VPWR VPWR sky130_fd_sc_hd__decap_3
XFILLER_27_236 VGND VGND VPWR VPWR sky130_fd_sc_hd__decap_3
XFILLER_55_556 VGND VGND VPWR VPWR sky130_fd_sc_hd__decap_3
XFILLER_55_567 VGND VGND VPWR VPWR sky130_fd_sc_hd__decap_3
XFILLER_94_191 VGND VGND VPWR VPWR sky130_fd_sc_hd__decap_3
XFILLER_27_269 VGND VGND VPWR VPWR sky130_fd_sc_hd__fill_1
XFILLER_42_217 VGND VGND VPWR VPWR sky130_fd_sc_hd__decap_3
XFILLER_43_729 VGND VGND VPWR VPWR sky130_fd_sc_hd__decap_3
X_7946_ _8683_/CLK _7946_/D load_slew572/X VGND VGND VPWR VPWR _7946_/Q sky130_fd_sc_hd__dfrtp_2
XFILLER_42_239 VGND VGND VPWR VPWR sky130_fd_sc_hd__decap_3
Xclkbuf_5_26__f_CLK clkbuf_4_13_0_CLK/X VGND VGND VPWR VPWR clkbuf_leaf_63_CLK/A sky130_fd_sc_hd__clkbuf_16
X_7877_ _8778_/CLK _7877_/D load_slew727/X VGND VGND VPWR VPWR _7877_/Q sky130_fd_sc_hd__dfrtp_2
XFILLER_11_604 VGND VGND VPWR VPWR sky130_fd_sc_hd__decap_3
X_6828_ _8457_/Q _4936_/A _6828_/S VGND VGND VPWR VPWR _6829_/A sky130_fd_sc_hd__mux2_2
XFILLER_11_626 VGND VGND VPWR VPWR sky130_fd_sc_hd__decap_3
XFILLER_109_514 VGND VGND VPWR VPWR sky130_fd_sc_hd__decap_3
XFILLER_11_659 VGND VGND VPWR VPWR sky130_fd_sc_hd__decap_3
XFILLER_12_21 VGND VGND VPWR VPWR sky130_fd_sc_hd__decap_3
XFILLER_7_608 VGND VGND VPWR VPWR sky130_fd_sc_hd__decap_3
X_6759_ _8424_/Q _4798_/A _6765_/S VGND VGND VPWR VPWR _6760_/A sky130_fd_sc_hd__mux2_2
XFILLER_128_21 VGND VGND VPWR VPWR sky130_fd_sc_hd__decap_3
XFILLER_12_32 VGND VGND VPWR VPWR sky130_fd_sc_hd__decap_3
XFILLER_6_129 VGND VGND VPWR VPWR sky130_fd_sc_hd__decap_3
XFILLER_109_558 VGND VGND VPWR VPWR sky130_fd_sc_hd__fill_2
XFILLER_124_506 VGND VGND VPWR VPWR sky130_fd_sc_hd__decap_3
XFILLER_128_32 VGND VGND VPWR VPWR sky130_fd_sc_hd__decap_3
XFILLER_12_65 VGND VGND VPWR VPWR sky130_fd_sc_hd__decap_3
XTAP_TAPCELL_ROW_131_2123 VGND VPWR sky130_fd_sc_hd__tapvpwrvgnd_1
X_8429_ _8671_/CLK _8429_/D load_slew687/X VGND VGND VPWR VPWR _8429_/Q sky130_fd_sc_hd__dfrtp_2
XFILLER_124_528 VGND VGND VPWR VPWR sky130_fd_sc_hd__decap_3
XFILLER_128_65 VGND VGND VPWR VPWR sky130_fd_sc_hd__decap_3
XFILLER_104_274 VGND VGND VPWR VPWR sky130_fd_sc_hd__decap_3
XFILLER_105_797 VGND VGND VPWR VPWR sky130_fd_sc_hd__decap_3
XFILLER_120_701 VGND VGND VPWR VPWR sky130_fd_sc_hd__decap_3
XFILLER_132_572 VGND VGND VPWR VPWR sky130_fd_sc_hd__decap_3
XFILLER_78_615 VGND VGND VPWR VPWR sky130_fd_sc_hd__fill_2
Xfanout650 fanout652/X VGND VGND VPWR VPWR fanout650/X sky130_fd_sc_hd__clkdlybuf4s25_1
XFILLER_120_778 VGND VGND VPWR VPWR sky130_fd_sc_hd__decap_3
XFILLER_19_715 VGND VGND VPWR VPWR sky130_fd_sc_hd__fill_1
XFILLER_77_169 VGND VGND VPWR VPWR sky130_fd_sc_hd__decap_3
XFILLER_92_106 VGND VGND VPWR VPWR sky130_fd_sc_hd__decap_3
Xfanout672 fanout674/X VGND VGND VPWR VPWR fanout672/X sky130_fd_sc_hd__clkdlybuf4s25_1
Xfanout683 fanout684/X VGND VGND VPWR VPWR fanout683/X sky130_fd_sc_hd__clkdlybuf4s25_1
Xfanout694 fanout754/X VGND VGND VPWR VPWR fanout694/X sky130_fd_sc_hd__clkdlybuf4s25_1
XFILLER_100_480 VGND VGND VPWR VPWR sky130_fd_sc_hd__fill_2
XFILLER_92_139 VGND VGND VPWR VPWR sky130_fd_sc_hd__fill_1
XTAP_TAPCELL_ROW_129_2096 VGND VPWR sky130_fd_sc_hd__tapvpwrvgnd_1
XFILLER_46_556 VGND VGND VPWR VPWR sky130_fd_sc_hd__fill_1
XFILLER_27_781 VGND VGND VPWR VPWR sky130_fd_sc_hd__decap_3
XFILLER_46_589 VGND VGND VPWR VPWR sky130_fd_sc_hd__decap_3
XFILLER_61_515 VGND VGND VPWR VPWR sky130_fd_sc_hd__decap_3
XFILLER_73_364 VGND VGND VPWR VPWR sky130_fd_sc_hd__decap_3
XFILLER_26_280 VGND VGND VPWR VPWR sky130_fd_sc_hd__decap_3
XFILLER_61_548 VGND VGND VPWR VPWR sky130_fd_sc_hd__decap_3
XTAP_TAPCELL_ROW_60_1129 VGND VPWR sky130_fd_sc_hd__tapvpwrvgnd_1
XFILLER_10_681 VGND VGND VPWR VPWR sky130_fd_sc_hd__decap_3
XFILLER_5_140 VGND VGND VPWR VPWR sky130_fd_sc_hd__decap_3
XFILLER_6_663 VGND VGND VPWR VPWR sky130_fd_sc_hd__decap_3
XTAP_TAPCELL_ROW_116_1918 VGND VPWR sky130_fd_sc_hd__tapvpwrvgnd_1
XFILLER_5_162 VGND VGND VPWR VPWR sky130_fd_sc_hd__decap_3
XFILLER_6_696 VGND VGND VPWR VPWR sky130_fd_sc_hd__decap_3
XFILLER_123_561 VGND VGND VPWR VPWR sky130_fd_sc_hd__decap_3
XFILLER_123_594 VGND VGND VPWR VPWR sky130_fd_sc_hd__decap_3
XFILLER_69_637 VGND VGND VPWR VPWR sky130_fd_sc_hd__fill_2
X_5090_ _5090_/A VGND VGND VPWR VPWR _7604_/D sky130_fd_sc_hd__buf_1
X_4110_ _8083_/Q _8164_/Q _8245_/Q _8326_/Q _4110_/S0 _4110_/S1 VGND VGND VPWR VPWR
+ _4110_/X sky130_fd_sc_hd__mux4_2
XFILLER_96_489 VGND VGND VPWR VPWR sky130_fd_sc_hd__fill_1
X_4041_ _8400_/Q _8481_/Q _8562_/Q _8643_/Q _4035_/S wire336/A VGND VGND VPWR VPWR
+ _4041_/X sky130_fd_sc_hd__mux4_2
XFILLER_77_670 VGND VGND VPWR VPWR sky130_fd_sc_hd__fill_2
XPHY_EDGE_ROW_3_Left_139 VGND VGND VPWR VPWR sky130_fd_sc_hd__decap_3
XFILLER_25_707 VGND VGND VPWR VPWR sky130_fd_sc_hd__fill_1
XFILLER_37_556 VGND VGND VPWR VPWR sky130_fd_sc_hd__decap_3
XFILLER_25_729 VGND VGND VPWR VPWR sky130_fd_sc_hd__decap_3
XFILLER_64_386 VGND VGND VPWR VPWR sky130_fd_sc_hd__fill_1
XFILLER_91_172 VGND VGND VPWR VPWR sky130_fd_sc_hd__decap_3
X_8780_ _8780_/CLK _8780_/D load_slew722/X VGND VGND VPWR VPWR _8780_/Q sky130_fd_sc_hd__dfrtp_2
X_7800_ _8701_/CLK _7800_/D fanout648/X VGND VGND VPWR VPWR _7800_/Q sky130_fd_sc_hd__dfrtp_2
X_5992_ _6139_/S VGND VGND VPWR VPWR _6011_/S sky130_fd_sc_hd__buf_2
XTAP_TAPCELL_ROW_86_1490 VGND VPWR sky130_fd_sc_hd__tapvpwrvgnd_1
X_7731_ _8470_/CLK _7731_/D load_slew587/X VGND VGND VPWR VPWR _7731_/Q sky130_fd_sc_hd__dfrtp_2
X_4943_ _4943_/A VGND VGND VPWR VPWR _7557_/D sky130_fd_sc_hd__buf_1
XTAP_TAPCELL_ROW_35_779 VGND VPWR sky130_fd_sc_hd__tapvpwrvgnd_1
X_7662_ _8725_/CLK _7662_/D load_slew491/X VGND VGND VPWR VPWR _7662_/Q sky130_fd_sc_hd__dfrtp_2
XFILLER_60_592 VGND VGND VPWR VPWR sky130_fd_sc_hd__decap_3
X_6613_ _6613_/A VGND VGND VPWR VPWR _8356_/D sky130_fd_sc_hd__buf_2
X_4874_ _4874_/A _4902_/B VGND VGND VPWR VPWR _4875_/A sky130_fd_sc_hd__and2_2
X_3825_ _3825_/A _3825_/B VGND VGND VPWR VPWR _3825_/X sky130_fd_sc_hd__or2_2
X_7593_ _8660_/CLK _7593_/D load_slew515/X VGND VGND VPWR VPWR _7593_/Q sky130_fd_sc_hd__dfrtp_2
X_3756_ _3748_/X _3754_/X _3755_/X _3840_/S wire326/X VGND VGND VPWR VPWR _3756_/X
+ sky130_fd_sc_hd__a221o_2
X_6544_ _6544_/A VGND VGND VPWR VPWR _8323_/D sky130_fd_sc_hd__buf_2
X_6475_ _6475_/A VGND VGND VPWR VPWR _8291_/D sky130_fd_sc_hd__buf_2
XFILLER_106_539 VGND VGND VPWR VPWR sky130_fd_sc_hd__decap_3
XFILLER_133_314 VGND VGND VPWR VPWR sky130_fd_sc_hd__decap_3
X_8214_ _8781_/CLK _8214_/D fanout749/A VGND VGND VPWR VPWR _8214_/Q sky130_fd_sc_hd__dfrtp_2
X_5426_ _7762_/Q _4781_/A _5440_/S VGND VGND VPWR VPWR _5427_/A sky130_fd_sc_hd__mux2_2
XFILLER_133_358 VGND VGND VPWR VPWR sky130_fd_sc_hd__decap_3
XFILLER_102_701 VGND VGND VPWR VPWR sky130_fd_sc_hd__decap_3
XFILLER_87_401 VGND VGND VPWR VPWR sky130_fd_sc_hd__decap_3
X_8145_ _8793_/CLK _8145_/D fanout542/X VGND VGND VPWR VPWR _8145_/Q sky130_fd_sc_hd__dfrtp_2
X_5357_ _5357_/A VGND VGND VPWR VPWR _7729_/D sky130_fd_sc_hd__buf_1
XFILLER_87_423 VGND VGND VPWR VPWR sky130_fd_sc_hd__decap_3
X_8076_ _8400_/CLK _8076_/D fanout556/X VGND VGND VPWR VPWR _8076_/Q sky130_fd_sc_hd__dfrtp_2
X_5288_ _5288_/A VGND VGND VPWR VPWR _7697_/D sky130_fd_sc_hd__buf_1
X_4308_ _8749_/Q _7524_/Q _7605_/Q _7686_/Q _4305_/S _4681_/A VGND VGND VPWR VPWR
+ _4308_/X sky130_fd_sc_hd__mux4_2
XFILLER_114_12 VGND VGND VPWR VPWR sky130_fd_sc_hd__decap_3
XFILLER_75_629 VGND VGND VPWR VPWR sky130_fd_sc_hd__fill_1
X_7027_ _7174_/S VGND VGND VPWR VPWR _7046_/S sky130_fd_sc_hd__buf_4
X_4239_ _7761_/Q _7842_/Q _7923_/Q _8004_/Q _4266_/S _4261_/A VGND VGND VPWR VPWR
+ _4239_/X sky130_fd_sc_hd__mux4_2
XFILLER_87_489 VGND VGND VPWR VPWR sky130_fd_sc_hd__fill_1
XFILLER_114_78 VGND VGND VPWR VPWR sky130_fd_sc_hd__decap_3
XFILLER_16_707 VGND VGND VPWR VPWR sky130_fd_sc_hd__decap_3
XFILLER_74_27 VGND VGND VPWR VPWR sky130_fd_sc_hd__fill_1
XFILLER_74_38 VGND VGND VPWR VPWR sky130_fd_sc_hd__decap_3
XFILLER_43_526 VGND VGND VPWR VPWR sky130_fd_sc_hd__decap_3
XFILLER_130_44 VGND VGND VPWR VPWR sky130_fd_sc_hd__decap_3
XFILLER_24_740 VGND VGND VPWR VPWR sky130_fd_sc_hd__decap_3
XFILLER_70_323 VGND VGND VPWR VPWR sky130_fd_sc_hd__decap_3
XFILLER_82_183 VGND VGND VPWR VPWR sky130_fd_sc_hd__decap_3
X_7929_ _8749_/CLK _7929_/D load_slew623/X VGND VGND VPWR VPWR _7929_/Q sky130_fd_sc_hd__dfrtp_2
XFILLER_130_77 VGND VGND VPWR VPWR sky130_fd_sc_hd__decap_3
XFILLER_130_88 VGND VGND VPWR VPWR sky130_fd_sc_hd__decap_3
XFILLER_30_209 VGND VGND VPWR VPWR sky130_fd_sc_hd__fill_1
XFILLER_11_412 VGND VGND VPWR VPWR sky130_fd_sc_hd__decap_3
XFILLER_129_609 VGND VGND VPWR VPWR sky130_fd_sc_hd__decap_3
XFILLER_23_20 VGND VGND VPWR VPWR sky130_fd_sc_hd__decap_3
XFILLER_90_59 VGND VGND VPWR VPWR sky130_fd_sc_hd__decap_3
XFILLER_11_445 VGND VGND VPWR VPWR sky130_fd_sc_hd__decap_3
XFILLER_135_3 VGND VGND VPWR VPWR sky130_fd_sc_hd__decap_3
XFILLER_23_53 VGND VGND VPWR VPWR sky130_fd_sc_hd__decap_3
XFILLER_23_75 VGND VGND VPWR VPWR sky130_fd_sc_hd__decap_3
XFILLER_7_427 VGND VGND VPWR VPWR sky130_fd_sc_hd__decap_3
Xwire336 wire336/A VGND VGND VPWR VPWR _4036_/A sky130_fd_sc_hd__clkbuf_4
XFILLER_109_355 VGND VGND VPWR VPWR sky130_fd_sc_hd__decap_3
XFILLER_99_46 VGND VGND VPWR VPWR sky130_fd_sc_hd__decap_3
XFILLER_109_388 VGND VGND VPWR VPWR sky130_fd_sc_hd__decap_3
XFILLER_2_121 VGND VGND VPWR VPWR sky130_fd_sc_hd__decap_3
XFILLER_3_644 VGND VGND VPWR VPWR sky130_fd_sc_hd__decap_3
XFILLER_105_561 VGND VGND VPWR VPWR sky130_fd_sc_hd__decap_3
XFILLER_3_688 VGND VGND VPWR VPWR sky130_fd_sc_hd__decap_3
Xload_slew308 _4522_/S VGND VGND VPWR VPWR _4534_/A sky130_fd_sc_hd__buf_2
XFILLER_132_391 VGND VGND VPWR VPWR sky130_fd_sc_hd__decap_3
XFILLER_2_187 VGND VGND VPWR VPWR sky130_fd_sc_hd__fill_1
XFILLER_78_434 VGND VGND VPWR VPWR sky130_fd_sc_hd__fill_2
XTAP_TAPCELL_ROW_111_1848 VGND VPWR sky130_fd_sc_hd__tapvpwrvgnd_1
XTAP_TAPCELL_ROW_57_1091 VGND VPWR sky130_fd_sc_hd__tapvpwrvgnd_1
XFILLER_38_309 VGND VGND VPWR VPWR sky130_fd_sc_hd__decap_3
XFILLER_17_9 VGND VGND VPWR VPWR sky130_fd_sc_hd__decap_3
XFILLER_48_83 VGND VGND VPWR VPWR sky130_fd_sc_hd__fill_1
XFILLER_59_670 VGND VGND VPWR VPWR sky130_fd_sc_hd__fill_2
XFILLER_93_415 VGND VGND VPWR VPWR sky130_fd_sc_hd__decap_3
XFILLER_0_24 VGND VGND VPWR VPWR sky130_fd_sc_hd__decap_3
XFILLER_0_35 VGND VGND VPWR VPWR sky130_fd_sc_hd__decap_3
XFILLER_58_180 VGND VGND VPWR VPWR sky130_fd_sc_hd__fill_2
XFILLER_0_57 VGND VGND VPWR VPWR sky130_fd_sc_hd__decap_3
XFILLER_61_323 VGND VGND VPWR VPWR sky130_fd_sc_hd__decap_3
XFILLER_64_82 VGND VGND VPWR VPWR sky130_fd_sc_hd__fill_2
XFILLER_14_283 VGND VGND VPWR VPWR sky130_fd_sc_hd__decap_3
XFILLER_42_581 VGND VGND VPWR VPWR sky130_fd_sc_hd__decap_3
XFILLER_61_389 VGND VGND VPWR VPWR sky130_fd_sc_hd__decap_3
XFILLER_9_33 VGND VGND VPWR VPWR sky130_fd_sc_hd__decap_3
XTAP_TAPCELL_ROW_122_1999 VGND VPWR sky130_fd_sc_hd__tapvpwrvgnd_1
XTAP_TAPCELL_ROW_32_738 VGND VPWR sky130_fd_sc_hd__tapvpwrvgnd_1
XFILLER_9_66 VGND VGND VPWR VPWR sky130_fd_sc_hd__decap_3
XFILLER_128_631 VGND VGND VPWR VPWR sky130_fd_sc_hd__decap_3
XPHY_EDGE_ROW_104_Right_104 VGND VGND VPWR VPWR sky130_fd_sc_hd__decap_3
XTAP_TAPCELL_ROW_12_462 VGND VPWR sky130_fd_sc_hd__tapvpwrvgnd_1
X_4590_ _4588_/X _4589_/X _4590_/S VGND VGND VPWR VPWR _4590_/X sky130_fd_sc_hd__mux2_2
XFILLER_115_303 VGND VGND VPWR VPWR sky130_fd_sc_hd__decap_3
XFILLER_128_675 VGND VGND VPWR VPWR sky130_fd_sc_hd__decap_3
Xhold906 _8676_/Q VGND VGND VPWR VPWR hold906/X sky130_fd_sc_hd__dlygate4sd3_1
Xhold917 _7976_/Q VGND VGND VPWR VPWR hold917/X sky130_fd_sc_hd__dlygate4sd3_1
Xhold928 _8581_/Q VGND VGND VPWR VPWR hold928/X sky130_fd_sc_hd__dlygate4sd3_1
XFILLER_127_196 VGND VGND VPWR VPWR sky130_fd_sc_hd__fill_1
XFILLER_50_3 VGND VGND VPWR VPWR sky130_fd_sc_hd__decap_3
XTAP_TAPCELL_ROW_73_1309 VGND VPWR sky130_fd_sc_hd__tapvpwrvgnd_1
Xhold939 _8229_/Q VGND VGND VPWR VPWR hold939/X sky130_fd_sc_hd__dlygate4sd3_1
X_6260_ _4837_/X _8190_/Q _6268_/S VGND VGND VPWR VPWR _6261_/A sky130_fd_sc_hd__mux2_4
X_6191_ _4691_/X _8157_/Q _6205_/S VGND VGND VPWR VPWR _6192_/A sky130_fd_sc_hd__mux2_4
X_5211_ _5211_/A VGND VGND VPWR VPWR _7660_/D sky130_fd_sc_hd__buf_1
XFILLER_69_445 VGND VGND VPWR VPWR sky130_fd_sc_hd__decap_3
X_5142_ _4903_/X _7629_/Q _5158_/S VGND VGND VPWR VPWR _5143_/A sky130_fd_sc_hd__mux2_2
XFILLER_57_607 VGND VGND VPWR VPWR sky130_fd_sc_hd__decap_3
XFILLER_96_253 VGND VGND VPWR VPWR sky130_fd_sc_hd__fill_1
XFILLER_96_275 VGND VGND VPWR VPWR sky130_fd_sc_hd__decap_3
X_5073_ _5073_/A VGND VGND VPWR VPWR _7596_/D sky130_fd_sc_hd__buf_1
XTAP_TAPCELL_ROW_88_1530 VGND VPWR sky130_fd_sc_hd__tapvpwrvgnd_1
X_4024_ _8075_/Q _8156_/Q _8237_/Q _8318_/Q _4090_/S0 _4091_/S1 VGND VGND VPWR VPWR
+ _4024_/X sky130_fd_sc_hd__mux4_2
XFILLER_52_301 VGND VGND VPWR VPWR sky130_fd_sc_hd__fill_1
XFILLER_65_673 VGND VGND VPWR VPWR sky130_fd_sc_hd__decap_3
XFILLER_80_610 VGND VGND VPWR VPWR sky130_fd_sc_hd__fill_1
XFILLER_25_559 VGND VGND VPWR VPWR sky130_fd_sc_hd__fill_1
XFILLER_52_312 VGND VGND VPWR VPWR sky130_fd_sc_hd__fill_1
XFILLER_52_334 VGND VGND VPWR VPWR sky130_fd_sc_hd__decap_3
XFILLER_80_632 VGND VGND VPWR VPWR sky130_fd_sc_hd__decap_3
XFILLER_12_209 VGND VGND VPWR VPWR sky130_fd_sc_hd__decap_3
X_8763_ _8763_/CLK _8763_/D fanout561/X VGND VGND VPWR VPWR _8763_/Q sky130_fd_sc_hd__dfrtp_2
X_5975_ _5975_/A VGND VGND VPWR VPWR _8055_/D sky130_fd_sc_hd__buf_1
XFILLER_100_25 VGND VGND VPWR VPWR sky130_fd_sc_hd__decap_3
X_8694_ _8694_/CLK _8694_/D load_slew729/X VGND VGND VPWR VPWR _8694_/Q sky130_fd_sc_hd__dfrtp_2
X_7714_ _8777_/CLK _7714_/D load_slew750/X VGND VGND VPWR VPWR _7714_/Q sky130_fd_sc_hd__dfrtp_2
X_4926_ _4925_/X _4926_/A1 _7453_/S VGND VGND VPWR VPWR _4927_/A sky130_fd_sc_hd__mux2_2
XFILLER_21_743 VGND VGND VPWR VPWR sky130_fd_sc_hd__decap_3
XFILLER_33_592 VGND VGND VPWR VPWR sky130_fd_sc_hd__decap_3
X_7645_ _8709_/CLK _7645_/D load_slew671/X VGND VGND VPWR VPWR _7645_/Q sky130_fd_sc_hd__dfrtp_2
X_4857_ _4857_/A VGND VGND VPWR VPWR _4857_/X sky130_fd_sc_hd__buf_1
XFILLER_119_620 VGND VGND VPWR VPWR sky130_fd_sc_hd__decap_3
XFILLER_20_253 VGND VGND VPWR VPWR sky130_fd_sc_hd__decap_3
XFILLER_21_776 VGND VGND VPWR VPWR sky130_fd_sc_hd__decap_3
XFILLER_21_798 VGND VGND VPWR VPWR sky130_fd_sc_hd__decap_3
X_3808_ _7642_/Q _4350_/A2 _3807_/X _3862_/A _3894_/A1 VGND VGND VPWR VPWR _3808_/X
+ sky130_fd_sc_hd__o221a_2
X_7576_ _8801_/CLK _7576_/D load_slew608/X VGND VGND VPWR VPWR _7576_/Q sky130_fd_sc_hd__dfrtp_2
XFILLER_119_664 VGND VGND VPWR VPWR sky130_fd_sc_hd__decap_3
XFILLER_20_286 VGND VGND VPWR VPWR sky130_fd_sc_hd__fill_1
XTAP_TAPCELL_ROW_99_1681 VGND VPWR sky130_fd_sc_hd__tapvpwrvgnd_1
X_6527_ _6527_/A VGND VGND VPWR VPWR _8315_/D sky130_fd_sc_hd__buf_2
X_4788_ _4787_/X _4788_/A1 _4820_/S VGND VGND VPWR VPWR _4789_/A sky130_fd_sc_hd__mux2_2
XFILLER_109_34 VGND VGND VPWR VPWR sky130_fd_sc_hd__decap_3
XFILLER_134_601 VGND VGND VPWR VPWR sky130_fd_sc_hd__decap_3
XFILLER_134_623 VGND VGND VPWR VPWR sky130_fd_sc_hd__decap_3
XFILLER_4_419 VGND VGND VPWR VPWR sky130_fd_sc_hd__fill_1
X_3739_ _4314_/S _3739_/B VGND VGND VPWR VPWR _3749_/A sky130_fd_sc_hd__nand2_2
XFILLER_133_111 VGND VGND VPWR VPWR sky130_fd_sc_hd__fill_1
XFILLER_133_122 VGND VGND VPWR VPWR sky130_fd_sc_hd__decap_3
XFILLER_134_645 VGND VGND VPWR VPWR sky130_fd_sc_hd__decap_3
XFILLER_69_38 VGND VGND VPWR VPWR sky130_fd_sc_hd__decap_3
X_6458_ _6458_/A VGND VGND VPWR VPWR _8283_/D sky130_fd_sc_hd__buf_2
XFILLER_0_603 VGND VGND VPWR VPWR sky130_fd_sc_hd__fill_2
XFILLER_133_155 VGND VGND VPWR VPWR sky130_fd_sc_hd__decap_3
XFILLER_134_678 VGND VGND VPWR VPWR sky130_fd_sc_hd__decap_3
XFILLER_88_710 VGND VGND VPWR VPWR sky130_fd_sc_hd__decap_3
X_6389_ _6389_/A VGND VGND VPWR VPWR _8250_/D sky130_fd_sc_hd__buf_2
X_5409_ _7754_/Q _4748_/A _5419_/S VGND VGND VPWR VPWR _5410_/A sky130_fd_sc_hd__mux2_2
XFILLER_0_636 VGND VGND VPWR VPWR sky130_fd_sc_hd__decap_3
XFILLER_102_531 VGND VGND VPWR VPWR sky130_fd_sc_hd__fill_1
XFILLER_125_33 VGND VGND VPWR VPWR sky130_fd_sc_hd__decap_3
XFILLER_133_199 VGND VGND VPWR VPWR sky130_fd_sc_hd__decap_3
X_8128_ _8776_/CLK _8128_/D fanout732/A VGND VGND VPWR VPWR _8128_/Q sky130_fd_sc_hd__dfrtp_2
XFILLER_0_669 VGND VGND VPWR VPWR sky130_fd_sc_hd__decap_3
XFILLER_125_66 VGND VGND VPWR VPWR sky130_fd_sc_hd__decap_3
XFILLER_88_754 VGND VGND VPWR VPWR sky130_fd_sc_hd__fill_2
XFILLER_102_575 VGND VGND VPWR VPWR sky130_fd_sc_hd__decap_3
XFILLER_125_99 VGND VGND VPWR VPWR sky130_fd_sc_hd__fill_2
XFILLER_87_275 VGND VGND VPWR VPWR sky130_fd_sc_hd__decap_3
X_8059_ _8710_/CLK _8059_/D fanout662/X VGND VGND VPWR VPWR _8059_/Q sky130_fd_sc_hd__dfrtp_2
XFILLER_18_53 VGND VGND VPWR VPWR sky130_fd_sc_hd__decap_3
XTAP_TAPCELL_ROW_126_2055 VGND VPWR sky130_fd_sc_hd__tapvpwrvgnd_1
XFILLER_71_610 VGND VGND VPWR VPWR sky130_fd_sc_hd__fill_2
XFILLER_83_470 VGND VGND VPWR VPWR sky130_fd_sc_hd__fill_1
XFILLER_90_429 VGND VGND VPWR VPWR sky130_fd_sc_hd__decap_3
XFILLER_55_172 VGND VGND VPWR VPWR sky130_fd_sc_hd__decap_3
XFILLER_71_665 VGND VGND VPWR VPWR sky130_fd_sc_hd__decap_3
XFILLER_71_676 VGND VGND VPWR VPWR sky130_fd_sc_hd__fill_2
XFILLER_12_721 VGND VGND VPWR VPWR sky130_fd_sc_hd__fill_2
XFILLER_43_389 VGND VGND VPWR VPWR sky130_fd_sc_hd__decap_3
XFILLER_70_186 VGND VGND VPWR VPWR sky130_fd_sc_hd__decap_3
XFILLER_11_231 VGND VGND VPWR VPWR sky130_fd_sc_hd__decap_3
XFILLER_129_417 VGND VGND VPWR VPWR sky130_fd_sc_hd__decap_3
XFILLER_34_85 VGND VGND VPWR VPWR sky130_fd_sc_hd__fill_1
XFILLER_70_197 VGND VGND VPWR VPWR sky130_fd_sc_hd__fill_2
XFILLER_11_275 VGND VGND VPWR VPWR sky130_fd_sc_hd__decap_3
XFILLER_12_787 VGND VGND VPWR VPWR sky130_fd_sc_hd__decap_3
XFILLER_8_725 VGND VGND VPWR VPWR sky130_fd_sc_hd__decap_3
XFILLER_7_257 VGND VGND VPWR VPWR sky130_fd_sc_hd__decap_3
XFILLER_8_769 VGND VGND VPWR VPWR sky130_fd_sc_hd__decap_3
XTAP_TAPCELL_ROW_59_1120 VGND VPWR sky130_fd_sc_hd__tapvpwrvgnd_1
XFILLER_124_144 VGND VGND VPWR VPWR sky130_fd_sc_hd__fill_2
XFILLER_124_155 VGND VGND VPWR VPWR sky130_fd_sc_hd__decap_3
XFILLER_98_529 VGND VGND VPWR VPWR sky130_fd_sc_hd__decap_3
XFILLER_78_220 VGND VGND VPWR VPWR sky130_fd_sc_hd__decap_3
XFILLER_78_242 VGND VGND VPWR VPWR sky130_fd_sc_hd__fill_1
XFILLER_120_383 VGND VGND VPWR VPWR sky130_fd_sc_hd__fill_2
XFILLER_15_6 VGND VGND VPWR VPWR sky130_fd_sc_hd__decap_3
XFILLER_94_757 VGND VGND VPWR VPWR sky130_fd_sc_hd__fill_1
XFILLER_94_779 VGND VGND VPWR VPWR sky130_fd_sc_hd__decap_3
XFILLER_46_150 VGND VGND VPWR VPWR sky130_fd_sc_hd__decap_3
XFILLER_47_673 VGND VGND VPWR VPWR sky130_fd_sc_hd__fill_2
XTAP_TAPCELL_ROW_37_808 VGND VPWR sky130_fd_sc_hd__tapvpwrvgnd_1
XFILLER_62_610 VGND VGND VPWR VPWR sky130_fd_sc_hd__decap_3
XPHY_EDGE_ROW_93_Left_229 VGND VGND VPWR VPWR sky130_fd_sc_hd__decap_3
XFILLER_62_654 VGND VGND VPWR VPWR sky130_fd_sc_hd__fill_1
XTAP_TAPCELL_ROW_17_532 VGND VPWR sky130_fd_sc_hd__tapvpwrvgnd_1
XFILLER_62_687 VGND VGND VPWR VPWR sky130_fd_sc_hd__decap_3
XTAP_TAPCELL_ROW_83_1460 VGND VPWR sky130_fd_sc_hd__tapvpwrvgnd_1
X_5760_ _5760_/A VGND VGND VPWR VPWR _7919_/D sky130_fd_sc_hd__buf_1
XFILLER_61_197 VGND VGND VPWR VPWR sky130_fd_sc_hd__fill_2
XFILLER_91_91 VGND VGND VPWR VPWR sky130_fd_sc_hd__decap_3
X_5691_ _5691_/A VGND VGND VPWR VPWR _7886_/D sky130_fd_sc_hd__buf_1
X_4711_ _4711_/A VGND VGND VPWR VPWR _4711_/X sky130_fd_sc_hd__buf_1
X_7430_ _7451_/S VGND VGND VPWR VPWR _7449_/S sky130_fd_sc_hd__clkbuf_2
X_4642_ _8617_/Q _4642_/A2 _4641_/X _4651_/A _4669_/S VGND VGND VPWR VPWR _4642_/X
+ sky130_fd_sc_hd__o221a_2
XFILLER_128_472 VGND VGND VPWR VPWR sky130_fd_sc_hd__decap_3
XFILLER_128_483 VGND VGND VPWR VPWR sky130_fd_sc_hd__decap_3
X_7361_ _8739_/Q _4760_/A _7365_/S VGND VGND VPWR VPWR _7362_/A sky130_fd_sc_hd__mux2_2
X_4573_ _8773_/Q _7548_/Q _4579_/S VGND VGND VPWR VPWR _4573_/X sky130_fd_sc_hd__mux2_2
XFILLER_7_780 VGND VGND VPWR VPWR sky130_fd_sc_hd__decap_3
XFILLER_7_791 VGND VGND VPWR VPWR sky130_fd_sc_hd__decap_3
X_7292_ _8706_/Q _4964_/A _7302_/S VGND VGND VPWR VPWR _7293_/A sky130_fd_sc_hd__mux2_2
X_6312_ _4941_/X _6312_/A1 _6312_/S VGND VGND VPWR VPWR _6313_/A sky130_fd_sc_hd__mux2_2
XFILLER_116_678 VGND VGND VPWR VPWR sky130_fd_sc_hd__decap_3
XFILLER_116_689 VGND VGND VPWR VPWR sky130_fd_sc_hd__fill_1
XFILLER_131_615 VGND VGND VPWR VPWR sky130_fd_sc_hd__fill_1
Xhold758 _7986_/Q VGND VGND VPWR VPWR hold758/X sky130_fd_sc_hd__dlygate4sd3_1
Xhold769 _8006_/Q VGND VGND VPWR VPWR hold769/X sky130_fd_sc_hd__dlygate4sd3_1
X_6243_ _4803_/X _8182_/Q _6247_/S VGND VGND VPWR VPWR _6244_/A sky130_fd_sc_hd__mux2_4
XFILLER_115_199 VGND VGND VPWR VPWR sky130_fd_sc_hd__decap_3
XFILLER_130_103 VGND VGND VPWR VPWR sky130_fd_sc_hd__decap_3
XFILLER_131_626 VGND VGND VPWR VPWR sky130_fd_sc_hd__decap_3
XFILLER_131_659 VGND VGND VPWR VPWR sky130_fd_sc_hd__decap_3
XFILLER_39_19 VGND VGND VPWR VPWR sky130_fd_sc_hd__fill_1
XFILLER_130_136 VGND VGND VPWR VPWR sky130_fd_sc_hd__decap_3
XFILLER_130_147 VGND VGND VPWR VPWR sky130_fd_sc_hd__decap_3
X_6174_ _5007_/X _8149_/Q _6184_/S VGND VGND VPWR VPWR _6175_/A sky130_fd_sc_hd__mux2_4
XFILLER_84_212 VGND VGND VPWR VPWR sky130_fd_sc_hd__fill_2
XFILLER_85_713 VGND VGND VPWR VPWR sky130_fd_sc_hd__decap_3
XFILLER_85_735 VGND VGND VPWR VPWR sky130_fd_sc_hd__decap_3
Xload_slew661 fanout660/X VGND VGND VPWR VPWR load_slew661/X sky130_fd_sc_hd__buf_2
X_5125_ _4871_/X _7621_/Q _5137_/S VGND VGND VPWR VPWR _5126_/A sky130_fd_sc_hd__mux2_2
XFILLER_29_139 VGND VGND VPWR VPWR sky130_fd_sc_hd__fill_2
XFILLER_38_640 VGND VGND VPWR VPWR sky130_fd_sc_hd__decap_3
X_5056_ _4731_/X hold965/X _5074_/S VGND VGND VPWR VPWR _5057_/A sky130_fd_sc_hd__mux2_2
XFILLER_84_256 VGND VGND VPWR VPWR sky130_fd_sc_hd__fill_1
XFILLER_84_289 VGND VGND VPWR VPWR sky130_fd_sc_hd__decap_3
X_4007_ _7739_/Q _7820_/Q _4007_/S VGND VGND VPWR VPWR _4007_/X sky130_fd_sc_hd__mux2_2
XFILLER_25_334 VGND VGND VPWR VPWR sky130_fd_sc_hd__fill_2
XFILLER_37_172 VGND VGND VPWR VPWR sky130_fd_sc_hd__fill_2
XFILLER_53_632 VGND VGND VPWR VPWR sky130_fd_sc_hd__decap_3
XFILLER_65_470 VGND VGND VPWR VPWR sky130_fd_sc_hd__fill_2
XFILLER_65_481 VGND VGND VPWR VPWR sky130_fd_sc_hd__decap_3
XFILLER_80_462 VGND VGND VPWR VPWR sky130_fd_sc_hd__fill_2
XFILLER_111_57 VGND VGND VPWR VPWR sky130_fd_sc_hd__decap_3
XFILLER_13_529 VGND VGND VPWR VPWR sky130_fd_sc_hd__decap_3
XFILLER_53_687 VGND VGND VPWR VPWR sky130_fd_sc_hd__decap_3
X_8746_ _8746_/CLK _8746_/D fanout624/X VGND VGND VPWR VPWR _8746_/Q sky130_fd_sc_hd__dfrtp_2
X_5958_ _5958_/A1 _5958_/A2 _4937_/X _5958_/B1 hold834/X VGND VGND VPWR VPWR _8042_/D
+ sky130_fd_sc_hd__a32o_2
XFILLER_40_348 VGND VGND VPWR VPWR sky130_fd_sc_hd__decap_3
XFILLER_40_359 VGND VGND VPWR VPWR sky130_fd_sc_hd__decap_3
XFILLER_52_197 VGND VGND VPWR VPWR sky130_fd_sc_hd__fill_2
X_4909_ _7455_/A VGND VGND VPWR VPWR _7453_/S sky130_fd_sc_hd__buf_2
X_8677_ _8678_/CLK _8677_/D fanout694/X VGND VGND VPWR VPWR _8677_/Q sky130_fd_sc_hd__dfrtp_2
X_5889_ _5881_/X _5882_/X _4711_/X _5883_/X hold794/X VGND VGND VPWR VPWR _7988_/D
+ sky130_fd_sc_hd__a32o_2
X_7628_ _8772_/CLK _7628_/D load_slew718/X VGND VGND VPWR VPWR _7628_/Q sky130_fd_sc_hd__dfrtp_2
XFILLER_5_706 VGND VGND VPWR VPWR sky130_fd_sc_hd__decap_3
X_7559_ _8622_/CLK _7559_/D load_slew655/X VGND VGND VPWR VPWR _7559_/Q sky130_fd_sc_hd__dfrtp_2
XFILLER_119_494 VGND VGND VPWR VPWR sky130_fd_sc_hd__decap_3
XFILLER_134_442 VGND VGND VPWR VPWR sky130_fd_sc_hd__decap_3
XFILLER_20_21 VGND VGND VPWR VPWR sky130_fd_sc_hd__decap_3
XFILLER_20_32 VGND VGND VPWR VPWR sky130_fd_sc_hd__decap_3
XFILLER_20_65 VGND VGND VPWR VPWR sky130_fd_sc_hd__decap_3
XFILLER_121_125 VGND VGND VPWR VPWR sky130_fd_sc_hd__decap_3
XFILLER_122_648 VGND VGND VPWR VPWR sky130_fd_sc_hd__decap_3
XFILLER_134_486 VGND VGND VPWR VPWR sky130_fd_sc_hd__decap_3
XFILLER_96_58 VGND VGND VPWR VPWR sky130_fd_sc_hd__decap_3
XFILLER_96_69 VGND VGND VPWR VPWR sky130_fd_sc_hd__decap_3
XTAP_TAPCELL_ROW_54_1050 VGND VPWR sky130_fd_sc_hd__tapvpwrvgnd_1
XFILLER_121_169 VGND VGND VPWR VPWR sky130_fd_sc_hd__decap_3
XFILLER_130_681 VGND VGND VPWR VPWR sky130_fd_sc_hd__decap_3
XFILLER_48_415 VGND VGND VPWR VPWR sky130_fd_sc_hd__decap_3
XFILLER_76_713 VGND VGND VPWR VPWR sky130_fd_sc_hd__decap_3
XFILLER_48_437 VGND VGND VPWR VPWR sky130_fd_sc_hd__decap_3
XFILLER_28_150 VGND VGND VPWR VPWR sky130_fd_sc_hd__decap_3
XFILLER_35_109 VGND VGND VPWR VPWR sky130_fd_sc_hd__decap_3
XFILLER_28_183 VGND VGND VPWR VPWR sky130_fd_sc_hd__fill_2
XFILLER_56_470 VGND VGND VPWR VPWR sky130_fd_sc_hd__decap_3
XFILLER_71_440 VGND VGND VPWR VPWR sky130_fd_sc_hd__decap_3
XFILLER_90_259 VGND VGND VPWR VPWR sky130_fd_sc_hd__decap_3
XFILLER_44_687 VGND VGND VPWR VPWR sky130_fd_sc_hd__decap_3
XFILLER_31_337 VGND VGND VPWR VPWR sky130_fd_sc_hd__fill_2
XFILLER_31_348 VGND VGND VPWR VPWR sky130_fd_sc_hd__decap_3
XFILLER_129_214 VGND VGND VPWR VPWR sky130_fd_sc_hd__decap_3
XFILLER_129_225 VGND VGND VPWR VPWR sky130_fd_sc_hd__decap_3
XFILLER_12_551 VGND VGND VPWR VPWR sky130_fd_sc_hd__decap_3
XFILLER_61_50 VGND VGND VPWR VPWR sky130_fd_sc_hd__decap_3
XTAP_TAPCELL_ROW_42_877 VGND VPWR sky130_fd_sc_hd__tapvpwrvgnd_1
XFILLER_129_258 VGND VGND VPWR VPWR sky130_fd_sc_hd__decap_3
XFILLER_12_595 VGND VGND VPWR VPWR sky130_fd_sc_hd__decap_3
XFILLER_8_533 VGND VGND VPWR VPWR sky130_fd_sc_hd__decap_3
XFILLER_6_12 VGND VGND VPWR VPWR sky130_fd_sc_hd__decap_3
XFILLER_8_566 VGND VGND VPWR VPWR sky130_fd_sc_hd__fill_1
XANTENNA_5 _4335_/A VGND VGND VPWR VPWR sky130_fd_sc_hd__diode_2
XFILLER_6_56 VGND VGND VPWR VPWR sky130_fd_sc_hd__decap_3
XFILLER_112_114 VGND VGND VPWR VPWR sky130_fd_sc_hd__fill_2
XFILLER_113_626 VGND VGND VPWR VPWR sky130_fd_sc_hd__decap_3
XFILLER_4_772 VGND VGND VPWR VPWR sky130_fd_sc_hd__decap_3
XFILLER_98_348 VGND VGND VPWR VPWR sky130_fd_sc_hd__fill_1
XFILLER_112_147 VGND VGND VPWR VPWR sky130_fd_sc_hd__fill_2
XFILLER_100_309 VGND VGND VPWR VPWR sky130_fd_sc_hd__decap_3
XFILLER_112_169 VGND VGND VPWR VPWR sky130_fd_sc_hd__fill_2
XFILLER_94_510 VGND VGND VPWR VPWR sky130_fd_sc_hd__fill_1
XFILLER_13_3 VGND VGND VPWR VPWR sky130_fd_sc_hd__decap_3
XFILLER_66_223 VGND VGND VPWR VPWR sky130_fd_sc_hd__decap_3
XFILLER_94_587 VGND VGND VPWR VPWR sky130_fd_sc_hd__fill_1
XFILLER_19_172 VGND VGND VPWR VPWR sky130_fd_sc_hd__decap_3
X_6930_ _6930_/A VGND VGND VPWR VPWR _8504_/D sky130_fd_sc_hd__buf_6
Xclkbuf_5_7__f_CLK clkbuf_4_3_0_CLK/X VGND VGND VPWR VPWR clkload2/A sky130_fd_sc_hd__clkbuf_16
X_6861_ _6861_/A VGND VGND VPWR VPWR _8471_/D sky130_fd_sc_hd__buf_6
XFILLER_50_602 VGND VGND VPWR VPWR sky130_fd_sc_hd__decap_3
X_8600_ _8766_/CLK _8600_/D fanout575/X VGND VGND VPWR VPWR _8600_/Q sky130_fd_sc_hd__dfrtp_2
X_6792_ _6792_/A VGND VGND VPWR VPWR _8439_/D sky130_fd_sc_hd__buf_2
X_5812_ _7944_/Q _4866_/A _5826_/S VGND VGND VPWR VPWR _5813_/A sky130_fd_sc_hd__mux2_2
XFILLER_34_186 VGND VGND VPWR VPWR sky130_fd_sc_hd__decap_3
XFILLER_34_197 VGND VGND VPWR VPWR sky130_fd_sc_hd__decap_3
X_8531_ _8693_/CLK _8531_/D load_slew738/X VGND VGND VPWR VPWR _8531_/Q sky130_fd_sc_hd__dfrtp_2
X_5743_ _5743_/A VGND VGND VPWR VPWR _7911_/D sky130_fd_sc_hd__buf_1
X_8462_ _8462_/CLK _8462_/D wire669/X VGND VGND VPWR VPWR _8462_/Q sky130_fd_sc_hd__dfrtp_2
X_5674_ _5674_/A VGND VGND VPWR VPWR _7879_/D sky130_fd_sc_hd__buf_1
X_8393_ _8799_/CLK _8393_/D fanout601/X VGND VGND VPWR VPWR _8393_/Q sky130_fd_sc_hd__dfrtp_2
X_7413_ _7413_/A VGND VGND VPWR VPWR _8763_/D sky130_fd_sc_hd__buf_1
X_4625_ _4669_/S _4625_/B VGND VGND VPWR VPWR _4625_/X sky130_fd_sc_hd__or2_2
XFILLER_135_228 VGND VGND VPWR VPWR sky130_fd_sc_hd__fill_1
XTAP_TAPCELL_ROW_96_1640 VGND VPWR sky130_fd_sc_hd__tapvpwrvgnd_1
X_7344_ _8731_/Q _4726_/A _7344_/S VGND VGND VPWR VPWR _7345_/A sky130_fd_sc_hd__mux2_2
X_4556_ _4503_/A _4554_/X _4555_/X VGND VGND VPWR VPWR _4556_/X sky130_fd_sc_hd__o21a_2
XFILLER_104_604 VGND VGND VPWR VPWR sky130_fd_sc_hd__decap_3
Xmax_cap252 _3795_/X VGND VGND VPWR VPWR _4666_/A1 sky130_fd_sc_hd__buf_6
Xmax_cap241 _4165_/A VGND VGND VPWR VPWR _4591_/S sky130_fd_sc_hd__buf_6
Xmax_cap230 _3760_/X VGND VGND VPWR VPWR _4685_/A1 sky130_fd_sc_hd__buf_6
XFILLER_89_315 VGND VGND VPWR VPWR sky130_fd_sc_hd__decap_3
XFILLER_89_337 VGND VGND VPWR VPWR sky130_fd_sc_hd__decap_3
Xmax_cap274 _3811_/A VGND VGND VPWR VPWR _3939_/A sky130_fd_sc_hd__buf_2
Xmax_cap263 _3995_/B VGND VGND VPWR VPWR _4195_/A2 sky130_fd_sc_hd__buf_6
X_7275_ _7267_/X _4917_/X _7280_/A3 _7280_/B1 hold885/X VGND VGND VPWR VPWR _8695_/D
+ sky130_fd_sc_hd__a32o_2
X_4487_ _4487_/A VGND VGND VPWR VPWR _4487_/X sky130_fd_sc_hd__buf_1
XFILLER_106_13 VGND VGND VPWR VPWR sky130_fd_sc_hd__decap_3
XFILLER_106_35 VGND VGND VPWR VPWR sky130_fd_sc_hd__decap_3
XFILLER_131_445 VGND VGND VPWR VPWR sky130_fd_sc_hd__decap_3
XFILLER_131_467 VGND VGND VPWR VPWR sky130_fd_sc_hd__decap_3
XFILLER_89_359 VGND VGND VPWR VPWR sky130_fd_sc_hd__decap_3
X_6226_ _4769_/X _8174_/Q _6226_/S VGND VGND VPWR VPWR _6227_/A sky130_fd_sc_hd__mux2_4
XFILLER_103_169 VGND VGND VPWR VPWR sky130_fd_sc_hd__decap_3
XFILLER_106_57 VGND VGND VPWR VPWR sky130_fd_sc_hd__decap_3
X_6157_ _4973_/X _8141_/Q _6163_/S VGND VGND VPWR VPWR _6158_/A sky130_fd_sc_hd__mux2_4
XFILLER_58_757 VGND VGND VPWR VPWR sky130_fd_sc_hd__decap_3
Xload_slew491 fanout490/X VGND VGND VPWR VPWR load_slew491/X sky130_fd_sc_hd__buf_2
Xload_slew480 fanout479/X VGND VGND VPWR VPWR load_slew480/X sky130_fd_sc_hd__buf_2
X_5108_ _4837_/X _7613_/Q _5116_/S VGND VGND VPWR VPWR _5109_/A sky130_fd_sc_hd__mux2_2
XFILLER_122_23 VGND VGND VPWR VPWR sky130_fd_sc_hd__decap_3
XFILLER_73_727 VGND VGND VPWR VPWR sky130_fd_sc_hd__fill_1
X_6088_ _6088_/A VGND VGND VPWR VPWR _8109_/D sky130_fd_sc_hd__buf_1
XFILLER_38_470 VGND VGND VPWR VPWR sky130_fd_sc_hd__fill_2
XFILLER_45_429 VGND VGND VPWR VPWR sky130_fd_sc_hd__decap_3
XTAP_TAPCELL_ROW_123_2014 VGND VPWR sky130_fd_sc_hd__tapvpwrvgnd_1
X_5039_ _4691_/X _7580_/Q _5053_/S VGND VGND VPWR VPWR _5040_/A sky130_fd_sc_hd__mux2_2
XFILLER_25_142 VGND VGND VPWR VPWR sky130_fd_sc_hd__decap_3
XFILLER_72_259 VGND VGND VPWR VPWR sky130_fd_sc_hd__decap_3
XFILLER_82_27 VGND VGND VPWR VPWR sky130_fd_sc_hd__fill_1
XFILLER_15_21 VGND VGND VPWR VPWR sky130_fd_sc_hd__decap_3
XFILLER_53_462 VGND VGND VPWR VPWR sky130_fd_sc_hd__decap_3
XTAP_TAPCELL_ROW_0_274 VGND VPWR sky130_fd_sc_hd__tapvpwrvgnd_1
XTAP_TAPCELL_ROW_0_285 VGND VPWR sky130_fd_sc_hd__tapvpwrvgnd_1
XTAP_TAPCELL_ROW_0_296 VGND VPWR sky130_fd_sc_hd__tapvpwrvgnd_1
XFILLER_13_326 VGND VGND VPWR VPWR sky130_fd_sc_hd__decap_3
XFILLER_15_54 VGND VGND VPWR VPWR sky130_fd_sc_hd__fill_2
XFILLER_40_123 VGND VGND VPWR VPWR sky130_fd_sc_hd__decap_3
XFILLER_41_646 VGND VGND VPWR VPWR sky130_fd_sc_hd__decap_3
XFILLER_80_281 VGND VGND VPWR VPWR sky130_fd_sc_hd__decap_3
XFILLER_15_87 VGND VGND VPWR VPWR sky130_fd_sc_hd__decap_3
XFILLER_15_98 VGND VGND VPWR VPWR sky130_fd_sc_hd__decap_3
XFILLER_41_679 VGND VGND VPWR VPWR sky130_fd_sc_hd__decap_3
XFILLER_9_308 VGND VGND VPWR VPWR sky130_fd_sc_hd__decap_3
X_8729_ _8729_/CLK _8729_/D fanout475/A VGND VGND VPWR VPWR _8729_/Q sky130_fd_sc_hd__dfrtp_2
XFILLER_21_381 VGND VGND VPWR VPWR sky130_fd_sc_hd__decap_3
XFILLER_40_189 VGND VGND VPWR VPWR sky130_fd_sc_hd__decap_3
XFILLER_127_718 VGND VGND VPWR VPWR sky130_fd_sc_hd__decap_3
XFILLER_127_729 VGND VGND VPWR VPWR sky130_fd_sc_hd__decap_3
XTAP_TAPCELL_ROW_134_2165 VGND VPWR sky130_fd_sc_hd__tapvpwrvgnd_1
XFILLER_107_464 VGND VGND VPWR VPWR sky130_fd_sc_hd__decap_3
XFILLER_134_250 VGND VGND VPWR VPWR sky130_fd_sc_hd__fill_2
XFILLER_1_753 VGND VGND VPWR VPWR sky130_fd_sc_hd__decap_3
Xoutput86 _8052_/Q VGND VGND VPWR VPWR full sky130_fd_sc_hd__clkdlybuf4s25_1
Xoutput97 _4015_/X VGND VGND VPWR VPWR rdata[19] sky130_fd_sc_hd__clkdlybuf4s25_1
XFILLER_1_797 VGND VGND VPWR VPWR sky130_fd_sc_hd__decap_3
XFILLER_49_735 VGND VGND VPWR VPWR sky130_fd_sc_hd__decap_3
XFILLER_48_267 VGND VGND VPWR VPWR sky130_fd_sc_hd__decap_3
XFILLER_56_50 VGND VGND VPWR VPWR sky130_fd_sc_hd__decap_3
XFILLER_76_554 VGND VGND VPWR VPWR sky130_fd_sc_hd__decap_3
XFILLER_76_587 VGND VGND VPWR VPWR sky130_fd_sc_hd__fill_1
XTAP_TAPCELL_ROW_108_1809 VGND VPWR sky130_fd_sc_hd__tapvpwrvgnd_1
XFILLER_63_215 VGND VGND VPWR VPWR sky130_fd_sc_hd__decap_3
XFILLER_64_738 VGND VGND VPWR VPWR sky130_fd_sc_hd__fill_1
XFILLER_76_598 VGND VGND VPWR VPWR sky130_fd_sc_hd__fill_1
XTAP_TAPCELL_ROW_47_947 VGND VPWR sky130_fd_sc_hd__tapvpwrvgnd_1
XFILLER_17_654 VGND VGND VPWR VPWR sky130_fd_sc_hd__decap_3
XTAP_TAPCELL_ROW_67_1230 VGND VPWR sky130_fd_sc_hd__tapvpwrvgnd_1
XFILLER_17_676 VGND VGND VPWR VPWR sky130_fd_sc_hd__decap_3
XFILLER_17_698 VGND VGND VPWR VPWR sky130_fd_sc_hd__decap_3
XFILLER_32_613 VGND VGND VPWR VPWR sky130_fd_sc_hd__decap_3
XTAP_TAPCELL_ROW_27_671 VGND VPWR sky130_fd_sc_hd__tapvpwrvgnd_1
XFILLER_71_270 VGND VGND VPWR VPWR sky130_fd_sc_hd__decap_3
XFILLER_71_281 VGND VGND VPWR VPWR sky130_fd_sc_hd__decap_3
XFILLER_31_156 VGND VGND VPWR VPWR sky130_fd_sc_hd__decap_3
XFILLER_12_370 VGND VGND VPWR VPWR sky130_fd_sc_hd__decap_3
XFILLER_40_690 VGND VGND VPWR VPWR sky130_fd_sc_hd__fill_1
XFILLER_118_718 VGND VGND VPWR VPWR sky130_fd_sc_hd__decap_3
XFILLER_12_392 VGND VGND VPWR VPWR sky130_fd_sc_hd__decap_3
XFILLER_8_363 VGND VGND VPWR VPWR sky130_fd_sc_hd__fill_1
XFILLER_8_374 VGND VGND VPWR VPWR sky130_fd_sc_hd__fill_2
XFILLER_8_385 VGND VGND VPWR VPWR sky130_fd_sc_hd__fill_1
X_4410_ _4415_/A _4408_/X _4409_/X VGND VGND VPWR VPWR _4410_/X sky130_fd_sc_hd__o21a_2
XFILLER_132_209 VGND VGND VPWR VPWR sky130_fd_sc_hd__decap_3
XTAP_TAPCELL_ROW_78_1381 VGND VPWR sky130_fd_sc_hd__tapvpwrvgnd_1
X_5390_ _7745_/Q _4710_/A _5398_/S VGND VGND VPWR VPWR _5391_/A sky130_fd_sc_hd__mux2_2
XFILLER_126_784 VGND VGND VPWR VPWR sky130_fd_sc_hd__decap_3
XFILLER_99_635 VGND VGND VPWR VPWR sky130_fd_sc_hd__decap_3
X_4341_ _8428_/Q _8509_/Q _8590_/Q _8671_/Q _4352_/S _4368_/A VGND VGND VPWR VPWR
+ _4341_/X sky130_fd_sc_hd__mux4_2
XFILLER_113_445 VGND VGND VPWR VPWR sky130_fd_sc_hd__decap_3
Xfanout309 _4092_/S VGND VGND VPWR VPWR _4557_/A1 sky130_fd_sc_hd__clkdlybuf4s25_1
X_7060_ _7060_/A VGND VGND VPWR VPWR _8565_/D sky130_fd_sc_hd__buf_2
X_4272_ _8098_/Q _8179_/Q _4272_/S VGND VGND VPWR VPWR _4273_/B sky130_fd_sc_hd__mux2_2
XFILLER_101_629 VGND VGND VPWR VPWR sky130_fd_sc_hd__fill_2
XFILLER_113_478 VGND VGND VPWR VPWR sky130_fd_sc_hd__fill_1
XFILLER_79_370 VGND VGND VPWR VPWR sky130_fd_sc_hd__decap_3
XFILLER_98_178 VGND VGND VPWR VPWR sky130_fd_sc_hd__fill_2
XTAP_TAPCELL_ROW_91_1570 VGND VPWR sky130_fd_sc_hd__tapvpwrvgnd_1
X_6011_ _6011_/A0 _5026_/A _6011_/S VGND VGND VPWR VPWR _6012_/A sky130_fd_sc_hd__mux2_2
XFILLER_27_418 VGND VGND VPWR VPWR sky130_fd_sc_hd__decap_3
XFILLER_54_226 VGND VGND VPWR VPWR sky130_fd_sc_hd__decap_3
XFILLER_55_749 VGND VGND VPWR VPWR sky130_fd_sc_hd__decap_3
X_7962_ _8782_/CLK _7962_/D load_slew649/X VGND VGND VPWR VPWR _7962_/Q sky130_fd_sc_hd__dfrtp_2
XFILLER_54_259 VGND VGND VPWR VPWR sky130_fd_sc_hd__fill_2
XFILLER_70_719 VGND VGND VPWR VPWR sky130_fd_sc_hd__decap_3
X_6913_ _6913_/A VGND VGND VPWR VPWR _8496_/D sky130_fd_sc_hd__buf_6
XFILLER_35_484 VGND VGND VPWR VPWR sky130_fd_sc_hd__decap_3
X_7893_ _8802_/CLK _7893_/D load_slew579/X VGND VGND VPWR VPWR _7893_/Q sky130_fd_sc_hd__dfrtp_2
XFILLER_50_421 VGND VGND VPWR VPWR sky130_fd_sc_hd__decap_3
XFILLER_50_443 VGND VGND VPWR VPWR sky130_fd_sc_hd__fill_1
XFILLER_62_292 VGND VGND VPWR VPWR sky130_fd_sc_hd__decap_3
Xclkbuf_4_5_0_CLK clkbuf_0_CLK/X VGND VGND VPWR VPWR clkbuf_4_5_0_CLK/X sky130_fd_sc_hd__clkbuf_8
X_6844_ _6844_/A VGND VGND VPWR VPWR _8463_/D sky130_fd_sc_hd__buf_6
XFILLER_10_307 VGND VGND VPWR VPWR sky130_fd_sc_hd__fill_1
X_3987_ _8071_/Q _8152_/Q _8233_/Q _8314_/Q _3906_/S _3910_/A VGND VGND VPWR VPWR
+ _3988_/B sky130_fd_sc_hd__mux4_2
X_6775_ _6775_/A VGND VGND VPWR VPWR _8431_/D sky130_fd_sc_hd__buf_2
XFILLER_10_318 VGND VGND VPWR VPWR sky130_fd_sc_hd__decap_3
XFILLER_22_189 VGND VGND VPWR VPWR sky130_fd_sc_hd__decap_3
X_8514_ _8758_/CLK _8514_/D fanout711/X VGND VGND VPWR VPWR _8514_/Q sky130_fd_sc_hd__dfrtp_2
X_5726_ _7903_/Q _5036_/A _5742_/S VGND VGND VPWR VPWR _5727_/A sky130_fd_sc_hd__mux2_2
XFILLER_109_729 VGND VGND VPWR VPWR sky130_fd_sc_hd__decap_3
X_8445_ _8688_/CLK _8445_/D load_slew572/X VGND VGND VPWR VPWR _8445_/Q sky130_fd_sc_hd__dfrtp_2
X_5657_ _7871_/Q _4899_/A _5675_/S VGND VGND VPWR VPWR _5658_/A sky130_fd_sc_hd__mux2_2
XFILLER_117_12 VGND VGND VPWR VPWR sky130_fd_sc_hd__decap_3
X_8376_ _8781_/CLK _8376_/D fanout749/A VGND VGND VPWR VPWR _8376_/Q sky130_fd_sc_hd__dfrtp_2
X_5588_ _5588_/A VGND VGND VPWR VPWR _7838_/D sky130_fd_sc_hd__buf_1
X_4608_ _8290_/Q _4642_/A2 _4607_/X _4633_/A _4120_/A VGND VGND VPWR VPWR _4608_/X
+ sky130_fd_sc_hd__o221a_2
XFILLER_116_250 VGND VGND VPWR VPWR sky130_fd_sc_hd__fill_2
XFILLER_132_710 VGND VGND VPWR VPWR sky130_fd_sc_hd__decap_3
X_7327_ _7327_/A VGND VGND VPWR VPWR _8722_/D sky130_fd_sc_hd__buf_1
X_4539_ _4543_/A _4539_/B VGND VGND VPWR VPWR _4539_/X sky130_fd_sc_hd__or2_2
XFILLER_104_456 VGND VGND VPWR VPWR sky130_fd_sc_hd__decap_3
XFILLER_131_220 VGND VGND VPWR VPWR sky130_fd_sc_hd__decap_3
XFILLER_131_231 VGND VGND VPWR VPWR sky130_fd_sc_hd__decap_3
XFILLER_132_743 VGND VGND VPWR VPWR sky130_fd_sc_hd__decap_3
X_7258_ _7254_/X _4857_/X _7256_/X _7257_/X hold833/X VGND VGND VPWR VPWR _8681_/D
+ sky130_fd_sc_hd__a32o_2
XFILLER_131_264 VGND VGND VPWR VPWR sky130_fd_sc_hd__decap_3
XFILLER_132_787 VGND VGND VPWR VPWR sky130_fd_sc_hd__decap_3
XFILLER_89_167 VGND VGND VPWR VPWR sky130_fd_sc_hd__fill_1
X_6209_ _6209_/A VGND VGND VPWR VPWR _8165_/D sky130_fd_sc_hd__buf_6
X_7189_ _7267_/A VGND VGND VPWR VPWR _7189_/X sky130_fd_sc_hd__clkbuf_2
XFILLER_133_33 VGND VGND VPWR VPWR sky130_fd_sc_hd__decap_3
XFILLER_133_66 VGND VGND VPWR VPWR sky130_fd_sc_hd__decap_3
XFILLER_46_716 VGND VGND VPWR VPWR sky130_fd_sc_hd__decap_3
XFILLER_73_502 VGND VGND VPWR VPWR sky130_fd_sc_hd__fill_2
XTAP_TAPCELL_ROW_5_366 VGND VPWR sky130_fd_sc_hd__tapvpwrvgnd_1
Xhold1030 _7520_/Q VGND VGND VPWR VPWR _4788_/A1 sky130_fd_sc_hd__dlygate4sd3_1
Xhold1041 _7918_/Q VGND VGND VPWR VPWR _5757_/A0 sky130_fd_sc_hd__dlygate4sd3_1
XFILLER_133_99 VGND VGND VPWR VPWR sky130_fd_sc_hd__decap_3
XFILLER_45_215 VGND VGND VPWR VPWR sky130_fd_sc_hd__decap_3
XFILLER_73_535 VGND VGND VPWR VPWR sky130_fd_sc_hd__decap_3
Xhold1052 _7552_/Q VGND VGND VPWR VPWR _4922_/A1 sky130_fd_sc_hd__dlygate4sd3_1
Xhold1063 _7673_/Q VGND VGND VPWR VPWR _5237_/A0 sky130_fd_sc_hd__dlygate4sd3_1
XFILLER_45_259 VGND VGND VPWR VPWR sky130_fd_sc_hd__decap_3
XTAP_TAPCELL_ROW_44_906 VGND VPWR sky130_fd_sc_hd__tapvpwrvgnd_1
XFILLER_26_53 VGND VGND VPWR VPWR sky130_fd_sc_hd__decap_3
XFILLER_54_760 VGND VGND VPWR VPWR sky130_fd_sc_hd__decap_3
XTAP_TAPCELL_ROW_103_1728 VGND VPWR sky130_fd_sc_hd__tapvpwrvgnd_1
XTAP_TAPCELL_ROW_103_1739 VGND VPWR sky130_fd_sc_hd__tapvpwrvgnd_1
XTAP_TAPCELL_ROW_24_630 VGND VPWR sky130_fd_sc_hd__tapvpwrvgnd_1
XFILLER_13_167 VGND VGND VPWR VPWR sky130_fd_sc_hd__fill_1
XFILLER_41_443 VGND VGND VPWR VPWR sky130_fd_sc_hd__decap_3
XFILLER_42_52 VGND VGND VPWR VPWR sky130_fd_sc_hd__decap_3
XFILLER_9_138 VGND VGND VPWR VPWR sky130_fd_sc_hd__decap_3
XTAP_TAPCELL_ROW_62_1160 VGND VPWR sky130_fd_sc_hd__tapvpwrvgnd_1
XFILLER_42_85 VGND VGND VPWR VPWR sky130_fd_sc_hd__decap_3
XFILLER_127_526 VGND VGND VPWR VPWR sky130_fd_sc_hd__decap_3
XFILLER_127_559 VGND VGND VPWR VPWR sky130_fd_sc_hd__fill_1
XFILLER_5_355 VGND VGND VPWR VPWR sky130_fd_sc_hd__decap_3
XFILLER_107_250 VGND VGND VPWR VPWR sky130_fd_sc_hd__decap_3
XFILLER_135_570 VGND VGND VPWR VPWR sky130_fd_sc_hd__decap_3
XFILLER_122_220 VGND VGND VPWR VPWR sky130_fd_sc_hd__decap_3
XFILLER_123_732 VGND VGND VPWR VPWR sky130_fd_sc_hd__decap_3
XFILLER_123_765 VGND VGND VPWR VPWR sky130_fd_sc_hd__decap_3
XFILLER_135_592 VGND VGND VPWR VPWR sky130_fd_sc_hd__decap_3
XFILLER_122_253 VGND VGND VPWR VPWR sky130_fd_sc_hd__decap_3
XFILLER_1_561 VGND VGND VPWR VPWR sky130_fd_sc_hd__fill_2
XFILLER_3_24 VGND VGND VPWR VPWR sky130_fd_sc_hd__decap_3
XFILLER_95_104 VGND VGND VPWR VPWR sky130_fd_sc_hd__decap_3
XFILLER_96_616 VGND VGND VPWR VPWR sky130_fd_sc_hd__decap_3
XFILLER_96_638 VGND VGND VPWR VPWR sky130_fd_sc_hd__decap_3
XFILLER_3_57 VGND VGND VPWR VPWR sky130_fd_sc_hd__decap_3
XFILLER_67_60 VGND VGND VPWR VPWR sky130_fd_sc_hd__decap_3
XFILLER_37_716 VGND VGND VPWR VPWR sky130_fd_sc_hd__decap_3
XFILLER_49_598 VGND VGND VPWR VPWR sky130_fd_sc_hd__decap_3
XFILLER_36_248 VGND VGND VPWR VPWR sky130_fd_sc_hd__decap_3
XFILLER_64_579 VGND VGND VPWR VPWR sky130_fd_sc_hd__decap_3
XFILLER_32_432 VGND VGND VPWR VPWR sky130_fd_sc_hd__fill_1
X_3910_ _3910_/A _3910_/B VGND VGND VPWR VPWR _3910_/X sky130_fd_sc_hd__or2_2
X_4890_ _4890_/A _4902_/B VGND VGND VPWR VPWR _4891_/A sky130_fd_sc_hd__and2_2
XFILLER_32_454 VGND VGND VPWR VPWR sky130_fd_sc_hd__decap_3
X_3841_ _3841_/A VGND VGND VPWR VPWR _3841_/X sky130_fd_sc_hd__buf_1
XFILLER_32_498 VGND VGND VPWR VPWR sky130_fd_sc_hd__fill_1
X_3772_ _7640_/Q _4295_/A2 _3771_/X VGND VGND VPWR VPWR _3772_/X sky130_fd_sc_hd__o21a_2
X_6560_ _4749_/X _8331_/Q _6570_/S VGND VGND VPWR VPWR _6561_/A sky130_fd_sc_hd__mux2_2
XFILLER_118_504 VGND VGND VPWR VPWR sky130_fd_sc_hd__decap_3
XFILLER_9_650 VGND VGND VPWR VPWR sky130_fd_sc_hd__decap_3
X_5511_ _5511_/A VGND VGND VPWR VPWR _7801_/D sky130_fd_sc_hd__buf_1
XFILLER_118_526 VGND VGND VPWR VPWR sky130_fd_sc_hd__decap_3
XFILLER_8_160 VGND VGND VPWR VPWR sky130_fd_sc_hd__decap_3
XFILLER_9_694 VGND VGND VPWR VPWR sky130_fd_sc_hd__decap_3
X_6491_ _4953_/X _8298_/Q _6507_/S VGND VGND VPWR VPWR _6492_/A sky130_fd_sc_hd__mux2_2
X_8230_ _8470_/CLK _8230_/D load_slew589/X VGND VGND VPWR VPWR _8230_/Q sky130_fd_sc_hd__dfrtp_2
X_5442_ _5505_/S VGND VGND VPWR VPWR _5461_/S sky130_fd_sc_hd__buf_2
XFILLER_133_529 VGND VGND VPWR VPWR sky130_fd_sc_hd__decap_3
X_8161_ _8161_/CLK _8161_/D fanout578/X VGND VGND VPWR VPWR _8161_/Q sky130_fd_sc_hd__dfrtp_2
X_5373_ _5373_/A0 _5018_/A _5377_/S VGND VGND VPWR VPWR _5374_/A sky130_fd_sc_hd__mux2_2
XFILLER_113_231 VGND VGND VPWR VPWR sky130_fd_sc_hd__decap_3
XFILLER_114_754 VGND VGND VPWR VPWR sky130_fd_sc_hd__fill_2
XFILLER_126_592 VGND VGND VPWR VPWR sky130_fd_sc_hd__decap_3
XFILLER_99_432 VGND VGND VPWR VPWR sky130_fd_sc_hd__decap_3
X_8092_ _8748_/CLK _8092_/D fanout540/X VGND VGND VPWR VPWR _8092_/Q sky130_fd_sc_hd__dfrtp_2
X_7112_ _4815_/X hold920/X _7130_/S VGND VGND VPWR VPWR _7113_/A sky130_fd_sc_hd__mux2_1
X_4324_ _4617_/B1 _4323_/X _4617_/A1 VGND VGND VPWR VPWR _4324_/X sky130_fd_sc_hd__a21o_2
XFILLER_101_415 VGND VGND VPWR VPWR sky130_fd_sc_hd__decap_3
XFILLER_114_765 VGND VGND VPWR VPWR sky130_fd_sc_hd__fill_1
XFILLER_99_476 VGND VGND VPWR VPWR sky130_fd_sc_hd__decap_3
X_7043_ _7043_/A VGND VGND VPWR VPWR _8557_/D sky130_fd_sc_hd__buf_2
XFILLER_101_437 VGND VGND VPWR VPWR sky130_fd_sc_hd__fill_2
XFILLER_86_137 VGND VGND VPWR VPWR sky130_fd_sc_hd__decap_3
X_4255_ _8421_/Q _8502_/Q _4260_/S VGND VGND VPWR VPWR _4256_/B sky130_fd_sc_hd__mux2_2
XFILLER_86_159 VGND VGND VPWR VPWR sky130_fd_sc_hd__decap_3
XTAP_TAPCELL_ROW_2_314 VGND VPWR sky130_fd_sc_hd__tapvpwrvgnd_1
X_4186_ _4231_/A _4182_/X _4184_/X _4185_/X VGND VGND VPWR VPWR _4186_/X sky130_fd_sc_hd__a22o_2
XFILLER_55_502 VGND VGND VPWR VPWR sky130_fd_sc_hd__fill_2
XTAP_TAPCELL_ROW_2_325 VGND VPWR sky130_fd_sc_hd__tapvpwrvgnd_1
XFILLER_103_25 VGND VGND VPWR VPWR sky130_fd_sc_hd__decap_3
XFILLER_27_248 VGND VGND VPWR VPWR sky130_fd_sc_hd__decap_3
XFILLER_103_69 VGND VGND VPWR VPWR sky130_fd_sc_hd__decap_3
XFILLER_55_579 VGND VGND VPWR VPWR sky130_fd_sc_hd__decap_3
XFILLER_70_527 VGND VGND VPWR VPWR sky130_fd_sc_hd__fill_2
XFILLER_82_365 VGND VGND VPWR VPWR sky130_fd_sc_hd__fill_2
XPHY_EDGE_ROW_118_Right_118 VGND VGND VPWR VPWR sky130_fd_sc_hd__decap_3
X_7945_ _8765_/CLK _7945_/D load_slew582/X VGND VGND VPWR VPWR _7945_/Q sky130_fd_sc_hd__dfrtp_2
XFILLER_35_281 VGND VGND VPWR VPWR sky130_fd_sc_hd__decap_3
X_7876_ _8777_/CLK _7876_/D load_slew750/X VGND VGND VPWR VPWR _7876_/Q sky130_fd_sc_hd__dfrtp_2
X_6827_ _6827_/A VGND VGND VPWR VPWR _8456_/D sky130_fd_sc_hd__buf_2
XFILLER_10_115 VGND VGND VPWR VPWR sky130_fd_sc_hd__fill_1
XFILLER_10_137 VGND VGND VPWR VPWR sky130_fd_sc_hd__decap_3
X_6758_ _6758_/A VGND VGND VPWR VPWR _8423_/D sky130_fd_sc_hd__buf_2
XFILLER_12_44 VGND VGND VPWR VPWR sky130_fd_sc_hd__decap_3
X_6689_ _6689_/A VGND VGND VPWR VPWR _8390_/D sky130_fd_sc_hd__buf_2
X_5709_ _7895_/Q _5003_/A _5721_/S VGND VGND VPWR VPWR _5710_/A sky130_fd_sc_hd__mux2_2
XFILLER_128_44 VGND VGND VPWR VPWR sky130_fd_sc_hd__decap_3
XFILLER_12_77 VGND VGND VPWR VPWR sky130_fd_sc_hd__decap_3
XTAP_TAPCELL_ROW_131_2124 VGND VPWR sky130_fd_sc_hd__tapvpwrvgnd_1
X_8428_ _8712_/CLK _8428_/D load_slew689/X VGND VGND VPWR VPWR _8428_/Q sky130_fd_sc_hd__dfrtp_2
XFILLER_117_570 VGND VGND VPWR VPWR sky130_fd_sc_hd__decap_3
XFILLER_128_77 VGND VGND VPWR VPWR sky130_fd_sc_hd__decap_3
XFILLER_128_88 VGND VGND VPWR VPWR sky130_fd_sc_hd__decap_3
X_8359_ _8764_/CLK _8359_/D fanout566/X VGND VGND VPWR VPWR _8359_/Q sky130_fd_sc_hd__dfrtp_2
XFILLER_105_732 VGND VGND VPWR VPWR sky130_fd_sc_hd__decap_3
XFILLER_104_253 VGND VGND VPWR VPWR sky130_fd_sc_hd__decap_3
XFILLER_132_551 VGND VGND VPWR VPWR sky130_fd_sc_hd__decap_3
XFILLER_120_735 VGND VGND VPWR VPWR sky130_fd_sc_hd__decap_3
XFILLER_132_584 VGND VGND VPWR VPWR sky130_fd_sc_hd__decap_3
XFILLER_132_595 VGND VGND VPWR VPWR sky130_fd_sc_hd__decap_3
XFILLER_78_638 VGND VGND VPWR VPWR sky130_fd_sc_hd__decap_3
Xfanout662 fanout664/X VGND VGND VPWR VPWR fanout662/X sky130_fd_sc_hd__clkdlybuf4s25_1
Xfanout684 fanout685/X VGND VGND VPWR VPWR fanout684/X sky130_fd_sc_hd__clkdlybuf4s25_1
XFILLER_19_727 VGND VGND VPWR VPWR sky130_fd_sc_hd__fill_1
XFILLER_58_362 VGND VGND VPWR VPWR sky130_fd_sc_hd__fill_2
XTAP_TAPCELL_ROW_129_2097 VGND VPWR sky130_fd_sc_hd__tapvpwrvgnd_1
XTAP_TAPCELL_ROW_29_700 VGND VPWR sky130_fd_sc_hd__tapvpwrvgnd_1
Xfanout695 fanout702/X VGND VGND VPWR VPWR fanout695/X sky130_fd_sc_hd__clkdlybuf4s25_1
XFILLER_18_226 VGND VGND VPWR VPWR sky130_fd_sc_hd__decap_3
XFILLER_37_63 VGND VGND VPWR VPWR sky130_fd_sc_hd__decap_3
XFILLER_37_85 VGND VGND VPWR VPWR sky130_fd_sc_hd__decap_3
XFILLER_73_343 VGND VGND VPWR VPWR sky130_fd_sc_hd__decap_3
XFILLER_46_579 VGND VGND VPWR VPWR sky130_fd_sc_hd__decap_3
XFILLER_42_752 VGND VGND VPWR VPWR sky130_fd_sc_hd__decap_3
XFILLER_41_262 VGND VGND VPWR VPWR sky130_fd_sc_hd__fill_2
XFILLER_53_73 VGND VGND VPWR VPWR sky130_fd_sc_hd__fill_2
XFILLER_53_84 VGND VGND VPWR VPWR sky130_fd_sc_hd__decap_3
XFILLER_128_802 VGND VGND VPWR VPWR sky130_fd_sc_hd__fill_2
XFILLER_10_660 VGND VGND VPWR VPWR sky130_fd_sc_hd__decap_3
XFILLER_10_693 VGND VGND VPWR VPWR sky130_fd_sc_hd__decap_3
XFILLER_6_631 VGND VGND VPWR VPWR sky130_fd_sc_hd__decap_3
XTAP_TAPCELL_ROW_116_1919 VGND VPWR sky130_fd_sc_hd__tapvpwrvgnd_1
XFILLER_6_675 VGND VGND VPWR VPWR sky130_fd_sc_hd__decap_3
XTAP_TAPCELL_ROW_75_1340 VGND VPWR sky130_fd_sc_hd__tapvpwrvgnd_1
XFILLER_111_702 VGND VGND VPWR VPWR sky130_fd_sc_hd__decap_3
XFILLER_123_551 VGND VGND VPWR VPWR sky130_fd_sc_hd__fill_2
XFILLER_96_413 VGND VGND VPWR VPWR sky130_fd_sc_hd__decap_3
XFILLER_96_424 VGND VGND VPWR VPWR sky130_fd_sc_hd__decap_3
XFILLER_110_256 VGND VGND VPWR VPWR sky130_fd_sc_hd__fill_2
XFILLER_77_660 VGND VGND VPWR VPWR sky130_fd_sc_hd__decap_3
XFILLER_96_457 VGND VGND VPWR VPWR sky130_fd_sc_hd__decap_3
X_4040_ _4543_/A _4040_/B VGND VGND VPWR VPWR _4040_/X sky130_fd_sc_hd__or2_2
XFILLER_37_513 VGND VGND VPWR VPWR sky130_fd_sc_hd__fill_2
XFILLER_64_321 VGND VGND VPWR VPWR sky130_fd_sc_hd__decap_3
XFILLER_76_181 VGND VGND VPWR VPWR sky130_fd_sc_hd__fill_1
XFILLER_76_192 VGND VGND VPWR VPWR sky130_fd_sc_hd__decap_3
XFILLER_24_218 VGND VGND VPWR VPWR sky130_fd_sc_hd__fill_2
XFILLER_91_151 VGND VGND VPWR VPWR sky130_fd_sc_hd__decap_3
X_5991_ _5991_/A VGND VGND VPWR VPWR _8063_/D sky130_fd_sc_hd__buf_1
XFILLER_18_782 VGND VGND VPWR VPWR sky130_fd_sc_hd__fill_1
XFILLER_91_184 VGND VGND VPWR VPWR sky130_fd_sc_hd__decap_3
XFILLER_92_696 VGND VGND VPWR VPWR sky130_fd_sc_hd__decap_3
XTAP_TAPCELL_ROW_86_1491 VGND VPWR sky130_fd_sc_hd__tapvpwrvgnd_1
X_7730_ _8672_/CLK _7730_/D load_slew689/X VGND VGND VPWR VPWR _7730_/Q sky130_fd_sc_hd__dfrtp_2
X_4942_ _4941_/X _7557_/Q _7453_/S VGND VGND VPWR VPWR _4943_/A sky130_fd_sc_hd__mux2_2
X_7661_ _8483_/CLK _7661_/D fanout504/X VGND VGND VPWR VPWR _7661_/Q sky130_fd_sc_hd__dfrtp_2
XFILLER_20_413 VGND VGND VPWR VPWR sky130_fd_sc_hd__decap_3
XFILLER_20_424 VGND VGND VPWR VPWR sky130_fd_sc_hd__decap_3
X_6612_ _4853_/X _8356_/Q _6612_/S VGND VGND VPWR VPWR _6613_/A sky130_fd_sc_hd__mux2_2
X_4873_ _4873_/A VGND VGND VPWR VPWR _7540_/D sky130_fd_sc_hd__buf_1
XFILLER_119_802 VGND VGND VPWR VPWR sky130_fd_sc_hd__fill_2
X_3824_ _8058_/Q _8139_/Q _3824_/S VGND VGND VPWR VPWR _3825_/B sky130_fd_sc_hd__mux2_2
X_7592_ _8493_/CLK _7592_/D load_slew480/X VGND VGND VPWR VPWR _7592_/Q sky130_fd_sc_hd__dfrtp_2
X_3755_ _8702_/Q _8783_/Q _7558_/Q _7639_/Q _3747_/S _3755_/S1 VGND VGND VPWR VPWR
+ _3755_/X sky130_fd_sc_hd__mux4_2
X_6543_ _4715_/X _8323_/Q _6549_/S VGND VGND VPWR VPWR _6544_/A sky130_fd_sc_hd__mux2_2
XFILLER_9_491 VGND VGND VPWR VPWR sky130_fd_sc_hd__decap_3
X_6474_ _4921_/X _8291_/Q _6482_/S VGND VGND VPWR VPWR _6475_/A sky130_fd_sc_hd__mux2_2
XFILLER_133_326 VGND VGND VPWR VPWR sky130_fd_sc_hd__decap_3
XPHY_EDGE_ROW_12_Right_12 VGND VGND VPWR VPWR sky130_fd_sc_hd__decap_3
X_8213_ _8697_/CLK _8213_/D load_slew724/X VGND VGND VPWR VPWR _8213_/Q sky130_fd_sc_hd__dfrtp_2
X_5425_ _5425_/A VGND VGND VPWR VPWR _7761_/D sky130_fd_sc_hd__buf_1
XFILLER_133_337 VGND VGND VPWR VPWR sky130_fd_sc_hd__decap_3
XFILLER_114_562 VGND VGND VPWR VPWR sky130_fd_sc_hd__decap_3
X_8144_ _8751_/CLK _8144_/D load_slew628/X VGND VGND VPWR VPWR _8144_/Q sky130_fd_sc_hd__dfrtp_2
X_5356_ _7729_/Q _4984_/A _5356_/S VGND VGND VPWR VPWR _5357_/A sky130_fd_sc_hd__mux2_2
XFILLER_114_595 VGND VGND VPWR VPWR sky130_fd_sc_hd__decap_3
XFILLER_87_435 VGND VGND VPWR VPWR sky130_fd_sc_hd__decap_3
X_8075_ _8729_/CLK _8075_/D fanout490/X VGND VGND VPWR VPWR _8075_/Q sky130_fd_sc_hd__dfrtp_2
X_5287_ _7697_/Q _4849_/X _5289_/S VGND VGND VPWR VPWR _5288_/A sky130_fd_sc_hd__mux2_2
X_4307_ _8587_/Q _4660_/A2 _4306_/X VGND VGND VPWR VPWR _4307_/X sky130_fd_sc_hd__o21a_2
XFILLER_102_757 VGND VGND VPWR VPWR sky130_fd_sc_hd__decap_3
XFILLER_59_159 VGND VGND VPWR VPWR sky130_fd_sc_hd__decap_3
XFILLER_87_457 VGND VGND VPWR VPWR sky130_fd_sc_hd__decap_3
X_7026_ _7026_/A VGND VGND VPWR VPWR _8549_/D sky130_fd_sc_hd__buf_2
X_4238_ _8743_/Q _7518_/Q _7599_/Q _7680_/Q _4226_/S _4227_/A VGND VGND VPWR VPWR
+ _4238_/X sky130_fd_sc_hd__mux4_2
XFILLER_101_267 VGND VGND VPWR VPWR sky130_fd_sc_hd__fill_2
XFILLER_101_278 VGND VGND VPWR VPWR sky130_fd_sc_hd__fill_2
XPHY_EDGE_ROW_113_Left_249 VGND VGND VPWR VPWR sky130_fd_sc_hd__decap_3
XFILLER_55_343 VGND VGND VPWR VPWR sky130_fd_sc_hd__decap_3
X_4169_ _7755_/Q _7836_/Q _4197_/S VGND VGND VPWR VPWR _4170_/B sky130_fd_sc_hd__mux2_2
XFILLER_130_12 VGND VGND VPWR VPWR sky130_fd_sc_hd__decap_3
XFILLER_28_568 VGND VGND VPWR VPWR sky130_fd_sc_hd__decap_3
XPHY_EDGE_ROW_21_Right_21 VGND VGND VPWR VPWR sky130_fd_sc_hd__decap_3
XFILLER_43_549 VGND VGND VPWR VPWR sky130_fd_sc_hd__decap_3
XFILLER_55_387 VGND VGND VPWR VPWR sky130_fd_sc_hd__decap_3
X_7928_ _8750_/CLK _7928_/D wire638/X VGND VGND VPWR VPWR _7928_/Q sky130_fd_sc_hd__dfrtp_2
XFILLER_130_56 VGND VGND VPWR VPWR sky130_fd_sc_hd__decap_3
XFILLER_23_240 VGND VGND VPWR VPWR sky130_fd_sc_hd__decap_3
XFILLER_70_357 VGND VGND VPWR VPWR sky130_fd_sc_hd__decap_3
XFILLER_90_38 VGND VGND VPWR VPWR sky130_fd_sc_hd__decap_3
X_7859_ _8671_/CLK _7859_/D load_slew696/X VGND VGND VPWR VPWR _7859_/Q sky130_fd_sc_hd__dfrtp_2
XFILLER_128_109 VGND VGND VPWR VPWR sky130_fd_sc_hd__decap_3
XFILLER_23_284 VGND VGND VPWR VPWR sky130_fd_sc_hd__decap_3
XFILLER_23_32 VGND VGND VPWR VPWR sky130_fd_sc_hd__decap_3
XFILLER_7_406 VGND VGND VPWR VPWR sky130_fd_sc_hd__decap_3
XPHY_EDGE_ROW_122_Left_258 VGND VGND VPWR VPWR sky130_fd_sc_hd__decap_3
XFILLER_128_3 VGND VGND VPWR VPWR sky130_fd_sc_hd__decap_3
XFILLER_7_439 VGND VGND VPWR VPWR sky130_fd_sc_hd__decap_3
Xwire326 wire326/A VGND VGND VPWR VPWR wire326/X sky130_fd_sc_hd__clkbuf_4
XFILLER_109_345 VGND VGND VPWR VPWR sky130_fd_sc_hd__decap_3
XFILLER_99_14 VGND VGND VPWR VPWR sky130_fd_sc_hd__fill_2
XPHY_EDGE_ROW_30_Right_30 VGND VGND VPWR VPWR sky130_fd_sc_hd__decap_3
XFILLER_109_367 VGND VGND VPWR VPWR sky130_fd_sc_hd__decap_3
XFILLER_124_315 VGND VGND VPWR VPWR sky130_fd_sc_hd__decap_3
XFILLER_3_601 VGND VGND VPWR VPWR sky130_fd_sc_hd__decap_3
XFILLER_99_69 VGND VGND VPWR VPWR sky130_fd_sc_hd__fill_2
XFILLER_2_100 VGND VGND VPWR VPWR sky130_fd_sc_hd__decap_3
XFILLER_3_623 VGND VGND VPWR VPWR sky130_fd_sc_hd__decap_3
XFILLER_3_656 VGND VGND VPWR VPWR sky130_fd_sc_hd__decap_3
XFILLER_105_573 VGND VGND VPWR VPWR sky130_fd_sc_hd__fill_1
XTAP_TAPCELL_ROW_111_1849 VGND VPWR sky130_fd_sc_hd__tapvpwrvgnd_1
XTAP_TAPCELL_ROW_57_1092 VGND VPWR sky130_fd_sc_hd__tapvpwrvgnd_1
XFILLER_120_554 VGND VGND VPWR VPWR sky130_fd_sc_hd__decap_3
XFILLER_66_608 VGND VGND VPWR VPWR sky130_fd_sc_hd__decap_3
XPHY_EDGE_ROW_131_Left_267 VGND VGND VPWR VPWR sky130_fd_sc_hd__decap_3
XFILLER_47_800 VGND VGND VPWR VPWR sky130_fd_sc_hd__decap_3
XTAP_TAPCELL_ROW_70_1270 VGND VPWR sky130_fd_sc_hd__tapvpwrvgnd_1
Xfanout470 _4632_/S VGND VGND VPWR VPWR _4650_/S sky130_fd_sc_hd__clkdlybuf4s25_1
Xfanout481 fanout487/X VGND VGND VPWR VPWR fanout481/X sky130_fd_sc_hd__clkdlybuf4s25_1
Xfanout492 fanout507/X VGND VGND VPWR VPWR fanout492/X sky130_fd_sc_hd__clkdlybuf4s25_1
XFILLER_19_557 VGND VGND VPWR VPWR sky130_fd_sc_hd__decap_3
XFILLER_46_332 VGND VGND VPWR VPWR sky130_fd_sc_hd__fill_1
XFILLER_74_641 VGND VGND VPWR VPWR sky130_fd_sc_hd__decap_3
XFILLER_0_47 VGND VGND VPWR VPWR sky130_fd_sc_hd__decap_3
XFILLER_0_69 VGND VGND VPWR VPWR sky130_fd_sc_hd__decap_3
XFILLER_34_516 VGND VGND VPWR VPWR sky130_fd_sc_hd__decap_3
XFILLER_46_376 VGND VGND VPWR VPWR sky130_fd_sc_hd__fill_1
XFILLER_73_162 VGND VGND VPWR VPWR sky130_fd_sc_hd__decap_3
XFILLER_46_398 VGND VGND VPWR VPWR sky130_fd_sc_hd__decap_3
XFILLER_61_335 VGND VGND VPWR VPWR sky130_fd_sc_hd__fill_1
XFILLER_74_696 VGND VGND VPWR VPWR sky130_fd_sc_hd__decap_3
XFILLER_9_12 VGND VGND VPWR VPWR sky130_fd_sc_hd__decap_3
XFILLER_14_262 VGND VGND VPWR VPWR sky130_fd_sc_hd__decap_3
XFILLER_42_560 VGND VGND VPWR VPWR sky130_fd_sc_hd__decap_3
XFILLER_9_45 VGND VGND VPWR VPWR sky130_fd_sc_hd__decap_3
XTAP_TAPCELL_ROW_32_739 VGND VPWR sky130_fd_sc_hd__tapvpwrvgnd_1
XFILLER_119_109 VGND VGND VPWR VPWR sky130_fd_sc_hd__decap_3
XFILLER_9_78 VGND VGND VPWR VPWR sky130_fd_sc_hd__decap_3
XFILLER_128_610 VGND VGND VPWR VPWR sky130_fd_sc_hd__decap_3
XTAP_TAPCELL_ROW_12_463 VGND VPWR sky130_fd_sc_hd__tapvpwrvgnd_1
XFILLER_128_643 VGND VGND VPWR VPWR sky130_fd_sc_hd__fill_1
XFILLER_128_654 VGND VGND VPWR VPWR sky130_fd_sc_hd__decap_3
XFILLER_115_315 VGND VGND VPWR VPWR sky130_fd_sc_hd__fill_2
XFILLER_127_153 VGND VGND VPWR VPWR sky130_fd_sc_hd__decap_3
XFILLER_127_175 VGND VGND VPWR VPWR sky130_fd_sc_hd__decap_3
XFILLER_128_687 VGND VGND VPWR VPWR sky130_fd_sc_hd__decap_3
Xhold907 _8024_/Q VGND VGND VPWR VPWR hold907/X sky130_fd_sc_hd__dlygate4sd3_1
Xhold918 _8259_/Q VGND VGND VPWR VPWR hold918/X sky130_fd_sc_hd__dlygate4sd3_1
Xhold929 _8256_/Q VGND VGND VPWR VPWR hold929/X sky130_fd_sc_hd__dlygate4sd3_1
X_5210_ _7660_/Q _5036_/X _5226_/S VGND VGND VPWR VPWR _5211_/A sky130_fd_sc_hd__mux2_2
XFILLER_130_318 VGND VGND VPWR VPWR sky130_fd_sc_hd__decap_3
X_6190_ _6190_/A VGND VGND VPWR VPWR _8156_/D sky130_fd_sc_hd__buf_6
XFILLER_123_370 VGND VGND VPWR VPWR sky130_fd_sc_hd__decap_3
XFILLER_69_413 VGND VGND VPWR VPWR sky130_fd_sc_hd__decap_3
X_5141_ _5141_/A VGND VGND VPWR VPWR _7628_/D sky130_fd_sc_hd__buf_1
XFILLER_96_232 VGND VGND VPWR VPWR sky130_fd_sc_hd__decap_3
X_5072_ _4765_/X _7596_/Q _5074_/S VGND VGND VPWR VPWR _5073_/A sky130_fd_sc_hd__mux2_2
XFILLER_111_587 VGND VGND VPWR VPWR sky130_fd_sc_hd__decap_3
XFILLER_96_265 VGND VGND VPWR VPWR sky130_fd_sc_hd__fill_1
XFILLER_96_287 VGND VGND VPWR VPWR sky130_fd_sc_hd__decap_3
XFILLER_97_788 VGND VGND VPWR VPWR sky130_fd_sc_hd__fill_2
X_4023_ _4023_/A VGND VGND VPWR VPWR _4023_/X sky130_fd_sc_hd__buf_1
XFILLER_37_332 VGND VGND VPWR VPWR sky130_fd_sc_hd__decap_3
XFILLER_49_192 VGND VGND VPWR VPWR sky130_fd_sc_hd__fill_1
XTAP_TAPCELL_ROW_88_1520 VGND VPWR sky130_fd_sc_hd__tapvpwrvgnd_1
XTAP_TAPCELL_ROW_88_1531 VGND VPWR sky130_fd_sc_hd__tapvpwrvgnd_1
XFILLER_65_652 VGND VGND VPWR VPWR sky130_fd_sc_hd__decap_3
XFILLER_64_195 VGND VGND VPWR VPWR sky130_fd_sc_hd__fill_1
X_8762_ _8798_/CLK _8762_/D wire600/X VGND VGND VPWR VPWR _8762_/Q sky130_fd_sc_hd__dfrtp_2
XFILLER_52_368 VGND VGND VPWR VPWR sky130_fd_sc_hd__decap_3
XFILLER_80_655 VGND VGND VPWR VPWR sky130_fd_sc_hd__decap_3
X_7713_ _8699_/CLK _7713_/D load_slew724/X VGND VGND VPWR VPWR _7713_/Q sky130_fd_sc_hd__dfrtp_2
X_5974_ _8055_/Q _4952_/A _5990_/S VGND VGND VPWR VPWR _5975_/A sky130_fd_sc_hd__mux2_2
X_8693_ _8693_/CLK _8693_/D load_slew740/X VGND VGND VPWR VPWR _8693_/Q sky130_fd_sc_hd__dfrtp_2
X_4925_ _4925_/A VGND VGND VPWR VPWR _4925_/X sky130_fd_sc_hd__buf_1
XFILLER_20_210 VGND VGND VPWR VPWR sky130_fd_sc_hd__fill_2
X_7644_ _8788_/CLK _7644_/D load_slew663/X VGND VGND VPWR VPWR _7644_/Q sky130_fd_sc_hd__dfrtp_2
X_4856_ _4856_/A _4860_/B VGND VGND VPWR VPWR _4857_/A sky130_fd_sc_hd__and2_2
X_3807_ _8705_/Q _8786_/Q _3814_/S VGND VGND VPWR VPWR _3807_/X sky130_fd_sc_hd__mux2_2
X_7575_ _8719_/CLK _7575_/D load_slew591/X VGND VGND VPWR VPWR _7575_/Q sky130_fd_sc_hd__dfrtp_2
X_6526_ _5023_/X _8315_/Q _6528_/S VGND VGND VPWR VPWR _6527_/A sky130_fd_sc_hd__mux2_2
X_4787_ _4787_/A VGND VGND VPWR VPWR _4787_/X sky130_fd_sc_hd__buf_1
XFILLER_109_46 VGND VGND VPWR VPWR sky130_fd_sc_hd__fill_1
XFILLER_114_9 VGND VGND VPWR VPWR sky130_fd_sc_hd__decap_3
XFILLER_118_175 VGND VGND VPWR VPWR sky130_fd_sc_hd__decap_3
XFILLER_119_676 VGND VGND VPWR VPWR sky130_fd_sc_hd__decap_3
XFILLER_134_613 VGND VGND VPWR VPWR sky130_fd_sc_hd__decap_3
XTAP_TAPCELL_ROW_99_1682 VGND VPWR sky130_fd_sc_hd__tapvpwrvgnd_1
X_3738_ _3825_/A _3738_/B VGND VGND VPWR VPWR _3738_/X sky130_fd_sc_hd__or2_2
XFILLER_109_57 VGND VGND VPWR VPWR sky130_fd_sc_hd__decap_3
XFILLER_118_197 VGND VGND VPWR VPWR sky130_fd_sc_hd__decap_3
XFILLER_133_134 VGND VGND VPWR VPWR sky130_fd_sc_hd__decap_3
XFILLER_134_635 VGND VGND VPWR VPWR sky130_fd_sc_hd__decap_3
XFILLER_134_657 VGND VGND VPWR VPWR sky130_fd_sc_hd__decap_3
Xclkload80 _8700_/CLK VGND VGND VPWR VPWR clkload80/X sky130_fd_sc_hd__clkbuf_8
X_6457_ _4887_/X _8283_/Q _6461_/S VGND VGND VPWR VPWR _6458_/A sky130_fd_sc_hd__mux2_2
XFILLER_133_167 VGND VGND VPWR VPWR sky130_fd_sc_hd__fill_1
X_6388_ _4749_/X _8250_/Q _6398_/S VGND VGND VPWR VPWR _6389_/A sky130_fd_sc_hd__mux2_2
X_5408_ _5408_/A VGND VGND VPWR VPWR _7753_/D sky130_fd_sc_hd__buf_1
XFILLER_114_381 VGND VGND VPWR VPWR sky130_fd_sc_hd__decap_3
XFILLER_121_318 VGND VGND VPWR VPWR sky130_fd_sc_hd__decap_3
XFILLER_125_12 VGND VGND VPWR VPWR sky130_fd_sc_hd__decap_3
XFILLER_133_178 VGND VGND VPWR VPWR sky130_fd_sc_hd__decap_3
XFILLER_88_722 VGND VGND VPWR VPWR sky130_fd_sc_hd__decap_3
X_8127_ _8775_/CLK _8127_/D load_slew727/X VGND VGND VPWR VPWR _8127_/Q sky130_fd_sc_hd__dfrtp_2
X_5339_ _5339_/A VGND VGND VPWR VPWR _7720_/D sky130_fd_sc_hd__buf_1
XFILLER_0_648 VGND VGND VPWR VPWR sky130_fd_sc_hd__decap_3
XFILLER_125_45 VGND VGND VPWR VPWR sky130_fd_sc_hd__decap_3
XFILLER_87_243 VGND VGND VPWR VPWR sky130_fd_sc_hd__decap_3
XFILLER_102_587 VGND VGND VPWR VPWR sky130_fd_sc_hd__fill_1
XFILLER_125_78 VGND VGND VPWR VPWR sky130_fd_sc_hd__decap_3
XFILLER_29_800 VGND VGND VPWR VPWR sky130_fd_sc_hd__decap_3
XFILLER_47_107 VGND VGND VPWR VPWR sky130_fd_sc_hd__fill_1
X_8058_ _8382_/CLK _8058_/D fanout677/X VGND VGND VPWR VPWR _8058_/Q sky130_fd_sc_hd__dfrtp_2
XFILLER_18_21 VGND VGND VPWR VPWR sky130_fd_sc_hd__decap_3
XFILLER_18_32 VGND VGND VPWR VPWR sky130_fd_sc_hd__decap_3
XTAP_TAPCELL_ROW_126_2056 VGND VPWR sky130_fd_sc_hd__tapvpwrvgnd_1
X_7009_ _4953_/X _8541_/Q _7025_/S VGND VGND VPWR VPWR _7010_/A sky130_fd_sc_hd__mux2_2
XFILLER_18_65 VGND VGND VPWR VPWR sky130_fd_sc_hd__decap_3
XFILLER_28_376 VGND VGND VPWR VPWR sky130_fd_sc_hd__decap_3
XFILLER_24_582 VGND VGND VPWR VPWR sky130_fd_sc_hd__fill_1
XFILLER_12_744 VGND VGND VPWR VPWR sky130_fd_sc_hd__decap_3
XFILLER_8_704 VGND VGND VPWR VPWR sky130_fd_sc_hd__decap_3
XFILLER_11_254 VGND VGND VPWR VPWR sky130_fd_sc_hd__decap_3
XFILLER_129_429 VGND VGND VPWR VPWR sky130_fd_sc_hd__decap_3
XFILLER_12_766 VGND VGND VPWR VPWR sky130_fd_sc_hd__decap_3
XFILLER_8_737 VGND VGND VPWR VPWR sky130_fd_sc_hd__decap_3
XFILLER_12_799 VGND VGND VPWR VPWR sky130_fd_sc_hd__decap_3
XFILLER_7_236 VGND VGND VPWR VPWR sky130_fd_sc_hd__decap_3
XFILLER_125_613 VGND VGND VPWR VPWR sky130_fd_sc_hd__decap_3
XFILLER_50_52 VGND VGND VPWR VPWR sky130_fd_sc_hd__decap_3
XTAP_TAPCELL_ROW_59_1121 VGND VPWR sky130_fd_sc_hd__tapvpwrvgnd_1
XFILLER_112_307 VGND VGND VPWR VPWR sky130_fd_sc_hd__fill_1
XFILLER_112_318 VGND VGND VPWR VPWR sky130_fd_sc_hd__decap_3
XFILLER_3_464 VGND VGND VPWR VPWR sky130_fd_sc_hd__fill_2
XFILLER_79_722 VGND VGND VPWR VPWR sky130_fd_sc_hd__decap_3
XFILLER_79_766 VGND VGND VPWR VPWR sky130_fd_sc_hd__fill_2
XFILLER_79_777 VGND VGND VPWR VPWR sky130_fd_sc_hd__decap_3
XFILLER_120_351 VGND VGND VPWR VPWR sky130_fd_sc_hd__fill_1
XFILLER_120_373 VGND VGND VPWR VPWR sky130_fd_sc_hd__decap_3
XFILLER_38_118 VGND VGND VPWR VPWR sky130_fd_sc_hd__decap_3
XFILLER_66_427 VGND VGND VPWR VPWR sky130_fd_sc_hd__fill_1
XFILLER_47_630 VGND VGND VPWR VPWR sky130_fd_sc_hd__decap_3
XFILLER_19_365 VGND VGND VPWR VPWR sky130_fd_sc_hd__decap_3
XFILLER_35_803 VGND VGND VPWR VPWR sky130_fd_sc_hd__fill_1
XFILLER_74_460 VGND VGND VPWR VPWR sky130_fd_sc_hd__decap_3
XFILLER_75_60 VGND VGND VPWR VPWR sky130_fd_sc_hd__decap_3
XTAP_TAPCELL_ROW_37_809 VGND VPWR sky130_fd_sc_hd__tapvpwrvgnd_1
XFILLER_19_376 VGND VGND VPWR VPWR sky130_fd_sc_hd__decap_3
XFILLER_62_633 VGND VGND VPWR VPWR sky130_fd_sc_hd__decap_3
XFILLER_34_335 VGND VGND VPWR VPWR sky130_fd_sc_hd__decap_3
XFILLER_34_368 VGND VGND VPWR VPWR sky130_fd_sc_hd__decap_3
XFILLER_46_195 VGND VGND VPWR VPWR sky130_fd_sc_hd__fill_1
XTAP_TAPCELL_ROW_17_533 VGND VPWR sky130_fd_sc_hd__tapvpwrvgnd_1
XFILLER_61_165 VGND VGND VPWR VPWR sky130_fd_sc_hd__decap_3
XFILLER_62_699 VGND VGND VPWR VPWR sky130_fd_sc_hd__fill_1
XTAP_TAPCELL_ROW_83_1450 VGND VPWR sky130_fd_sc_hd__tapvpwrvgnd_1
XTAP_TAPCELL_ROW_83_1461 VGND VPWR sky130_fd_sc_hd__tapvpwrvgnd_1
XFILLER_15_582 VGND VGND VPWR VPWR sky130_fd_sc_hd__decap_3
X_5690_ _5690_/A0 _4965_/A _5700_/S VGND VGND VPWR VPWR _5691_/A sky130_fd_sc_hd__mux2_2
X_4710_ _4710_/A _4726_/B VGND VGND VPWR VPWR _4711_/A sky130_fd_sc_hd__and2_2
X_4641_ _8455_/Q _8536_/Q _4650_/S VGND VGND VPWR VPWR _4641_/X sky130_fd_sc_hd__mux2_2
XFILLER_30_585 VGND VGND VPWR VPWR sky130_fd_sc_hd__decap_3
XFILLER_128_451 VGND VGND VPWR VPWR sky130_fd_sc_hd__decap_3
X_7360_ _7360_/A VGND VGND VPWR VPWR _8738_/D sky130_fd_sc_hd__buf_1
X_4572_ _4666_/A1 _4561_/X _4564_/X _4567_/X _4571_/X VGND VGND VPWR VPWR _4572_/X
+ sky130_fd_sc_hd__o32a_2
XFILLER_128_495 VGND VGND VPWR VPWR sky130_fd_sc_hd__decap_3
X_7291_ _7291_/A VGND VGND VPWR VPWR _8705_/D sky130_fd_sc_hd__buf_1
X_6311_ _6311_/A VGND VGND VPWR VPWR _8214_/D sky130_fd_sc_hd__buf_6
XFILLER_115_134 VGND VGND VPWR VPWR sky130_fd_sc_hd__fill_1
Xhold759 _7985_/Q VGND VGND VPWR VPWR hold759/X sky130_fd_sc_hd__dlygate4sd3_1
X_6242_ _6242_/A VGND VGND VPWR VPWR _8181_/D sky130_fd_sc_hd__buf_6
XFILLER_115_178 VGND VGND VPWR VPWR sky130_fd_sc_hd__decap_3
XFILLER_130_115 VGND VGND VPWR VPWR sky130_fd_sc_hd__decap_3
XFILLER_131_638 VGND VGND VPWR VPWR sky130_fd_sc_hd__decap_3
XFILLER_111_340 VGND VGND VPWR VPWR sky130_fd_sc_hd__decap_3
XFILLER_130_159 VGND VGND VPWR VPWR sky130_fd_sc_hd__decap_3
XFILLER_69_243 VGND VGND VPWR VPWR sky130_fd_sc_hd__fill_2
XFILLER_97_552 VGND VGND VPWR VPWR sky130_fd_sc_hd__decap_3
Xload_slew640 fanout639/X VGND VGND VPWR VPWR load_slew640/X sky130_fd_sc_hd__buf_2
X_6173_ _6173_/A VGND VGND VPWR VPWR _8148_/D sky130_fd_sc_hd__buf_6
XFILLER_57_405 VGND VGND VPWR VPWR sky130_fd_sc_hd__decap_3
XFILLER_69_276 VGND VGND VPWR VPWR sky130_fd_sc_hd__decap_3
XFILLER_85_725 VGND VGND VPWR VPWR sky130_fd_sc_hd__decap_3
Xload_slew673 fanout672/X VGND VGND VPWR VPWR load_slew673/X sky130_fd_sc_hd__buf_4
Xload_slew651 fanout650/X VGND VGND VPWR VPWR fanout648/A sky130_fd_sc_hd__buf_4
X_5124_ _5124_/A VGND VGND VPWR VPWR _7620_/D sky130_fd_sc_hd__buf_1
XFILLER_111_384 VGND VGND VPWR VPWR sky130_fd_sc_hd__decap_3
XFILLER_57_449 VGND VGND VPWR VPWR sky130_fd_sc_hd__decap_3
X_5055_ _5118_/A VGND VGND VPWR VPWR _5074_/S sky130_fd_sc_hd__buf_2
XFILLER_37_140 VGND VGND VPWR VPWR sky130_fd_sc_hd__decap_3
XFILLER_53_600 VGND VGND VPWR VPWR sky130_fd_sc_hd__decap_3
XFILLER_84_268 VGND VGND VPWR VPWR sky130_fd_sc_hd__decap_3
X_4006_ _3984_/A _4004_/X _4005_/X VGND VGND VPWR VPWR _4006_/X sky130_fd_sc_hd__o21a_2
XFILLER_1_90 VGND VGND VPWR VPWR sky130_fd_sc_hd__decap_3
XFILLER_37_162 VGND VGND VPWR VPWR sky130_fd_sc_hd__decap_3
XFILLER_37_184 VGND VGND VPWR VPWR sky130_fd_sc_hd__decap_3
XFILLER_65_493 VGND VGND VPWR VPWR sky130_fd_sc_hd__fill_2
XFILLER_93_780 VGND VGND VPWR VPWR sky130_fd_sc_hd__decap_3
XFILLER_71_18 VGND VGND VPWR VPWR sky130_fd_sc_hd__fill_2
XFILLER_80_485 VGND VGND VPWR VPWR sky130_fd_sc_hd__decap_3
X_8745_ _8745_/CLK _8745_/D wire618/A VGND VGND VPWR VPWR _8745_/Q sky130_fd_sc_hd__dfrtp_2
X_5957_ _5958_/A1 _5958_/A2 _4933_/X _5958_/B1 hold893/X VGND VGND VPWR VPWR _8041_/D
+ sky130_fd_sc_hd__a32o_2
XFILLER_21_530 VGND VGND VPWR VPWR sky130_fd_sc_hd__decap_3
X_8676_ _8676_/CLK _8676_/D wire701/X VGND VGND VPWR VPWR _8676_/Q sky130_fd_sc_hd__dfrtp_2
X_4908_ _4908_/A VGND VGND VPWR VPWR _4908_/X sky130_fd_sc_hd__buf_1
X_7627_ _8771_/CLK _7627_/D load_slew596/X VGND VGND VPWR VPWR _7627_/Q sky130_fd_sc_hd__dfrtp_2
X_5888_ _5893_/A1 _5893_/A2 _4707_/X _5893_/B1 hold774/X VGND VGND VPWR VPWR _7987_/D
+ sky130_fd_sc_hd__a32o_2
X_4839_ _4839_/A VGND VGND VPWR VPWR _7532_/D sky130_fd_sc_hd__buf_1
XFILLER_5_718 VGND VGND VPWR VPWR sky130_fd_sc_hd__decap_3
XFILLER_5_729 VGND VGND VPWR VPWR sky130_fd_sc_hd__decap_3
X_7558_ _8783_/CLK _7558_/D wire680/X VGND VGND VPWR VPWR _7558_/Q sky130_fd_sc_hd__dfrtp_2
XFILLER_134_421 VGND VGND VPWR VPWR sky130_fd_sc_hd__decap_3
X_7489_ _5019_/X _8800_/Q _7495_/S VGND VGND VPWR VPWR _7490_/A sky130_fd_sc_hd__mux2_2
X_6509_ _6656_/S VGND VGND VPWR VPWR _6528_/S sky130_fd_sc_hd__buf_6
XFILLER_134_454 VGND VGND VPWR VPWR sky130_fd_sc_hd__decap_3
XFILLER_20_44 VGND VGND VPWR VPWR sky130_fd_sc_hd__decap_3
XFILLER_20_77 VGND VGND VPWR VPWR sky130_fd_sc_hd__decap_3
XFILLER_0_401 VGND VGND VPWR VPWR sky130_fd_sc_hd__fill_1
XFILLER_106_178 VGND VGND VPWR VPWR sky130_fd_sc_hd__fill_1
XFILLER_134_498 VGND VGND VPWR VPWR sky130_fd_sc_hd__decap_3
XFILLER_20_88 VGND VGND VPWR VPWR sky130_fd_sc_hd__decap_3
XFILLER_96_26 VGND VGND VPWR VPWR sky130_fd_sc_hd__fill_2
XFILLER_0_445 VGND VGND VPWR VPWR sky130_fd_sc_hd__decap_3
XTAP_TAPCELL_ROW_54_1051 VGND VPWR sky130_fd_sc_hd__tapvpwrvgnd_1
XFILLER_130_660 VGND VGND VPWR VPWR sky130_fd_sc_hd__decap_3
XFILLER_29_42 VGND VGND VPWR VPWR sky130_fd_sc_hd__decap_3
XFILLER_48_427 VGND VGND VPWR VPWR sky130_fd_sc_hd__fill_1
XFILLER_76_725 VGND VGND VPWR VPWR sky130_fd_sc_hd__decap_3
Xclkbuf_leaf_130_CLK clkbuf_5_6__f_CLK/X VGND VGND VPWR VPWR _8735_/CLK sky130_fd_sc_hd__clkbuf_8
XFILLER_130_693 VGND VGND VPWR VPWR sky130_fd_sc_hd__decap_3
XFILLER_75_213 VGND VGND VPWR VPWR sky130_fd_sc_hd__decap_3
XFILLER_29_641 VGND VGND VPWR VPWR sky130_fd_sc_hd__decap_3
XFILLER_28_195 VGND VGND VPWR VPWR sky130_fd_sc_hd__fill_1
XFILLER_71_430 VGND VGND VPWR VPWR sky130_fd_sc_hd__fill_1
XFILLER_83_290 VGND VGND VPWR VPWR sky130_fd_sc_hd__fill_1
XFILLER_90_249 VGND VGND VPWR VPWR sky130_fd_sc_hd__decap_3
XFILLER_16_368 VGND VGND VPWR VPWR sky130_fd_sc_hd__decap_3
XFILLER_44_677 VGND VGND VPWR VPWR sky130_fd_sc_hd__decap_3
XFILLER_44_699 VGND VGND VPWR VPWR sky130_fd_sc_hd__fill_1
XFILLER_45_85 VGND VGND VPWR VPWR sky130_fd_sc_hd__decap_3
XFILLER_12_563 VGND VGND VPWR VPWR sky130_fd_sc_hd__fill_1
XTAP_TAPCELL_ROW_42_878 VGND VPWR sky130_fd_sc_hd__tapvpwrvgnd_1
XFILLER_129_237 VGND VGND VPWR VPWR sky130_fd_sc_hd__decap_3
XFILLER_12_585 VGND VGND VPWR VPWR sky130_fd_sc_hd__decap_3
XFILLER_8_545 VGND VGND VPWR VPWR sky130_fd_sc_hd__decap_3
XFILLER_6_24 VGND VGND VPWR VPWR sky130_fd_sc_hd__decap_3
XFILLER_8_589 VGND VGND VPWR VPWR sky130_fd_sc_hd__decap_3
XANTENNA_6 _4860_/B VGND VGND VPWR VPWR sky130_fd_sc_hd__diode_2
XFILLER_125_432 VGND VGND VPWR VPWR sky130_fd_sc_hd__decap_3
XFILLER_6_35 VGND VGND VPWR VPWR sky130_fd_sc_hd__decap_3
XFILLER_113_605 VGND VGND VPWR VPWR sky130_fd_sc_hd__fill_2
XFILLER_4_740 VGND VGND VPWR VPWR sky130_fd_sc_hd__decap_3
XFILLER_6_68 VGND VGND VPWR VPWR sky130_fd_sc_hd__decap_3
XFILLER_3_250 VGND VGND VPWR VPWR sky130_fd_sc_hd__fill_1
XFILLER_4_784 VGND VGND VPWR VPWR sky130_fd_sc_hd__decap_3
XFILLER_98_327 VGND VGND VPWR VPWR sky130_fd_sc_hd__fill_1
Xclkbuf_leaf_121_CLK clkbuf_5_17__f_CLK/X VGND VGND VPWR VPWR _8670_/CLK sky130_fd_sc_hd__clkbuf_8
XFILLER_86_92 VGND VGND VPWR VPWR sky130_fd_sc_hd__decap_3
XFILLER_94_533 VGND VGND VPWR VPWR sky130_fd_sc_hd__decap_3
XFILLER_54_408 VGND VGND VPWR VPWR sky130_fd_sc_hd__decap_3
XFILLER_66_268 VGND VGND VPWR VPWR sky130_fd_sc_hd__fill_2
XFILLER_66_279 VGND VGND VPWR VPWR sky130_fd_sc_hd__decap_3
XFILLER_81_216 VGND VGND VPWR VPWR sky130_fd_sc_hd__decap_3
XFILLER_81_238 VGND VGND VPWR VPWR sky130_fd_sc_hd__fill_2
XFILLER_19_184 VGND VGND VPWR VPWR sky130_fd_sc_hd__decap_3
XFILLER_47_493 VGND VGND VPWR VPWR sky130_fd_sc_hd__decap_3
X_6860_ _4999_/X _8471_/Q _6874_/S VGND VGND VPWR VPWR _6861_/A sky130_fd_sc_hd__mux2_4
X_6791_ _8439_/Q _4860_/A _6807_/S VGND VGND VPWR VPWR _6792_/A sky130_fd_sc_hd__mux2_2
X_5811_ _5811_/A VGND VGND VPWR VPWR _7943_/D sky130_fd_sc_hd__buf_1
X_8530_ _8530_/CLK _8530_/D fanout737/X VGND VGND VPWR VPWR _8530_/Q sky130_fd_sc_hd__dfrtp_2
X_5742_ _7911_/Q _4727_/A _5742_/S VGND VGND VPWR VPWR _5743_/A sky130_fd_sc_hd__mux2_2
XFILLER_50_669 VGND VGND VPWR VPWR sky130_fd_sc_hd__decap_3
XFILLER_30_360 VGND VGND VPWR VPWR sky130_fd_sc_hd__decap_3
XFILLER_30_371 VGND VGND VPWR VPWR sky130_fd_sc_hd__decap_3
X_8461_ _8623_/CLK _8461_/D load_slew676/X VGND VGND VPWR VPWR _8461_/Q sky130_fd_sc_hd__dfrtp_2
X_5673_ _7879_/Q _4933_/A _5675_/S VGND VGND VPWR VPWR _5674_/A sky130_fd_sc_hd__mux2_2
XFILLER_129_771 VGND VGND VPWR VPWR sky130_fd_sc_hd__decap_3
XPHY_EDGE_ROW_6_Right_6 VGND VGND VPWR VPWR sky130_fd_sc_hd__decap_3
X_8392_ _8518_/CLK _8392_/D load_slew704/X VGND VGND VPWR VPWR _8392_/Q sky130_fd_sc_hd__dfrtp_2
X_7412_ _8763_/Q _4860_/A _7428_/S VGND VGND VPWR VPWR _7413_/A sky130_fd_sc_hd__mux2_2
X_4624_ _8777_/Q _7552_/Q _7633_/Q _7714_/Q _4670_/S0 _4651_/A VGND VGND VPWR VPWR
+ _4625_/B sky130_fd_sc_hd__mux4_2
XFILLER_116_421 VGND VGND VPWR VPWR sky130_fd_sc_hd__decap_3
XTAP_TAPCELL_ROW_96_1630 VGND VPWR sky130_fd_sc_hd__tapvpwrvgnd_1
XTAP_TAPCELL_ROW_96_1641 VGND VPWR sky130_fd_sc_hd__tapvpwrvgnd_1
X_7343_ _7343_/A VGND VGND VPWR VPWR _8730_/D sky130_fd_sc_hd__buf_1
X_4555_ _8366_/Q _3767_/A _3817_/A _8285_/Q _4525_/S VGND VGND VPWR VPWR _4555_/X
+ sky130_fd_sc_hd__o221a_2
XFILLER_116_454 VGND VGND VPWR VPWR sky130_fd_sc_hd__decap_3
Xmax_cap253 _4221_/A VGND VGND VPWR VPWR _4393_/A sky130_fd_sc_hd__clkbuf_8
Xmax_cap242 _3939_/X VGND VGND VPWR VPWR _4399_/A2 sky130_fd_sc_hd__buf_6
Xmax_cap231 _3732_/X VGND VGND VPWR VPWR _4313_/A1 sky130_fd_sc_hd__buf_6
XFILLER_131_424 VGND VGND VPWR VPWR sky130_fd_sc_hd__decap_3
XFILLER_89_327 VGND VGND VPWR VPWR sky130_fd_sc_hd__decap_3
Xmax_cap275 _4590_/S VGND VGND VPWR VPWR _4525_/S sky130_fd_sc_hd__buf_6
Xmax_cap264 _3735_/X VGND VGND VPWR VPWR _4510_/A1 sky130_fd_sc_hd__buf_6
X_7274_ _7267_/X _4913_/X _7280_/A3 _7280_/B1 hold889/X VGND VGND VPWR VPWR _8694_/D
+ sky130_fd_sc_hd__a32o_2
X_4486_ _4482_/X _4485_/X _4591_/S VGND VGND VPWR VPWR _4487_/A sky130_fd_sc_hd__mux2_2
XFILLER_89_349 VGND VGND VPWR VPWR sky130_fd_sc_hd__fill_2
X_6225_ _6225_/A VGND VGND VPWR VPWR _8173_/D sky130_fd_sc_hd__buf_6
XFILLER_131_479 VGND VGND VPWR VPWR sky130_fd_sc_hd__decap_3
Xclkbuf_leaf_112_CLK clkbuf_5_20__f_CLK/X VGND VGND VPWR VPWR _8387_/CLK sky130_fd_sc_hd__clkbuf_8
X_6156_ _6156_/A VGND VGND VPWR VPWR _8140_/D sky130_fd_sc_hd__buf_6
XFILLER_111_181 VGND VGND VPWR VPWR sky130_fd_sc_hd__decap_3
XFILLER_58_736 VGND VGND VPWR VPWR sky130_fd_sc_hd__fill_2
XFILLER_66_29 VGND VGND VPWR VPWR sky130_fd_sc_hd__decap_3
XFILLER_97_393 VGND VGND VPWR VPWR sky130_fd_sc_hd__decap_3
X_5107_ _5107_/A VGND VGND VPWR VPWR _7612_/D sky130_fd_sc_hd__buf_1
X_6087_ _8109_/Q _4836_/A _6095_/S VGND VGND VPWR VPWR _6088_/A sky130_fd_sc_hd__mux2_2
XTAP_TAPCELL_ROW_123_2015 VGND VPWR sky130_fd_sc_hd__tapvpwrvgnd_1
X_5038_ _5038_/A VGND VGND VPWR VPWR _7579_/D sky130_fd_sc_hd__buf_1
XFILLER_122_79 VGND VGND VPWR VPWR sky130_fd_sc_hd__fill_1
XFILLER_53_441 VGND VGND VPWR VPWR sky130_fd_sc_hd__decap_3
XFILLER_72_249 VGND VGND VPWR VPWR sky130_fd_sc_hd__decap_3
XFILLER_26_699 VGND VGND VPWR VPWR sky130_fd_sc_hd__fill_1
XTAP_TAPCELL_ROW_0_275 VGND VPWR sky130_fd_sc_hd__tapvpwrvgnd_1
XTAP_TAPCELL_ROW_0_286 VGND VPWR sky130_fd_sc_hd__tapvpwrvgnd_1
XTAP_TAPCELL_ROW_0_297 VGND VPWR sky130_fd_sc_hd__tapvpwrvgnd_1
XFILLER_15_33 VGND VGND VPWR VPWR sky130_fd_sc_hd__decap_3
XFILLER_15_66 VGND VGND VPWR VPWR sky130_fd_sc_hd__decap_3
XFILLER_40_135 VGND VGND VPWR VPWR sky130_fd_sc_hd__fill_2
XFILLER_41_658 VGND VGND VPWR VPWR sky130_fd_sc_hd__decap_3
X_8728_ _8728_/CLK _8728_/D fanout556/X VGND VGND VPWR VPWR _8728_/Q sky130_fd_sc_hd__dfrtp_2
X_6989_ _6989_/A VGND VGND VPWR VPWR _8532_/D sky130_fd_sc_hd__buf_6
XFILLER_21_360 VGND VGND VPWR VPWR sky130_fd_sc_hd__decap_3
X_8659_ _8740_/CLK _8659_/D load_slew536/X VGND VGND VPWR VPWR _8659_/Q sky130_fd_sc_hd__dfrtp_2
XFILLER_21_393 VGND VGND VPWR VPWR sky130_fd_sc_hd__decap_3
XFILLER_31_32 VGND VGND VPWR VPWR sky130_fd_sc_hd__decap_3
XFILLER_119_281 VGND VGND VPWR VPWR sky130_fd_sc_hd__decap_3
XTAP_TAPCELL_ROW_134_2166 VGND VPWR sky130_fd_sc_hd__tapvpwrvgnd_1
XFILLER_135_741 VGND VGND VPWR VPWR sky130_fd_sc_hd__decap_3
XFILLER_135_763 VGND VGND VPWR VPWR sky130_fd_sc_hd__decap_3
XFILLER_5_548 VGND VGND VPWR VPWR sky130_fd_sc_hd__fill_1
XFILLER_134_262 VGND VGND VPWR VPWR sky130_fd_sc_hd__decap_3
XFILLER_135_785 VGND VGND VPWR VPWR sky130_fd_sc_hd__decap_3
XFILLER_0_220 VGND VGND VPWR VPWR sky130_fd_sc_hd__decap_3
XFILLER_134_295 VGND VGND VPWR VPWR sky130_fd_sc_hd__decap_3
XFILLER_1_721 VGND VGND VPWR VPWR sky130_fd_sc_hd__decap_3
XFILLER_1_732 VGND VGND VPWR VPWR sky130_fd_sc_hd__decap_3
XFILLER_0_242 VGND VGND VPWR VPWR sky130_fd_sc_hd__fill_2
XFILLER_0_253 VGND VGND VPWR VPWR sky130_fd_sc_hd__decap_3
XFILLER_110_608 VGND VGND VPWR VPWR sky130_fd_sc_hd__decap_3
XFILLER_122_468 VGND VGND VPWR VPWR sky130_fd_sc_hd__decap_3
XFILLER_1_765 VGND VGND VPWR VPWR sky130_fd_sc_hd__decap_3
XFILLER_49_703 VGND VGND VPWR VPWR sky130_fd_sc_hd__decap_3
XFILLER_49_725 VGND VGND VPWR VPWR sky130_fd_sc_hd__decap_3
Xclkbuf_leaf_103_CLK clkload7/A VGND VGND VPWR VPWR _8382_/CLK sky130_fd_sc_hd__clkbuf_8
Xoutput87 _3757_/X VGND VGND VPWR VPWR rdata[0] sky130_fd_sc_hd__clkdlybuf4s25_1
Xoutput98 _3781_/X VGND VGND VPWR VPWR rdata[1] sky130_fd_sc_hd__clkdlybuf4s25_1
XFILLER_102_170 VGND VGND VPWR VPWR sky130_fd_sc_hd__decap_3
XFILLER_76_566 VGND VGND VPWR VPWR sky130_fd_sc_hd__decap_3
XFILLER_91_503 VGND VGND VPWR VPWR sky130_fd_sc_hd__fill_1
XFILLER_17_600 VGND VGND VPWR VPWR sky130_fd_sc_hd__fill_2
XFILLER_29_460 VGND VGND VPWR VPWR sky130_fd_sc_hd__decap_3
XFILLER_48_279 VGND VGND VPWR VPWR sky130_fd_sc_hd__decap_3
XTAP_TAPCELL_ROW_47_948 VGND VPWR sky130_fd_sc_hd__tapvpwrvgnd_1
XFILLER_16_121 VGND VGND VPWR VPWR sky130_fd_sc_hd__fill_1
XFILLER_17_633 VGND VGND VPWR VPWR sky130_fd_sc_hd__decap_3
XFILLER_44_430 VGND VGND VPWR VPWR sky130_fd_sc_hd__decap_3
XFILLER_56_290 VGND VGND VPWR VPWR sky130_fd_sc_hd__decap_3
XFILLER_72_750 VGND VGND VPWR VPWR sky130_fd_sc_hd__fill_2
XFILLER_91_547 VGND VGND VPWR VPWR sky130_fd_sc_hd__fill_1
XTAP_TAPCELL_ROW_67_1231 VGND VPWR sky130_fd_sc_hd__tapvpwrvgnd_1
XFILLER_16_165 VGND VGND VPWR VPWR sky130_fd_sc_hd__decap_3
XFILLER_17_666 VGND VGND VPWR VPWR sky130_fd_sc_hd__decap_3
XFILLER_44_452 VGND VGND VPWR VPWR sky130_fd_sc_hd__fill_1
XFILLER_44_474 VGND VGND VPWR VPWR sky130_fd_sc_hd__fill_2
XFILLER_112_90 VGND VGND VPWR VPWR sky130_fd_sc_hd__decap_3
XFILLER_31_113 VGND VGND VPWR VPWR sky130_fd_sc_hd__fill_2
XFILLER_32_658 VGND VGND VPWR VPWR sky130_fd_sc_hd__decap_3
XFILLER_44_485 VGND VGND VPWR VPWR sky130_fd_sc_hd__decap_3
XFILLER_71_293 VGND VGND VPWR VPWR sky130_fd_sc_hd__decap_3
XFILLER_72_50 VGND VGND VPWR VPWR sky130_fd_sc_hd__decap_3
XTAP_TAPCELL_ROW_27_672 VGND VPWR sky130_fd_sc_hd__tapvpwrvgnd_1
XFILLER_12_360 VGND VGND VPWR VPWR sky130_fd_sc_hd__decap_3
XPHY_EDGE_ROW_59_Right_59 VGND VGND VPWR VPWR sky130_fd_sc_hd__decap_3
XFILLER_75_6 VGND VGND VPWR VPWR sky130_fd_sc_hd__decap_3
XFILLER_99_603 VGND VGND VPWR VPWR sky130_fd_sc_hd__decap_3
XFILLER_125_273 VGND VGND VPWR VPWR sky130_fd_sc_hd__decap_3
XFILLER_126_796 VGND VGND VPWR VPWR sky130_fd_sc_hd__decap_3
XTAP_TAPCELL_ROW_78_1382 VGND VPWR sky130_fd_sc_hd__tapvpwrvgnd_1
X_4340_ _8347_/Q _4399_/A2 _3916_/B _8266_/Q _4677_/C1 VGND VGND VPWR VPWR _4340_/X
+ sky130_fd_sc_hd__o221a_2
XFILLER_125_284 VGND VGND VPWR VPWR sky130_fd_sc_hd__decap_3
XFILLER_4_592 VGND VGND VPWR VPWR sky130_fd_sc_hd__decap_3
XFILLER_98_124 VGND VGND VPWR VPWR sky130_fd_sc_hd__decap_3
XFILLER_99_647 VGND VGND VPWR VPWR sky130_fd_sc_hd__decap_3
X_4271_ _8665_/Q _4295_/A2 _4270_/X VGND VGND VPWR VPWR _4271_/X sky130_fd_sc_hd__o21a_2
XTAP_TAPCELL_ROW_91_1560 VGND VPWR sky130_fd_sc_hd__tapvpwrvgnd_1
XTAP_TAPCELL_ROW_91_1571 VGND VPWR sky130_fd_sc_hd__tapvpwrvgnd_1
X_6010_ _6010_/A VGND VGND VPWR VPWR _8072_/D sky130_fd_sc_hd__buf_1
XFILLER_79_393 VGND VGND VPWR VPWR sky130_fd_sc_hd__decap_3
XPHY_EDGE_ROW_68_Right_68 VGND VGND VPWR VPWR sky130_fd_sc_hd__decap_3
XFILLER_67_544 VGND VGND VPWR VPWR sky130_fd_sc_hd__decap_3
XFILLER_67_555 VGND VGND VPWR VPWR sky130_fd_sc_hd__fill_1
XFILLER_54_205 VGND VGND VPWR VPWR sky130_fd_sc_hd__fill_1
XFILLER_94_374 VGND VGND VPWR VPWR sky130_fd_sc_hd__decap_3
X_7961_ _8700_/CLK _7961_/D wire746/X VGND VGND VPWR VPWR _7961_/Q sky130_fd_sc_hd__dfrtp_2
XFILLER_54_238 VGND VGND VPWR VPWR sky130_fd_sc_hd__fill_1
XFILLER_54_249 VGND VGND VPWR VPWR sky130_fd_sc_hd__decap_3
X_7892_ _8712_/CLK _7892_/D load_slew589/X VGND VGND VPWR VPWR _7892_/Q sky130_fd_sc_hd__dfrtp_2
X_6912_ _4761_/X _8496_/Q _6916_/S VGND VGND VPWR VPWR _6913_/A sky130_fd_sc_hd__mux2_4
XFILLER_35_452 VGND VGND VPWR VPWR sky130_fd_sc_hd__decap_3
X_6843_ _4965_/X _8463_/Q _6853_/S VGND VGND VPWR VPWR _6844_/A sky130_fd_sc_hd__mux2_4
XPHY_EDGE_ROW_77_Right_77 VGND VGND VPWR VPWR sky130_fd_sc_hd__decap_3
X_3986_ _3980_/X _3982_/X _3984_/X _3985_/X VGND VGND VPWR VPWR _3986_/X sky130_fd_sc_hd__a22o_2
X_6774_ _8431_/Q _4828_/A _6786_/S VGND VGND VPWR VPWR _6775_/A sky130_fd_sc_hd__mux2_2
XFILLER_50_477 VGND VGND VPWR VPWR sky130_fd_sc_hd__decap_3
X_8513_ _8756_/CLK _8513_/D fanout702/X VGND VGND VPWR VPWR _8513_/Q sky130_fd_sc_hd__dfrtp_2
X_5725_ _5725_/A VGND VGND VPWR VPWR _7902_/D sky130_fd_sc_hd__buf_1
X_8444_ _8687_/CLK _8444_/D load_slew568/X VGND VGND VPWR VPWR _8444_/Q sky130_fd_sc_hd__dfrtp_2
X_5656_ _5677_/S VGND VGND VPWR VPWR _5675_/S sky130_fd_sc_hd__buf_2
XFILLER_108_229 VGND VGND VPWR VPWR sky130_fd_sc_hd__decap_3
X_4607_ _8128_/Q _8209_/Q _4630_/S VGND VGND VPWR VPWR _4607_/X sky130_fd_sc_hd__mux2_2
X_8375_ _8780_/CLK _8375_/D load_slew722/X VGND VGND VPWR VPWR _8375_/Q sky130_fd_sc_hd__dfrtp_2
X_5587_ _7838_/Q _4761_/A _5591_/S VGND VGND VPWR VPWR _5588_/A sky130_fd_sc_hd__mux2_2
XFILLER_117_774 VGND VGND VPWR VPWR sky130_fd_sc_hd__fill_1
XFILLER_117_785 VGND VGND VPWR VPWR sky130_fd_sc_hd__decap_3
XFILLER_132_722 VGND VGND VPWR VPWR sky130_fd_sc_hd__decap_3
XFILLER_89_113 VGND VGND VPWR VPWR sky130_fd_sc_hd__decap_3
X_7326_ _8722_/Q _5030_/A _7344_/S VGND VGND VPWR VPWR _7327_/A sky130_fd_sc_hd__mux2_2
X_4538_ _8770_/Q _7545_/Q _7626_/Q _7707_/Q _4544_/S0 _4498_/A VGND VGND VPWR VPWR
+ _4539_/B sky130_fd_sc_hd__mux4_2
XFILLER_116_295 VGND VGND VPWR VPWR sky130_fd_sc_hd__decap_3
XFILLER_117_57 VGND VGND VPWR VPWR sky130_fd_sc_hd__decap_3
XFILLER_132_755 VGND VGND VPWR VPWR sky130_fd_sc_hd__fill_1
XFILLER_7_9 VGND VGND VPWR VPWR sky130_fd_sc_hd__decap_3
X_7257_ _7270_/A VGND VGND VPWR VPWR _7257_/X sky130_fd_sc_hd__clkbuf_1
X_4469_ _8024_/Q _3806_/X _4065_/X _7943_/Q _4462_/A VGND VGND VPWR VPWR _4469_/X
+ sky130_fd_sc_hd__o221a_2
XFILLER_104_468 VGND VGND VPWR VPWR sky130_fd_sc_hd__decap_3
XFILLER_131_243 VGND VGND VPWR VPWR sky130_fd_sc_hd__decap_3
XFILLER_132_766 VGND VGND VPWR VPWR sky130_fd_sc_hd__decap_3
XFILLER_132_799 VGND VGND VPWR VPWR sky130_fd_sc_hd__decap_3
XPHY_EDGE_ROW_86_Right_86 VGND VGND VPWR VPWR sky130_fd_sc_hd__decap_3
XTAP_TAPCELL_ROW_51_1010 VGND VPWR sky130_fd_sc_hd__tapvpwrvgnd_1
X_6208_ _4731_/X _8165_/Q _6226_/S VGND VGND VPWR VPWR _6209_/A sky130_fd_sc_hd__mux2_4
XFILLER_131_287 VGND VGND VPWR VPWR sky130_fd_sc_hd__decap_3
XFILLER_133_12 VGND VGND VPWR VPWR sky130_fd_sc_hd__decap_3
XFILLER_58_522 VGND VGND VPWR VPWR sky130_fd_sc_hd__fill_1
XFILLER_58_533 VGND VGND VPWR VPWR sky130_fd_sc_hd__fill_1
XFILLER_98_691 VGND VGND VPWR VPWR sky130_fd_sc_hd__decap_3
X_7188_ _7188_/A1 _4981_/X _7176_/X _7179_/X hold825/X VGND VGND VPWR VPWR _8629_/D
+ sky130_fd_sc_hd__a32o_2
XFILLER_133_45 VGND VGND VPWR VPWR sky130_fd_sc_hd__decap_3
XTAP_TAPCELL_ROW_5_356 VGND VPWR sky130_fd_sc_hd__tapvpwrvgnd_1
XTAP_TAPCELL_ROW_5_367 VGND VPWR sky130_fd_sc_hd__tapvpwrvgnd_1
Xhold1020 _7957_/Q VGND VGND VPWR VPWR _5839_/A0 sky130_fd_sc_hd__dlygate4sd3_1
Xhold1031 _7632_/Q VGND VGND VPWR VPWR _5148_/A1 sky130_fd_sc_hd__dlygate4sd3_1
Xhold1042 _7657_/Q VGND VGND VPWR VPWR _5203_/A0 sky130_fd_sc_hd__dlygate4sd3_1
X_6139_ _8134_/Q _4940_/A _6139_/S VGND VGND VPWR VPWR _6140_/A sky130_fd_sc_hd__mux2_2
XFILLER_133_78 VGND VGND VPWR VPWR sky130_fd_sc_hd__decap_3
XFILLER_46_728 VGND VGND VPWR VPWR sky130_fd_sc_hd__fill_1
Xhold1053 _7513_/Q VGND VGND VPWR VPWR _4758_/A1 sky130_fd_sc_hd__dlygate4sd3_1
Xhold1064 _8748_/Q VGND VGND VPWR VPWR _7380_/A0 sky130_fd_sc_hd__dlygate4sd3_1
XFILLER_26_21 VGND VGND VPWR VPWR sky130_fd_sc_hd__decap_3
XFILLER_26_32 VGND VGND VPWR VPWR sky130_fd_sc_hd__decap_3
XFILLER_26_430 VGND VGND VPWR VPWR sky130_fd_sc_hd__fill_1
XFILLER_38_290 VGND VGND VPWR VPWR sky130_fd_sc_hd__decap_3
XFILLER_61_709 VGND VGND VPWR VPWR sky130_fd_sc_hd__decap_3
XFILLER_26_452 VGND VGND VPWR VPWR sky130_fd_sc_hd__decap_3
XFILLER_26_65 VGND VGND VPWR VPWR sky130_fd_sc_hd__decap_3
XFILLER_41_400 VGND VGND VPWR VPWR sky130_fd_sc_hd__decap_3
XFILLER_54_750 VGND VGND VPWR VPWR sky130_fd_sc_hd__decap_3
XTAP_TAPCELL_ROW_44_907 VGND VPWR sky130_fd_sc_hd__tapvpwrvgnd_1
XFILLER_13_113 VGND VGND VPWR VPWR sky130_fd_sc_hd__decap_3
XFILLER_41_422 VGND VGND VPWR VPWR sky130_fd_sc_hd__decap_3
XFILLER_81_591 VGND VGND VPWR VPWR sky130_fd_sc_hd__decap_3
XPHY_EDGE_ROW_95_Right_95 VGND VGND VPWR VPWR sky130_fd_sc_hd__decap_3
XTAP_TAPCELL_ROW_103_1729 VGND VPWR sky130_fd_sc_hd__tapvpwrvgnd_1
XFILLER_41_466 VGND VGND VPWR VPWR sky130_fd_sc_hd__fill_2
XTAP_TAPCELL_ROW_24_631 VGND VPWR sky130_fd_sc_hd__tapvpwrvgnd_1
XTAP_TAPCELL_ROW_62_1161 VGND VPWR sky130_fd_sc_hd__tapvpwrvgnd_1
XFILLER_127_505 VGND VGND VPWR VPWR sky130_fd_sc_hd__decap_3
XFILLER_42_64 VGND VGND VPWR VPWR sky130_fd_sc_hd__decap_3
XFILLER_6_802 VGND VGND VPWR VPWR sky130_fd_sc_hd__fill_2
XFILLER_127_538 VGND VGND VPWR VPWR sky130_fd_sc_hd__decap_3
XFILLER_108_752 VGND VGND VPWR VPWR sky130_fd_sc_hd__decap_3
XFILLER_5_334 VGND VGND VPWR VPWR sky130_fd_sc_hd__fill_2
XTAP_TAPCELL_ROW_118_1950 VGND VPWR sky130_fd_sc_hd__tapvpwrvgnd_1
XFILLER_5_378 VGND VGND VPWR VPWR sky130_fd_sc_hd__fill_2
XFILLER_122_232 VGND VGND VPWR VPWR sky130_fd_sc_hd__decap_3
XFILLER_123_744 VGND VGND VPWR VPWR sky130_fd_sc_hd__decap_3
XFILLER_123_777 VGND VGND VPWR VPWR sky130_fd_sc_hd__decap_3
XFILLER_123_788 VGND VGND VPWR VPWR sky130_fd_sc_hd__decap_3
XFILLER_3_36 VGND VGND VPWR VPWR sky130_fd_sc_hd__decap_3
XFILLER_122_276 VGND VGND VPWR VPWR sky130_fd_sc_hd__decap_3
XFILLER_1_595 VGND VGND VPWR VPWR sky130_fd_sc_hd__decap_3
XFILLER_3_69 VGND VGND VPWR VPWR sky130_fd_sc_hd__decap_3
XFILLER_89_691 VGND VGND VPWR VPWR sky130_fd_sc_hd__decap_3
XFILLER_67_72 VGND VGND VPWR VPWR sky130_fd_sc_hd__fill_1
XFILLER_67_94 VGND VGND VPWR VPWR sky130_fd_sc_hd__decap_3
XFILLER_29_290 VGND VGND VPWR VPWR sky130_fd_sc_hd__decap_3
XFILLER_64_536 VGND VGND VPWR VPWR sky130_fd_sc_hd__decap_3
XFILLER_64_547 VGND VGND VPWR VPWR sky130_fd_sc_hd__decap_3
XFILLER_64_558 VGND VGND VPWR VPWR sky130_fd_sc_hd__decap_3
XFILLER_17_452 VGND VGND VPWR VPWR sky130_fd_sc_hd__decap_3
XFILLER_45_750 VGND VGND VPWR VPWR sky130_fd_sc_hd__decap_3
XFILLER_83_60 VGND VGND VPWR VPWR sky130_fd_sc_hd__decap_3
XFILLER_60_731 VGND VGND VPWR VPWR sky130_fd_sc_hd__decap_3
XFILLER_91_399 VGND VGND VPWR VPWR sky130_fd_sc_hd__decap_3
X_3840_ _3836_/X _3839_/X _3840_/S VGND VGND VPWR VPWR _3841_/A sky130_fd_sc_hd__mux2_2
XFILLER_20_628 VGND VGND VPWR VPWR sky130_fd_sc_hd__decap_3
XFILLER_32_477 VGND VGND VPWR VPWR sky130_fd_sc_hd__decap_3
XPHY_EDGE_ROW_17_Left_153 VGND VGND VPWR VPWR sky130_fd_sc_hd__decap_3
X_3771_ _7559_/Q _3769_/X _3770_/X _3835_/S1 _3732_/A VGND VGND VPWR VPWR _3771_/X
+ sky130_fd_sc_hd__o221a_2
XFILLER_9_662 VGND VGND VPWR VPWR sky130_fd_sc_hd__decap_3
X_5510_ _7801_/Q _4945_/A _5528_/S VGND VGND VPWR VPWR _5511_/A sky130_fd_sc_hd__mux2_2
XFILLER_8_172 VGND VGND VPWR VPWR sky130_fd_sc_hd__decap_3
XFILLER_9_673 VGND VGND VPWR VPWR sky130_fd_sc_hd__decap_3
X_6490_ _6490_/A VGND VGND VPWR VPWR _8297_/D sky130_fd_sc_hd__buf_2
XFILLER_133_508 VGND VGND VPWR VPWR sky130_fd_sc_hd__decap_3
XTAP_TAPCELL_ROW_93_1600 VGND VPWR sky130_fd_sc_hd__tapvpwrvgnd_1
X_5441_ _5441_/A VGND VGND VPWR VPWR _7769_/D sky130_fd_sc_hd__buf_1
XFILLER_126_560 VGND VGND VPWR VPWR sky130_fd_sc_hd__decap_3
XFILLER_126_571 VGND VGND VPWR VPWR sky130_fd_sc_hd__decap_3
X_8160_ _8647_/CLK _8160_/D fanout534/X VGND VGND VPWR VPWR _8160_/Q sky130_fd_sc_hd__dfrtp_2
X_5372_ _5372_/A VGND VGND VPWR VPWR _7736_/D sky130_fd_sc_hd__buf_1
X_8091_ _8736_/CLK _8091_/D fanout508/X VGND VGND VPWR VPWR _8091_/Q sky130_fd_sc_hd__dfrtp_2
X_7111_ _7174_/S VGND VGND VPWR VPWR _7130_/S sky130_fd_sc_hd__buf_6
X_4323_ _8426_/Q _8507_/Q _8588_/Q _8669_/Q _4305_/S _3739_/B VGND VGND VPWR VPWR
+ _4323_/X sky130_fd_sc_hd__mux4_2
XFILLER_87_606 VGND VGND VPWR VPWR sky130_fd_sc_hd__decap_3
XFILLER_87_617 VGND VGND VPWR VPWR sky130_fd_sc_hd__fill_1
XFILLER_99_455 VGND VGND VPWR VPWR sky130_fd_sc_hd__decap_3
XPHY_EDGE_ROW_26_Left_162 VGND VGND VPWR VPWR sky130_fd_sc_hd__decap_3
X_7042_ _5019_/X _8557_/Q _7046_/S VGND VGND VPWR VPWR _7043_/A sky130_fd_sc_hd__mux2_2
XFILLER_113_287 VGND VGND VPWR VPWR sky130_fd_sc_hd__decap_3
X_4254_ _3760_/X _4249_/X _4253_/X VGND VGND VPWR VPWR _4254_/X sky130_fd_sc_hd__a21o_2
XFILLER_101_449 VGND VGND VPWR VPWR sky130_fd_sc_hd__decap_3
X_4185_ _8333_/Q _4032_/B _4160_/B _8252_/Q _3791_/A VGND VGND VPWR VPWR _4185_/X
+ sky130_fd_sc_hd__o221a_2
XFILLER_28_728 VGND VGND VPWR VPWR sky130_fd_sc_hd__decap_3
XTAP_TAPCELL_ROW_2_315 VGND VPWR sky130_fd_sc_hd__tapvpwrvgnd_1
XTAP_TAPCELL_ROW_2_326 VGND VPWR sky130_fd_sc_hd__tapvpwrvgnd_1
XFILLER_94_182 VGND VGND VPWR VPWR sky130_fd_sc_hd__decap_3
X_7944_ _8683_/CLK _7944_/D load_slew565/X VGND VGND VPWR VPWR _7944_/Q sky130_fd_sc_hd__dfrtp_2
X_7875_ _8776_/CLK _7875_/D load_slew731/X VGND VGND VPWR VPWR _7875_/Q sky130_fd_sc_hd__dfrtp_2
XFILLER_50_230 VGND VGND VPWR VPWR sky130_fd_sc_hd__decap_3
XPHY_EDGE_ROW_35_Left_171 VGND VGND VPWR VPWR sky130_fd_sc_hd__decap_3
X_6826_ _8456_/Q _4932_/A _6828_/S VGND VGND VPWR VPWR _6827_/A sky130_fd_sc_hd__mux2_2
XFILLER_11_617 VGND VGND VPWR VPWR sky130_fd_sc_hd__decap_3
XFILLER_50_263 VGND VGND VPWR VPWR sky130_fd_sc_hd__decap_3
XFILLER_51_797 VGND VGND VPWR VPWR sky130_fd_sc_hd__decap_3
X_6757_ _8423_/Q _4794_/A _6765_/S VGND VGND VPWR VPWR _6758_/A sky130_fd_sc_hd__mux2_2
XFILLER_109_505 VGND VGND VPWR VPWR sky130_fd_sc_hd__decap_3
XFILLER_12_12 VGND VGND VPWR VPWR sky130_fd_sc_hd__decap_3
X_3969_ _4326_/B VGND VGND VPWR VPWR _3969_/X sky130_fd_sc_hd__clkbuf_2
Xwire519 wire519/A VGND VGND VPWR VPWR wire519/X sky130_fd_sc_hd__clkbuf_4
X_5708_ _5708_/A VGND VGND VPWR VPWR _7894_/D sky130_fd_sc_hd__buf_1
XFILLER_128_12 VGND VGND VPWR VPWR sky130_fd_sc_hd__decap_3
XFILLER_6_109 VGND VGND VPWR VPWR sky130_fd_sc_hd__fill_2
X_6688_ _8390_/Q input6/X _6702_/S VGND VGND VPWR VPWR _6689_/A sky130_fd_sc_hd__mux2_2
XFILLER_12_56 VGND VGND VPWR VPWR sky130_fd_sc_hd__decap_3
X_8427_ _8427_/CLK _8427_/D wire631/X VGND VGND VPWR VPWR _8427_/Q sky130_fd_sc_hd__dfrtp_2
X_5639_ _5639_/A VGND VGND VPWR VPWR _7862_/D sky130_fd_sc_hd__buf_1
XFILLER_105_700 VGND VGND VPWR VPWR sky130_fd_sc_hd__fill_2
XFILLER_128_56 VGND VGND VPWR VPWR sky130_fd_sc_hd__decap_3
XFILLER_88_27 VGND VGND VPWR VPWR sky130_fd_sc_hd__fill_1
XTAP_TAPCELL_ROW_131_2125 VGND VPWR sky130_fd_sc_hd__tapvpwrvgnd_1
X_8358_ _8728_/CLK _8358_/D fanout556/X VGND VGND VPWR VPWR _8358_/Q sky130_fd_sc_hd__dfrtp_2
XFILLER_104_221 VGND VGND VPWR VPWR sky130_fd_sc_hd__decap_3
XFILLER_105_744 VGND VGND VPWR VPWR sky130_fd_sc_hd__decap_3
XFILLER_2_348 VGND VGND VPWR VPWR sky130_fd_sc_hd__fill_2
XFILLER_5_6 VGND VGND VPWR VPWR sky130_fd_sc_hd__decap_3
XPHY_EDGE_ROW_44_Left_180 VGND VGND VPWR VPWR sky130_fd_sc_hd__decap_3
X_7309_ _8714_/Q input6/X _7323_/S VGND VGND VPWR VPWR _7310_/A sky130_fd_sc_hd__mux2_2
XFILLER_104_265 VGND VGND VPWR VPWR sky130_fd_sc_hd__decap_3
XFILLER_132_563 VGND VGND VPWR VPWR sky130_fd_sc_hd__decap_3
X_8289_ _8694_/CLK _8289_/D load_slew729/X VGND VGND VPWR VPWR _8289_/Q sky130_fd_sc_hd__dfrtp_2
XTAP_TAPCELL_ROW_113_1880 VGND VPWR sky130_fd_sc_hd__tapvpwrvgnd_1
Xfanout630 fanout634/X VGND VGND VPWR VPWR wire631/A sky130_fd_sc_hd__clkdlybuf4s25_1
Xfanout641 fanout643/X VGND VGND VPWR VPWR fanout641/X sky130_fd_sc_hd__clkdlybuf4s25_1
Xfanout652 fanout653/X VGND VGND VPWR VPWR fanout652/X sky130_fd_sc_hd__clkdlybuf4s25_1
Xfanout674 fanout684/X VGND VGND VPWR VPWR fanout674/X sky130_fd_sc_hd__clkdlybuf4s25_1
Xfanout685 fanout754/A VGND VGND VPWR VPWR fanout685/X sky130_fd_sc_hd__clkdlybuf4s25_1
XFILLER_37_20 VGND VGND VPWR VPWR sky130_fd_sc_hd__decap_3
XFILLER_86_672 VGND VGND VPWR VPWR sky130_fd_sc_hd__decap_3
XFILLER_86_694 VGND VGND VPWR VPWR sky130_fd_sc_hd__decap_3
XTAP_TAPCELL_ROW_129_2098 VGND VPWR sky130_fd_sc_hd__tapvpwrvgnd_1
XTAP_TAPCELL_ROW_29_701 VGND VPWR sky130_fd_sc_hd__tapvpwrvgnd_1
XFILLER_27_750 VGND VGND VPWR VPWR sky130_fd_sc_hd__fill_1
XFILLER_27_772 VGND VGND VPWR VPWR sky130_fd_sc_hd__decap_3
XFILLER_46_569 VGND VGND VPWR VPWR sky130_fd_sc_hd__fill_1
XFILLER_73_355 VGND VGND VPWR VPWR sky130_fd_sc_hd__decap_3
XFILLER_26_271 VGND VGND VPWR VPWR sky130_fd_sc_hd__decap_3
XFILLER_27_794 VGND VGND VPWR VPWR sky130_fd_sc_hd__fill_2
XFILLER_33_219 VGND VGND VPWR VPWR sky130_fd_sc_hd__decap_3
XFILLER_61_539 VGND VGND VPWR VPWR sky130_fd_sc_hd__decap_3
XFILLER_14_433 VGND VGND VPWR VPWR sky130_fd_sc_hd__decap_3
XFILLER_41_296 VGND VGND VPWR VPWR sky130_fd_sc_hd__fill_1
XFILLER_10_672 VGND VGND VPWR VPWR sky130_fd_sc_hd__decap_3
XFILLER_6_610 VGND VGND VPWR VPWR sky130_fd_sc_hd__decap_3
XFILLER_127_335 VGND VGND VPWR VPWR sky130_fd_sc_hd__fill_1
XFILLER_5_131 VGND VGND VPWR VPWR sky130_fd_sc_hd__decap_3
XFILLER_6_643 VGND VGND VPWR VPWR sky130_fd_sc_hd__fill_1
XFILLER_6_654 VGND VGND VPWR VPWR sky130_fd_sc_hd__decap_3
XFILLER_127_368 VGND VGND VPWR VPWR sky130_fd_sc_hd__fill_1
XFILLER_6_687 VGND VGND VPWR VPWR sky130_fd_sc_hd__decap_3
XFILLER_5_186 VGND VGND VPWR VPWR sky130_fd_sc_hd__decap_3
XTAP_TAPCELL_ROW_75_1341 VGND VPWR sky130_fd_sc_hd__tapvpwrvgnd_1
XFILLER_111_714 VGND VGND VPWR VPWR sky130_fd_sc_hd__decap_3
XFILLER_69_617 VGND VGND VPWR VPWR sky130_fd_sc_hd__fill_1
Xclkbuf_4_4_0_CLK clkbuf_0_CLK/X VGND VGND VPWR VPWR clkbuf_4_4_0_CLK/X sky130_fd_sc_hd__clkbuf_8
XFILLER_123_585 VGND VGND VPWR VPWR sky130_fd_sc_hd__decap_3
XFILLER_1_370 VGND VGND VPWR VPWR sky130_fd_sc_hd__fill_1
XFILLER_68_138 VGND VGND VPWR VPWR sky130_fd_sc_hd__fill_2
XFILLER_49_352 VGND VGND VPWR VPWR sky130_fd_sc_hd__fill_1
XFILLER_64_344 VGND VGND VPWR VPWR sky130_fd_sc_hd__decap_3
XFILLER_92_620 VGND VGND VPWR VPWR sky130_fd_sc_hd__decap_3
XFILLER_94_81 VGND VGND VPWR VPWR sky130_fd_sc_hd__decap_3
XFILLER_52_517 VGND VGND VPWR VPWR sky130_fd_sc_hd__decap_3
XFILLER_91_130 VGND VGND VPWR VPWR sky130_fd_sc_hd__decap_3
XFILLER_91_163 VGND VGND VPWR VPWR sky130_fd_sc_hd__decap_3
X_5990_ _8063_/Q _4984_/A _5990_/S VGND VGND VPWR VPWR _5991_/A sky130_fd_sc_hd__mux2_2
XFILLER_91_196 VGND VGND VPWR VPWR sky130_fd_sc_hd__decap_3
XTAP_TAPCELL_ROW_86_1492 VGND VPWR sky130_fd_sc_hd__tapvpwrvgnd_1
X_4941_ _4941_/A VGND VGND VPWR VPWR _4941_/X sky130_fd_sc_hd__buf_1
X_7660_ _8733_/CLK _7660_/D load_slew486/X VGND VGND VPWR VPWR _7660_/Q sky130_fd_sc_hd__dfrtp_2
X_4872_ _4871_/X _4872_/A1 _4896_/S VGND VGND VPWR VPWR _4873_/A sky130_fd_sc_hd__mux2_2
XFILLER_60_583 VGND VGND VPWR VPWR sky130_fd_sc_hd__decap_3
X_3823_ _8382_/Q _8463_/Q _8544_/Q _8625_/Q _3824_/S _3825_/A VGND VGND VPWR VPWR
+ _3823_/X sky130_fd_sc_hd__mux4_2
X_6611_ _6611_/A VGND VGND VPWR VPWR _8355_/D sky130_fd_sc_hd__buf_2
XFILLER_20_436 VGND VGND VPWR VPWR sky130_fd_sc_hd__decap_3
X_7591_ _8646_/CLK _7591_/D load_slew529/X VGND VGND VPWR VPWR _7591_/Q sky130_fd_sc_hd__dfrtp_2
XFILLER_9_470 VGND VGND VPWR VPWR sky130_fd_sc_hd__decap_3
X_3754_ _8297_/Q _4682_/A2 _3752_/X _8216_/Q _4315_/C1 VGND VGND VPWR VPWR _3754_/X
+ sky130_fd_sc_hd__o221a_2
Xclkbuf_leaf_92_CLK clkload6/A VGND VGND VPWR VPWR _8547_/CLK sky130_fd_sc_hd__clkbuf_8
X_6542_ _6542_/A VGND VGND VPWR VPWR _8322_/D sky130_fd_sc_hd__buf_2
X_6473_ _6473_/A VGND VGND VPWR VPWR _8290_/D sky130_fd_sc_hd__buf_2
XFILLER_118_368 VGND VGND VPWR VPWR sky130_fd_sc_hd__decap_3
XFILLER_133_305 VGND VGND VPWR VPWR sky130_fd_sc_hd__decap_3
X_8212_ _8779_/CLK _8212_/D wire746/A VGND VGND VPWR VPWR _8212_/Q sky130_fd_sc_hd__dfrtp_2
X_5424_ _7761_/Q _4776_/A _5440_/S VGND VGND VPWR VPWR _5425_/A sky130_fd_sc_hd__mux2_2
XFILLER_133_349 VGND VGND VPWR VPWR sky130_fd_sc_hd__decap_3
X_8143_ _8791_/CLK _8143_/D fanout665/X VGND VGND VPWR VPWR _8143_/Q sky130_fd_sc_hd__dfrtp_2
X_5355_ _5355_/A VGND VGND VPWR VPWR _7728_/D sky130_fd_sc_hd__buf_1
XFILLER_102_736 VGND VGND VPWR VPWR sky130_fd_sc_hd__fill_1
XFILLER_59_127 VGND VGND VPWR VPWR sky130_fd_sc_hd__decap_3
XFILLER_87_414 VGND VGND VPWR VPWR sky130_fd_sc_hd__decap_3
XFILLER_99_274 VGND VGND VPWR VPWR sky130_fd_sc_hd__decap_3
XFILLER_99_296 VGND VGND VPWR VPWR sky130_fd_sc_hd__fill_2
X_8074_ _8560_/CLK _8074_/D _8053_/SET_B VGND VGND VPWR VPWR _8074_/Q sky130_fd_sc_hd__dfrtp_2
X_5286_ _5286_/A VGND VGND VPWR VPWR _7696_/D sky130_fd_sc_hd__buf_1
X_4306_ _8668_/Q _4326_/B _4305_/X _3739_/B _4460_/A VGND VGND VPWR VPWR _4306_/X
+ sky130_fd_sc_hd__o221a_2
XFILLER_114_25 VGND VGND VPWR VPWR sky130_fd_sc_hd__decap_3
XFILLER_87_447 VGND VGND VPWR VPWR sky130_fd_sc_hd__fill_1
X_7025_ _4985_/X _8549_/Q _7025_/S VGND VGND VPWR VPWR _7026_/A sky130_fd_sc_hd__mux2_2
X_4237_ _4235_/X _4236_/X _4252_/A VGND VGND VPWR VPWR _4237_/X sky130_fd_sc_hd__mux2_2
XFILLER_74_119 VGND VGND VPWR VPWR sky130_fd_sc_hd__decap_3
XFILLER_110_780 VGND VGND VPWR VPWR sky130_fd_sc_hd__decap_3
XFILLER_28_536 VGND VGND VPWR VPWR sky130_fd_sc_hd__fill_2
XFILLER_67_182 VGND VGND VPWR VPWR sky130_fd_sc_hd__decap_3
XFILLER_74_29 VGND VGND VPWR VPWR sky130_fd_sc_hd__decap_3
XFILLER_83_642 VGND VGND VPWR VPWR sky130_fd_sc_hd__decap_3
X_4168_ _4129_/A _4163_/X _4165_/X _4167_/X VGND VGND VPWR VPWR _4168_/X sky130_fd_sc_hd__a22o_2
XFILLER_15_208 VGND VGND VPWR VPWR sky130_fd_sc_hd__fill_2
XFILLER_82_141 VGND VGND VPWR VPWR sky130_fd_sc_hd__fill_1
X_4099_ _4096_/X _4097_/X _4098_/X _4099_/B2 VGND VGND VPWR VPWR _4099_/X sky130_fd_sc_hd__a22o_2
XFILLER_130_24 VGND VGND VPWR VPWR sky130_fd_sc_hd__decap_3
XFILLER_130_35 VGND VGND VPWR VPWR sky130_fd_sc_hd__decap_3
XFILLER_36_580 VGND VGND VPWR VPWR sky130_fd_sc_hd__decap_3
XFILLER_55_399 VGND VGND VPWR VPWR sky130_fd_sc_hd__decap_3
XFILLER_82_174 VGND VGND VPWR VPWR sky130_fd_sc_hd__decap_3
X_7927_ _8747_/CLK _7927_/D fanout644/X VGND VGND VPWR VPWR _7927_/Q sky130_fd_sc_hd__dfrtp_2
XFILLER_130_68 VGND VGND VPWR VPWR sky130_fd_sc_hd__decap_3
X_7858_ _8019_/CLK _7858_/D fanout708/X VGND VGND VPWR VPWR _7858_/Q sky130_fd_sc_hd__dfrtp_2
XFILLER_23_11 VGND VGND VPWR VPWR sky130_fd_sc_hd__decap_3
XFILLER_51_572 VGND VGND VPWR VPWR sky130_fd_sc_hd__fill_1
XTAP_TAPCELL_ROW_34_770 VGND VPWR sky130_fd_sc_hd__tapvpwrvgnd_1
X_6809_ _6830_/S VGND VGND VPWR VPWR _6828_/S sky130_fd_sc_hd__buf_2
XFILLER_23_44 VGND VGND VPWR VPWR sky130_fd_sc_hd__decap_3
XFILLER_51_594 VGND VGND VPWR VPWR sky130_fd_sc_hd__decap_3
X_7789_ _8029_/CLK _7789_/D load_slew570/X VGND VGND VPWR VPWR _7789_/Q sky130_fd_sc_hd__dfrtp_2
XFILLER_23_66 VGND VGND VPWR VPWR sky130_fd_sc_hd__decap_3
XFILLER_7_418 VGND VGND VPWR VPWR sky130_fd_sc_hd__decap_3
Xclkbuf_leaf_83_CLK clkbuf_leaf_84_CLK/A VGND VGND VPWR VPWR _8697_/CLK sky130_fd_sc_hd__clkbuf_8
XFILLER_109_379 VGND VGND VPWR VPWR sky130_fd_sc_hd__decap_3
XFILLER_124_349 VGND VGND VPWR VPWR sky130_fd_sc_hd__decap_3
XFILLER_2_112 VGND VGND VPWR VPWR sky130_fd_sc_hd__decap_3
XFILLER_3_613 VGND VGND VPWR VPWR sky130_fd_sc_hd__decap_3
XFILLER_3_635 VGND VGND VPWR VPWR sky130_fd_sc_hd__decap_3
XFILLER_105_541 VGND VGND VPWR VPWR sky130_fd_sc_hd__decap_3
XFILLER_3_3 VGND VGND VPWR VPWR sky130_fd_sc_hd__decap_3
XFILLER_3_668 VGND VGND VPWR VPWR sky130_fd_sc_hd__decap_3
XFILLER_3_679 VGND VGND VPWR VPWR sky130_fd_sc_hd__decap_3
XFILLER_120_522 VGND VGND VPWR VPWR sky130_fd_sc_hd__decap_3
XFILLER_132_382 VGND VGND VPWR VPWR sky130_fd_sc_hd__decap_3
XFILLER_2_167 VGND VGND VPWR VPWR sky130_fd_sc_hd__decap_3
XFILLER_78_425 VGND VGND VPWR VPWR sky130_fd_sc_hd__decap_3
XTAP_TAPCELL_ROW_57_1093 VGND VPWR sky130_fd_sc_hd__tapvpwrvgnd_1
XFILLER_19_503 VGND VGND VPWR VPWR sky130_fd_sc_hd__fill_1
XFILLER_48_63 VGND VGND VPWR VPWR sky130_fd_sc_hd__decap_3
XFILLER_48_85 VGND VGND VPWR VPWR sky130_fd_sc_hd__decap_3
XFILLER_93_406 VGND VGND VPWR VPWR sky130_fd_sc_hd__decap_3
XTAP_TAPCELL_ROW_70_1271 VGND VPWR sky130_fd_sc_hd__tapvpwrvgnd_1
Xfanout493 fanout497/X VGND VGND VPWR VPWR fanout493/X sky130_fd_sc_hd__clkdlybuf4s25_1
XFILLER_0_15 VGND VGND VPWR VPWR sky130_fd_sc_hd__decap_3
XFILLER_46_322 VGND VGND VPWR VPWR sky130_fd_sc_hd__fill_1
XFILLER_58_171 VGND VGND VPWR VPWR sky130_fd_sc_hd__decap_3
XFILLER_74_620 VGND VGND VPWR VPWR sky130_fd_sc_hd__decap_3
XFILLER_74_631 VGND VGND VPWR VPWR sky130_fd_sc_hd__decap_3
XFILLER_104_80 VGND VGND VPWR VPWR sky130_fd_sc_hd__decap_3
XFILLER_74_675 VGND VGND VPWR VPWR sky130_fd_sc_hd__decap_3
XFILLER_14_230 VGND VGND VPWR VPWR sky130_fd_sc_hd__fill_1
XFILLER_14_274 VGND VGND VPWR VPWR sky130_fd_sc_hd__decap_3
XFILLER_15_775 VGND VGND VPWR VPWR sky130_fd_sc_hd__decap_3
XFILLER_30_701 VGND VGND VPWR VPWR sky130_fd_sc_hd__decap_3
XFILLER_42_572 VGND VGND VPWR VPWR sky130_fd_sc_hd__decap_3
XFILLER_9_24 VGND VGND VPWR VPWR sky130_fd_sc_hd__decap_3
XFILLER_9_57 VGND VGND VPWR VPWR sky130_fd_sc_hd__decap_3
XFILLER_128_622 VGND VGND VPWR VPWR sky130_fd_sc_hd__decap_3
XFILLER_30_778 VGND VGND VPWR VPWR sky130_fd_sc_hd__decap_3
Xclkbuf_leaf_74_CLK clkload11/A VGND VGND VPWR VPWR _8698_/CLK sky130_fd_sc_hd__clkbuf_8
XFILLER_80_94 VGND VGND VPWR VPWR sky130_fd_sc_hd__decap_3
XTAP_TAPCELL_ROW_12_464 VGND VPWR sky130_fd_sc_hd__tapvpwrvgnd_1
XFILLER_127_165 VGND VGND VPWR VPWR sky130_fd_sc_hd__decap_3
XFILLER_128_666 VGND VGND VPWR VPWR sky130_fd_sc_hd__decap_3
XFILLER_128_699 VGND VGND VPWR VPWR sky130_fd_sc_hd__fill_1
Xhold908 _8662_/Q VGND VGND VPWR VPWR hold908/X sky130_fd_sc_hd__dlygate4sd3_1
Xhold919 _8576_/Q VGND VGND VPWR VPWR hold919/X sky130_fd_sc_hd__dlygate4sd3_1
XFILLER_127_187 VGND VGND VPWR VPWR sky130_fd_sc_hd__decap_3
XFILLER_6_495 VGND VGND VPWR VPWR sky130_fd_sc_hd__fill_2
XFILLER_111_511 VGND VGND VPWR VPWR sky130_fd_sc_hd__decap_3
XFILLER_97_712 VGND VGND VPWR VPWR sky130_fd_sc_hd__decap_3
X_5140_ _4899_/X _7628_/Q _5158_/S VGND VGND VPWR VPWR _5141_/A sky130_fd_sc_hd__mux2_2
XFILLER_123_393 VGND VGND VPWR VPWR sky130_fd_sc_hd__decap_3
XFILLER_2_690 VGND VGND VPWR VPWR sky130_fd_sc_hd__decap_3
XFILLER_97_756 VGND VGND VPWR VPWR sky130_fd_sc_hd__fill_2
XFILLER_97_767 VGND VGND VPWR VPWR sky130_fd_sc_hd__decap_3
X_5071_ _5071_/A VGND VGND VPWR VPWR _7595_/D sky130_fd_sc_hd__buf_1
XFILLER_84_417 VGND VGND VPWR VPWR sky130_fd_sc_hd__decap_3
X_4022_ _4018_/X _4021_/X _4112_/S VGND VGND VPWR VPWR _4023_/A sky130_fd_sc_hd__mux2_2
XFILLER_96_299 VGND VGND VPWR VPWR sky130_fd_sc_hd__decap_3
XTAP_TAPCELL_ROW_88_1521 VGND VPWR sky130_fd_sc_hd__tapvpwrvgnd_1
XFILLER_64_141 VGND VGND VPWR VPWR sky130_fd_sc_hd__fill_2
XFILLER_65_664 VGND VGND VPWR VPWR sky130_fd_sc_hd__decap_3
XFILLER_80_601 VGND VGND VPWR VPWR sky130_fd_sc_hd__decap_3
XFILLER_92_450 VGND VGND VPWR VPWR sky130_fd_sc_hd__decap_3
XFILLER_64_163 VGND VGND VPWR VPWR sky130_fd_sc_hd__fill_1
XFILLER_64_185 VGND VGND VPWR VPWR sky130_fd_sc_hd__decap_3
XFILLER_92_494 VGND VGND VPWR VPWR sky130_fd_sc_hd__fill_1
X_8761_ _8761_/CLK _8761_/D wire707/X VGND VGND VPWR VPWR _8761_/Q sky130_fd_sc_hd__dfrtp_2
X_5973_ _5973_/A VGND VGND VPWR VPWR _8054_/D sky130_fd_sc_hd__buf_1
XFILLER_80_645 VGND VGND VPWR VPWR sky130_fd_sc_hd__fill_2
X_7712_ _8694_/CLK _7712_/D fanout728/X VGND VGND VPWR VPWR _7712_/Q sky130_fd_sc_hd__dfrtp_2
X_4924_ _4924_/A _4936_/B VGND VGND VPWR VPWR _4925_/A sky130_fd_sc_hd__and2_2
XFILLER_33_561 VGND VGND VPWR VPWR sky130_fd_sc_hd__fill_1
X_8692_ _8773_/CLK _8692_/D load_slew738/X VGND VGND VPWR VPWR _8692_/Q sky130_fd_sc_hd__dfrtp_2
XFILLER_20_200 VGND VGND VPWR VPWR sky130_fd_sc_hd__fill_1
XFILLER_20_233 VGND VGND VPWR VPWR sky130_fd_sc_hd__fill_1
XFILLER_33_583 VGND VGND VPWR VPWR sky130_fd_sc_hd__decap_3
X_7643_ _8382_/CLK _7643_/D load_slew663/X VGND VGND VPWR VPWR _7643_/Q sky130_fd_sc_hd__dfrtp_2
X_4855_ _4855_/A VGND VGND VPWR VPWR _7536_/D sky130_fd_sc_hd__buf_1
X_3806_ _3939_/A VGND VGND VPWR VPWR _3806_/X sky130_fd_sc_hd__clkbuf_2
Xclkbuf_leaf_65_CLK clkload9/A VGND VGND VPWR VPWR _8757_/CLK sky130_fd_sc_hd__clkbuf_8
X_7574_ _8637_/CLK _7574_/D fanout595/X VGND VGND VPWR VPWR _7574_/Q sky130_fd_sc_hd__dfrtp_2
X_4786_ _4786_/A _4810_/B VGND VGND VPWR VPWR _4787_/A sky130_fd_sc_hd__and2_2
XFILLER_109_14 VGND VGND VPWR VPWR sky130_fd_sc_hd__decap_3
XTAP_TAPCELL_ROW_99_1672 VGND VPWR sky130_fd_sc_hd__tapvpwrvgnd_1
X_3737_ _7720_/Q _7801_/Q _3747_/S VGND VGND VPWR VPWR _3738_/B sky130_fd_sc_hd__mux2_2
X_6525_ _6525_/A VGND VGND VPWR VPWR _8314_/D sky130_fd_sc_hd__buf_2
XFILLER_109_25 VGND VGND VPWR VPWR sky130_fd_sc_hd__decap_3
XFILLER_118_165 VGND VGND VPWR VPWR sky130_fd_sc_hd__fill_1
XTAP_TAPCELL_ROW_99_1683 VGND VPWR sky130_fd_sc_hd__tapvpwrvgnd_1
XFILLER_133_102 VGND VGND VPWR VPWR sky130_fd_sc_hd__decap_3
XFILLER_133_113 VGND VGND VPWR VPWR sky130_fd_sc_hd__decap_3
XFILLER_69_29 VGND VGND VPWR VPWR sky130_fd_sc_hd__decap_3
Xclkload70 _8518_/CLK VGND VGND VPWR VPWR clkload70/X sky130_fd_sc_hd__clkbuf_4
X_6456_ _6456_/A VGND VGND VPWR VPWR _8282_/D sky130_fd_sc_hd__buf_2
XFILLER_133_146 VGND VGND VPWR VPWR sky130_fd_sc_hd__decap_3
XFILLER_134_669 VGND VGND VPWR VPWR sky130_fd_sc_hd__decap_3
XFILLER_88_701 VGND VGND VPWR VPWR sky130_fd_sc_hd__decap_3
Xclkload81 _8779_/CLK VGND VGND VPWR VPWR clkload81/X sky130_fd_sc_hd__clkbuf_8
X_6387_ _6387_/A VGND VGND VPWR VPWR _8249_/D sky130_fd_sc_hd__buf_2
X_5407_ _7753_/Q _4744_/A _5419_/S VGND VGND VPWR VPWR _5408_/A sky130_fd_sc_hd__mux2_2
XFILLER_102_511 VGND VGND VPWR VPWR sky130_fd_sc_hd__fill_1
XFILLER_102_522 VGND VGND VPWR VPWR sky130_fd_sc_hd__decap_3
XFILLER_125_24 VGND VGND VPWR VPWR sky130_fd_sc_hd__decap_3
XFILLER_88_734 VGND VGND VPWR VPWR sky130_fd_sc_hd__fill_1
X_8126_ _8450_/CLK _8126_/D load_slew742/X VGND VGND VPWR VPWR _8126_/Q sky130_fd_sc_hd__dfrtp_2
X_5338_ _7720_/Q input3/X _5356_/S VGND VGND VPWR VPWR _5339_/A sky130_fd_sc_hd__mux2_2
XFILLER_102_533 VGND VGND VPWR VPWR sky130_fd_sc_hd__decap_3
XFILLER_88_745 VGND VGND VPWR VPWR sky130_fd_sc_hd__fill_2
XFILLER_88_778 VGND VGND VPWR VPWR sky130_fd_sc_hd__decap_3
X_8057_ _8462_/CLK _8057_/D wire669/X VGND VGND VPWR VPWR _8057_/Q sky130_fd_sc_hd__dfrtp_2
XFILLER_47_119 VGND VGND VPWR VPWR sky130_fd_sc_hd__fill_1
XFILLER_75_417 VGND VGND VPWR VPWR sky130_fd_sc_hd__fill_1
XFILLER_85_39 VGND VGND VPWR VPWR sky130_fd_sc_hd__fill_1
X_7008_ _7008_/A VGND VGND VPWR VPWR _8540_/D sky130_fd_sc_hd__buf_2
X_5269_ _5269_/A VGND VGND VPWR VPWR _7688_/D sky130_fd_sc_hd__buf_1
XFILLER_102_599 VGND VGND VPWR VPWR sky130_fd_sc_hd__decap_3
XFILLER_18_44 VGND VGND VPWR VPWR sky130_fd_sc_hd__decap_3
XFILLER_68_480 VGND VGND VPWR VPWR sky130_fd_sc_hd__decap_3
XTAP_TAPCELL_ROW_126_2057 VGND VPWR sky130_fd_sc_hd__tapvpwrvgnd_1
XFILLER_18_77 VGND VGND VPWR VPWR sky130_fd_sc_hd__decap_3
XTAP_TAPCELL_ROW_39_840 VGND VPWR sky130_fd_sc_hd__tapvpwrvgnd_1
XFILLER_55_163 VGND VGND VPWR VPWR sky130_fd_sc_hd__fill_1
XFILLER_12_701 VGND VGND VPWR VPWR sky130_fd_sc_hd__fill_2
XFILLER_129_408 VGND VGND VPWR VPWR sky130_fd_sc_hd__decap_3
XFILLER_51_380 VGND VGND VPWR VPWR sky130_fd_sc_hd__decap_3
XFILLER_12_778 VGND VGND VPWR VPWR sky130_fd_sc_hd__decap_3
XFILLER_8_716 VGND VGND VPWR VPWR sky130_fd_sc_hd__decap_3
XTAP_TAPCELL_ROW_121_1990 VGND VPWR sky130_fd_sc_hd__tapvpwrvgnd_1
Xclkbuf_leaf_56_CLK clkbuf_leaf_89_CLK/A VGND VGND VPWR VPWR _8680_/CLK sky130_fd_sc_hd__clkbuf_8
XFILLER_109_121 VGND VGND VPWR VPWR sky130_fd_sc_hd__fill_1
XFILLER_8_749 VGND VGND VPWR VPWR sky130_fd_sc_hd__decap_3
XFILLER_125_603 VGND VGND VPWR VPWR sky130_fd_sc_hd__fill_1
XTAP_TAPCELL_ROW_59_1122 VGND VPWR sky130_fd_sc_hd__tapvpwrvgnd_1
XFILLER_50_97 VGND VGND VPWR VPWR sky130_fd_sc_hd__fill_1
XFILLER_125_658 VGND VGND VPWR VPWR sky130_fd_sc_hd__fill_1
XTAP_TAPCELL_ROW_72_1300 VGND VPWR sky130_fd_sc_hd__tapvpwrvgnd_1
XFILLER_3_487 VGND VGND VPWR VPWR sky130_fd_sc_hd__decap_3
XFILLER_78_200 VGND VGND VPWR VPWR sky130_fd_sc_hd__fill_1
XFILLER_105_393 VGND VGND VPWR VPWR sky130_fd_sc_hd__decap_3
XFILLER_120_330 VGND VGND VPWR VPWR sky130_fd_sc_hd__decap_3
XFILLER_133_691 VGND VGND VPWR VPWR sky130_fd_sc_hd__decap_3
XFILLER_120_396 VGND VGND VPWR VPWR sky130_fd_sc_hd__decap_3
XFILLER_47_620 VGND VGND VPWR VPWR sky130_fd_sc_hd__fill_2
XFILLER_78_299 VGND VGND VPWR VPWR sky130_fd_sc_hd__fill_1
XFILLER_93_225 VGND VGND VPWR VPWR sky130_fd_sc_hd__decap_3
XFILLER_93_236 VGND VGND VPWR VPWR sky130_fd_sc_hd__decap_3
XFILLER_19_333 VGND VGND VPWR VPWR sky130_fd_sc_hd__decap_3
XFILLER_46_141 VGND VGND VPWR VPWR sky130_fd_sc_hd__decap_3
XFILLER_93_258 VGND VGND VPWR VPWR sky130_fd_sc_hd__decap_3
XFILLER_19_388 VGND VGND VPWR VPWR sky130_fd_sc_hd__decap_3
XFILLER_62_645 VGND VGND VPWR VPWR sky130_fd_sc_hd__decap_3
XFILLER_62_667 VGND VGND VPWR VPWR sky130_fd_sc_hd__decap_3
XTAP_TAPCELL_ROW_17_534 VGND VPWR sky130_fd_sc_hd__tapvpwrvgnd_1
XFILLER_15_561 VGND VGND VPWR VPWR sky130_fd_sc_hd__decap_3
XFILLER_91_60 VGND VGND VPWR VPWR sky130_fd_sc_hd__decap_3
XTAP_TAPCELL_ROW_83_1451 VGND VPWR sky130_fd_sc_hd__tapvpwrvgnd_1
XFILLER_30_531 VGND VGND VPWR VPWR sky130_fd_sc_hd__fill_1
XFILLER_42_380 VGND VGND VPWR VPWR sky130_fd_sc_hd__decap_3
XFILLER_61_188 VGND VGND VPWR VPWR sky130_fd_sc_hd__decap_3
XFILLER_91_82 VGND VGND VPWR VPWR sky130_fd_sc_hd__decap_3
Xclkbuf_leaf_47_CLK clkload4/A VGND VGND VPWR VPWR _8639_/CLK sky130_fd_sc_hd__clkbuf_8
X_4640_ _4673_/S _4635_/X _4637_/X _4639_/X VGND VGND VPWR VPWR _4640_/X sky130_fd_sc_hd__a22o_2
XFILLER_128_430 VGND VGND VPWR VPWR sky130_fd_sc_hd__decap_3
XFILLER_30_575 VGND VGND VPWR VPWR sky130_fd_sc_hd__decap_3
XFILLER_128_463 VGND VGND VPWR VPWR sky130_fd_sc_hd__decap_3
X_6310_ _4937_/X _8214_/Q _6310_/S VGND VGND VPWR VPWR _6311_/A sky130_fd_sc_hd__mux2_4
X_4571_ _4605_/A1 _4569_/X _4570_/X _4665_/C1 VGND VGND VPWR VPWR _4571_/X sky130_fd_sc_hd__a31o_2
XFILLER_116_636 VGND VGND VPWR VPWR sky130_fd_sc_hd__decap_3
XFILLER_7_771 VGND VGND VPWR VPWR sky130_fd_sc_hd__decap_3
Xwire680 wire680/A VGND VGND VPWR VPWR wire680/X sky130_fd_sc_hd__clkbuf_4
X_7290_ _8705_/Q _4960_/A _7302_/S VGND VGND VPWR VPWR _7291_/A sky130_fd_sc_hd__mux2_2
XFILLER_131_606 VGND VGND VPWR VPWR sky130_fd_sc_hd__decap_3
X_6241_ _4799_/X _8181_/Q _6247_/S VGND VGND VPWR VPWR _6242_/A sky130_fd_sc_hd__mux2_4
XFILLER_131_617 VGND VGND VPWR VPWR sky130_fd_sc_hd__decap_3
X_6172_ _5003_/X _8148_/Q _6184_/S VGND VGND VPWR VPWR _6173_/A sky130_fd_sc_hd__mux2_4
XFILLER_130_127 VGND VGND VPWR VPWR sky130_fd_sc_hd__decap_3
X_5123_ _4866_/X _5123_/A1 _5137_/S VGND VGND VPWR VPWR _5124_/A sky130_fd_sc_hd__mux2_2
XFILLER_111_352 VGND VGND VPWR VPWR sky130_fd_sc_hd__fill_2
XFILLER_97_564 VGND VGND VPWR VPWR sky130_fd_sc_hd__decap_3
Xload_slew663 fanout662/X VGND VGND VPWR VPWR load_slew663/X sky130_fd_sc_hd__buf_4
XFILLER_111_396 VGND VGND VPWR VPWR sky130_fd_sc_hd__decap_3
XFILLER_38_631 VGND VGND VPWR VPWR sky130_fd_sc_hd__decap_3
Xload_slew696 fanout695/X VGND VGND VPWR VPWR load_slew696/X sky130_fd_sc_hd__buf_4
X_5054_ _5054_/A VGND VGND VPWR VPWR _7587_/D sky130_fd_sc_hd__buf_1
XFILLER_84_247 VGND VGND VPWR VPWR sky130_fd_sc_hd__decap_3
X_4005_ _7658_/Q _4032_/B _4160_/B _7577_/Q _3791_/A VGND VGND VPWR VPWR _4005_/X
+ sky130_fd_sc_hd__o221a_2
XFILLER_37_152 VGND VGND VPWR VPWR sky130_fd_sc_hd__fill_2
XFILLER_38_686 VGND VGND VPWR VPWR sky130_fd_sc_hd__fill_1
XFILLER_53_623 VGND VGND VPWR VPWR sky130_fd_sc_hd__fill_1
XFILLER_52_122 VGND VGND VPWR VPWR sky130_fd_sc_hd__decap_3
XFILLER_53_645 VGND VGND VPWR VPWR sky130_fd_sc_hd__decap_3
XFILLER_92_280 VGND VGND VPWR VPWR sky130_fd_sc_hd__decap_3
XPHY_EDGE_ROW_9_Left_145 VGND VGND VPWR VPWR sky130_fd_sc_hd__decap_3
X_8744_ _8744_/CLK _8744_/D fanout627/X VGND VGND VPWR VPWR _8744_/Q sky130_fd_sc_hd__dfrtp_2
X_5956_ _5958_/A1 _5947_/X _4929_/X _5948_/X hold843/X VGND VGND VPWR VPWR _8040_/D
+ sky130_fd_sc_hd__a32o_2
X_8675_ _8676_/CLK _8675_/D wire701/X VGND VGND VPWR VPWR _8675_/Q sky130_fd_sc_hd__dfrtp_2
X_5887_ _5893_/A1 _5893_/A2 _4703_/X _5893_/B1 hold758/X VGND VGND VPWR VPWR _7986_/D
+ sky130_fd_sc_hd__a32o_2
X_4907_ _4907_/A _4936_/B VGND VGND VPWR VPWR _4908_/A sky130_fd_sc_hd__and2_2
Xclkbuf_leaf_38_CLK clkload3/A VGND VGND VPWR VPWR _8029_/CLK sky130_fd_sc_hd__clkbuf_8
X_7626_ _8770_/CLK _7626_/D fanout549/X VGND VGND VPWR VPWR _7626_/Q sky130_fd_sc_hd__dfrtp_2
X_4838_ _4837_/X hold986/X _4862_/S VGND VGND VPWR VPWR _4839_/A sky130_fd_sc_hd__mux2_2
XFILLER_119_452 VGND VGND VPWR VPWR sky130_fd_sc_hd__decap_3
X_7557_ _8547_/CLK _7557_/D load_slew649/X VGND VGND VPWR VPWR _7557_/Q sky130_fd_sc_hd__dfrtp_2
X_4769_ _4769_/A VGND VGND VPWR VPWR _4769_/X sky130_fd_sc_hd__buf_1
XFILLER_134_411 VGND VGND VPWR VPWR sky130_fd_sc_hd__fill_1
XFILLER_134_433 VGND VGND VPWR VPWR sky130_fd_sc_hd__decap_3
XFILLER_20_12 VGND VGND VPWR VPWR sky130_fd_sc_hd__decap_3
XFILLER_4_218 VGND VGND VPWR VPWR sky130_fd_sc_hd__fill_2
X_7488_ _7488_/A VGND VGND VPWR VPWR _8799_/D sky130_fd_sc_hd__buf_1
X_6508_ _6508_/A VGND VGND VPWR VPWR _8306_/D sky130_fd_sc_hd__buf_2
XFILLER_106_135 VGND VGND VPWR VPWR sky130_fd_sc_hd__fill_1
XFILLER_107_658 VGND VGND VPWR VPWR sky130_fd_sc_hd__fill_2
XFILLER_20_56 VGND VGND VPWR VPWR sky130_fd_sc_hd__decap_3
X_6439_ _6439_/A VGND VGND VPWR VPWR _8274_/D sky130_fd_sc_hd__buf_2
XFILLER_134_477 VGND VGND VPWR VPWR sky130_fd_sc_hd__decap_3
XFILLER_121_149 VGND VGND VPWR VPWR sky130_fd_sc_hd__decap_3
XFILLER_88_542 VGND VGND VPWR VPWR sky130_fd_sc_hd__fill_2
XTAP_TAPCELL_ROW_54_1052 VGND VPWR sky130_fd_sc_hd__tapvpwrvgnd_1
X_8109_ _8758_/CLK _8109_/D fanout711/X VGND VGND VPWR VPWR _8109_/Q sky130_fd_sc_hd__dfrtp_2
XFILLER_130_672 VGND VGND VPWR VPWR sky130_fd_sc_hd__decap_3
XFILLER_29_54 VGND VGND VPWR VPWR sky130_fd_sc_hd__fill_2
XFILLER_29_76 VGND VGND VPWR VPWR sky130_fd_sc_hd__fill_1
XFILLER_75_225 VGND VGND VPWR VPWR sky130_fd_sc_hd__decap_3
XFILLER_28_141 VGND VGND VPWR VPWR sky130_fd_sc_hd__decap_3
XFILLER_29_98 VGND VGND VPWR VPWR sky130_fd_sc_hd__fill_1
XFILLER_29_697 VGND VGND VPWR VPWR sky130_fd_sc_hd__fill_2
XFILLER_91_729 VGND VGND VPWR VPWR sky130_fd_sc_hd__decap_3
XFILLER_43_111 VGND VGND VPWR VPWR sky130_fd_sc_hd__fill_1
XFILLER_44_645 VGND VGND VPWR VPWR sky130_fd_sc_hd__decap_3
XFILLER_45_53 VGND VGND VPWR VPWR sky130_fd_sc_hd__decap_3
XFILLER_90_239 VGND VGND VPWR VPWR sky130_fd_sc_hd__fill_1
XFILLER_43_144 VGND VGND VPWR VPWR sky130_fd_sc_hd__fill_2
XFILLER_45_97 VGND VGND VPWR VPWR sky130_fd_sc_hd__decap_3
XFILLER_12_520 VGND VGND VPWR VPWR sky130_fd_sc_hd__fill_1
XFILLER_71_497 VGND VGND VPWR VPWR sky130_fd_sc_hd__decap_3
XFILLER_129_205 VGND VGND VPWR VPWR sky130_fd_sc_hd__decap_3
XFILLER_12_542 VGND VGND VPWR VPWR sky130_fd_sc_hd__decap_3
XFILLER_8_513 VGND VGND VPWR VPWR sky130_fd_sc_hd__fill_2
XTAP_TAPCELL_ROW_42_879 VGND VPWR sky130_fd_sc_hd__tapvpwrvgnd_1
XFILLER_129_249 VGND VGND VPWR VPWR sky130_fd_sc_hd__decap_3
XFILLER_61_63 VGND VGND VPWR VPWR sky130_fd_sc_hd__decap_3
Xclkbuf_leaf_29_CLK clkbuf_5_8__f_CLK/X VGND VGND VPWR VPWR _8689_/CLK sky130_fd_sc_hd__clkbuf_8
XFILLER_8_557 VGND VGND VPWR VPWR sky130_fd_sc_hd__decap_3
XANTENNA_7 _5677_/S VGND VGND VPWR VPWR sky130_fd_sc_hd__diode_2
XFILLER_6_47 VGND VGND VPWR VPWR sky130_fd_sc_hd__decap_3
XFILLER_125_444 VGND VGND VPWR VPWR sky130_fd_sc_hd__decap_3
XFILLER_4_752 VGND VGND VPWR VPWR sky130_fd_sc_hd__decap_3
XFILLER_112_105 VGND VGND VPWR VPWR sky130_fd_sc_hd__decap_3
XFILLER_113_617 VGND VGND VPWR VPWR sky130_fd_sc_hd__decap_3
XFILLER_125_477 VGND VGND VPWR VPWR sky130_fd_sc_hd__decap_3
XFILLER_4_763 VGND VGND VPWR VPWR sky130_fd_sc_hd__decap_3
XFILLER_4_796 VGND VGND VPWR VPWR sky130_fd_sc_hd__decap_3
XFILLER_98_306 VGND VGND VPWR VPWR sky130_fd_sc_hd__fill_2
XFILLER_106_680 VGND VGND VPWR VPWR sky130_fd_sc_hd__decap_3
XFILLER_20_6 VGND VGND VPWR VPWR sky130_fd_sc_hd__decap_3
XFILLER_67_704 VGND VGND VPWR VPWR sky130_fd_sc_hd__fill_2
XFILLER_67_715 VGND VGND VPWR VPWR sky130_fd_sc_hd__decap_3
XFILLER_66_236 VGND VGND VPWR VPWR sky130_fd_sc_hd__decap_3
XFILLER_86_82 VGND VGND VPWR VPWR sky130_fd_sc_hd__fill_2
XFILLER_19_130 VGND VGND VPWR VPWR sky130_fd_sc_hd__decap_3
XFILLER_82_707 VGND VGND VPWR VPWR sky130_fd_sc_hd__decap_3
XFILLER_81_228 VGND VGND VPWR VPWR sky130_fd_sc_hd__fill_1
XFILLER_94_589 VGND VGND VPWR VPWR sky130_fd_sc_hd__decap_3
XFILLER_90_751 VGND VGND VPWR VPWR sky130_fd_sc_hd__decap_3
XFILLER_34_144 VGND VGND VPWR VPWR sky130_fd_sc_hd__decap_3
X_6790_ _6790_/A VGND VGND VPWR VPWR _8438_/D sky130_fd_sc_hd__buf_2
X_5810_ _7943_/Q _4861_/A _5826_/S VGND VGND VPWR VPWR _5811_/A sky130_fd_sc_hd__mux2_2
XFILLER_22_328 VGND VGND VPWR VPWR sky130_fd_sc_hd__decap_3
XFILLER_62_486 VGND VGND VPWR VPWR sky130_fd_sc_hd__decap_3
X_5741_ _5741_/A VGND VGND VPWR VPWR _7910_/D sky130_fd_sc_hd__buf_1
X_8460_ _8622_/CLK _8460_/D wire657/X VGND VGND VPWR VPWR _8460_/Q sky130_fd_sc_hd__dfrtp_2
X_7411_ _7411_/A VGND VGND VPWR VPWR _8762_/D sky130_fd_sc_hd__buf_1
X_5672_ _5672_/A VGND VGND VPWR VPWR _7878_/D sky130_fd_sc_hd__buf_1
XFILLER_129_750 VGND VGND VPWR VPWR sky130_fd_sc_hd__decap_3
X_8391_ _8761_/CLK _8391_/D wire707/X VGND VGND VPWR VPWR _8391_/Q sky130_fd_sc_hd__dfrtp_2
X_4623_ _4393_/A _4619_/X _4621_/X _4622_/X VGND VGND VPWR VPWR _4623_/X sky130_fd_sc_hd__a22o_2
XFILLER_116_400 VGND VGND VPWR VPWR sky130_fd_sc_hd__decap_3
XFILLER_129_783 VGND VGND VPWR VPWR sky130_fd_sc_hd__fill_1
XFILLER_129_794 VGND VGND VPWR VPWR sky130_fd_sc_hd__decap_3
XTAP_TAPCELL_ROW_96_1631 VGND VPWR sky130_fd_sc_hd__tapvpwrvgnd_1
XTAP_TAPCELL_ROW_96_1642 VGND VPWR sky130_fd_sc_hd__tapvpwrvgnd_1
Xmax_cap210 _5946_/X VGND VGND VPWR VPWR _5958_/A1 sky130_fd_sc_hd__buf_2
X_7342_ _7342_/A0 _4722_/A _7344_/S VGND VGND VPWR VPWR _7343_/A sky130_fd_sc_hd__mux2_2
X_4554_ _8123_/Q _8204_/Q _4554_/S VGND VGND VPWR VPWR _4554_/X sky130_fd_sc_hd__mux2_2
XFILLER_116_433 VGND VGND VPWR VPWR sky130_fd_sc_hd__decap_3
XFILLER_7_590 VGND VGND VPWR VPWR sky130_fd_sc_hd__decap_3
Xmax_cap243 _3921_/X VGND VGND VPWR VPWR _4634_/A2 sky130_fd_sc_hd__buf_6
Xmax_cap232 _7241_/X VGND VGND VPWR VPWR _7253_/A1 sky130_fd_sc_hd__buf_2
X_7273_ _7267_/X _4908_/X _7269_/X _7270_/X hold839/X VGND VGND VPWR VPWR _8693_/D
+ sky130_fd_sc_hd__a32o_2
XFILLER_116_477 VGND VGND VPWR VPWR sky130_fd_sc_hd__fill_2
XFILLER_116_488 VGND VGND VPWR VPWR sky130_fd_sc_hd__fill_1
Xmax_cap265 _4117_/A VGND VGND VPWR VPWR _3732_/A sky130_fd_sc_hd__buf_6
Xmax_cap254 _3785_/X VGND VGND VPWR VPWR _4631_/A2 sky130_fd_sc_hd__buf_6
X_6224_ _4765_/X _8173_/Q _6226_/S VGND VGND VPWR VPWR _6225_/A sky130_fd_sc_hd__mux2_4
X_4485_ _4483_/X _4484_/X _4534_/A VGND VGND VPWR VPWR _4485_/X sky130_fd_sc_hd__mux2_2
XFILLER_103_116 VGND VGND VPWR VPWR sky130_fd_sc_hd__fill_2
XFILLER_103_127 VGND VGND VPWR VPWR sky130_fd_sc_hd__decap_3
XFILLER_131_436 VGND VGND VPWR VPWR sky130_fd_sc_hd__decap_3
XFILLER_131_458 VGND VGND VPWR VPWR sky130_fd_sc_hd__decap_3
X_6155_ _4969_/X _8140_/Q _6163_/S VGND VGND VPWR VPWR _6156_/A sky130_fd_sc_hd__mux2_4
XFILLER_57_225 VGND VGND VPWR VPWR sky130_fd_sc_hd__fill_2
Xload_slew482 fanout481/X VGND VGND VPWR VPWR fanout479/A sky130_fd_sc_hd__buf_4
Xload_slew471 _4650_/S VGND VGND VPWR VPWR _4670_/S0 sky130_fd_sc_hd__buf_4
Xload_slew460 _4454_/S VGND VGND VPWR VPWR _4446_/S sky130_fd_sc_hd__buf_2
X_6086_ _6086_/A VGND VGND VPWR VPWR _8108_/D sky130_fd_sc_hd__buf_1
X_5106_ _4833_/X _5106_/A1 _5116_/S VGND VGND VPWR VPWR _5107_/A sky130_fd_sc_hd__mux2_2
XFILLER_122_14 VGND VGND VPWR VPWR sky130_fd_sc_hd__decap_3
XFILLER_57_269 VGND VGND VPWR VPWR sky130_fd_sc_hd__fill_2
XFILLER_85_567 VGND VGND VPWR VPWR sky130_fd_sc_hd__decap_3
X_5037_ _5036_/X _7579_/Q _5053_/S VGND VGND VPWR VPWR _5038_/A sky130_fd_sc_hd__mux2_2
XFILLER_26_601 VGND VGND VPWR VPWR sky130_fd_sc_hd__fill_1
XFILLER_26_623 VGND VGND VPWR VPWR sky130_fd_sc_hd__fill_1
XFILLER_85_589 VGND VGND VPWR VPWR sky130_fd_sc_hd__decap_3
XTAP_TAPCELL_ROW_123_2016 VGND VPWR sky130_fd_sc_hd__tapvpwrvgnd_1
XFILLER_26_645 VGND VGND VPWR VPWR sky130_fd_sc_hd__decap_3
XFILLER_15_12 VGND VGND VPWR VPWR sky130_fd_sc_hd__decap_3
XFILLER_41_604 VGND VGND VPWR VPWR sky130_fd_sc_hd__decap_3
XFILLER_53_453 VGND VGND VPWR VPWR sky130_fd_sc_hd__decap_3
XFILLER_80_250 VGND VGND VPWR VPWR sky130_fd_sc_hd__fill_2
XFILLER_81_773 VGND VGND VPWR VPWR sky130_fd_sc_hd__decap_3
XTAP_TAPCELL_ROW_0_276 VGND VPWR sky130_fd_sc_hd__tapvpwrvgnd_1
XTAP_TAPCELL_ROW_0_287 VGND VPWR sky130_fd_sc_hd__tapvpwrvgnd_1
XFILLER_13_317 VGND VGND VPWR VPWR sky130_fd_sc_hd__decap_3
XFILLER_15_45 VGND VGND VPWR VPWR sky130_fd_sc_hd__decap_3
XFILLER_25_177 VGND VGND VPWR VPWR sky130_fd_sc_hd__decap_3
XFILLER_25_188 VGND VGND VPWR VPWR sky130_fd_sc_hd__decap_3
XTAP_TAPCELL_ROW_0_298 VGND VPWR sky130_fd_sc_hd__tapvpwrvgnd_1
XTAP_TAPCELL_ROW_105_1760 VGND VPWR sky130_fd_sc_hd__tapvpwrvgnd_1
X_8727_ _8727_/CLK _8727_/D load_slew533/X VGND VGND VPWR VPWR _8727_/Q sky130_fd_sc_hd__dfrtp_2
X_6988_ _4913_/X _8532_/Q _7000_/S VGND VGND VPWR VPWR _6989_/A sky130_fd_sc_hd__mux2_4
XFILLER_15_78 VGND VGND VPWR VPWR sky130_fd_sc_hd__decap_3
X_5939_ _5933_/X _5934_/X _4871_/X _5935_/X hold819/X VGND VGND VPWR VPWR _8026_/D
+ sky130_fd_sc_hd__a32o_2
XFILLER_21_372 VGND VGND VPWR VPWR sky130_fd_sc_hd__decap_3
X_8658_ _8658_/CLK _8658_/D fanout516/X VGND VGND VPWR VPWR _8658_/Q sky130_fd_sc_hd__dfrtp_2
XFILLER_127_709 VGND VGND VPWR VPWR sky130_fd_sc_hd__decap_3
XFILLER_5_505 VGND VGND VPWR VPWR sky130_fd_sc_hd__fill_2
X_8589_ _8670_/CLK _8589_/D load_slew633/X VGND VGND VPWR VPWR _8589_/Q sky130_fd_sc_hd__dfrtp_2
X_7609_ _8782_/CLK _7609_/D load_slew642/X VGND VGND VPWR VPWR _7609_/Q sky130_fd_sc_hd__dfrtp_2
XFILLER_107_411 VGND VGND VPWR VPWR sky130_fd_sc_hd__decap_3
XTAP_TAPCELL_ROW_134_2167 VGND VPWR sky130_fd_sc_hd__tapvpwrvgnd_1
XFILLER_119_293 VGND VGND VPWR VPWR sky130_fd_sc_hd__decap_3
XFILLER_134_241 VGND VGND VPWR VPWR sky130_fd_sc_hd__decap_3
XFILLER_135_753 VGND VGND VPWR VPWR sky130_fd_sc_hd__decap_3
XFILLER_103_3 VGND VGND VPWR VPWR sky130_fd_sc_hd__decap_3
XFILLER_134_274 VGND VGND VPWR VPWR sky130_fd_sc_hd__decap_3
XFILLER_135_775 VGND VGND VPWR VPWR sky130_fd_sc_hd__decap_3
XFILLER_135_797 VGND VGND VPWR VPWR sky130_fd_sc_hd__decap_3
XFILLER_1_700 VGND VGND VPWR VPWR sky130_fd_sc_hd__decap_3
XFILLER_1_744 VGND VGND VPWR VPWR sky130_fd_sc_hd__decap_3
XFILLER_103_661 VGND VGND VPWR VPWR sky130_fd_sc_hd__fill_2
XFILLER_1_777 VGND VGND VPWR VPWR sky130_fd_sc_hd__decap_3
XFILLER_88_350 VGND VGND VPWR VPWR sky130_fd_sc_hd__fill_2
XFILLER_88_361 VGND VGND VPWR VPWR sky130_fd_sc_hd__decap_3
Xoutput88 _3902_/X VGND VGND VPWR VPWR rdata[10] sky130_fd_sc_hd__clkdlybuf4s25_1
Xoutput99 _4023_/X VGND VGND VPWR VPWR rdata[20] sky130_fd_sc_hd__clkdlybuf4s25_1
XFILLER_130_480 VGND VGND VPWR VPWR sky130_fd_sc_hd__decap_3
XFILLER_1_788 VGND VGND VPWR VPWR sky130_fd_sc_hd__decap_3
XTAP_TAPCELL_ROW_8_398 VGND VPWR sky130_fd_sc_hd__tapvpwrvgnd_1
XFILLER_36_409 VGND VGND VPWR VPWR sky130_fd_sc_hd__fill_1
XFILLER_48_236 VGND VGND VPWR VPWR sky130_fd_sc_hd__fill_2
XFILLER_56_41 VGND VGND VPWR VPWR sky130_fd_sc_hd__decap_3
XFILLER_64_707 VGND VGND VPWR VPWR sky130_fd_sc_hd__decap_3
XFILLER_76_578 VGND VGND VPWR VPWR sky130_fd_sc_hd__decap_3
XFILLER_57_781 VGND VGND VPWR VPWR sky130_fd_sc_hd__decap_3
XFILLER_63_206 VGND VGND VPWR VPWR sky130_fd_sc_hd__decap_3
XFILLER_76_589 VGND VGND VPWR VPWR sky130_fd_sc_hd__decap_3
XFILLER_17_623 VGND VGND VPWR VPWR sky130_fd_sc_hd__fill_2
XFILLER_17_645 VGND VGND VPWR VPWR sky130_fd_sc_hd__decap_3
XFILLER_29_483 VGND VGND VPWR VPWR sky130_fd_sc_hd__decap_3
XFILLER_56_85 VGND VGND VPWR VPWR sky130_fd_sc_hd__decap_3
XTAP_TAPCELL_ROW_47_949 VGND VPWR sky130_fd_sc_hd__tapvpwrvgnd_1
XTAP_TAPCELL_ROW_67_1232 VGND VPWR sky130_fd_sc_hd__tapvpwrvgnd_1
XFILLER_32_637 VGND VGND VPWR VPWR sky130_fd_sc_hd__decap_3
XFILLER_71_261 VGND VGND VPWR VPWR sky130_fd_sc_hd__decap_3
XFILLER_72_62 VGND VGND VPWR VPWR sky130_fd_sc_hd__fill_1
XTAP_TAPCELL_ROW_27_673 VGND VPWR sky130_fd_sc_hd__tapvpwrvgnd_1
XTAP_TAPCELL_ROW_80_1410 VGND VPWR sky130_fd_sc_hd__tapvpwrvgnd_1
XFILLER_9_800 VGND VGND VPWR VPWR sky130_fd_sc_hd__decap_3
XFILLER_31_169 VGND VGND VPWR VPWR sky130_fd_sc_hd__fill_2
XFILLER_40_681 VGND VGND VPWR VPWR sky130_fd_sc_hd__decap_3
XFILLER_118_709 VGND VGND VPWR VPWR sky130_fd_sc_hd__decap_3
XFILLER_8_365 VGND VGND VPWR VPWR sky130_fd_sc_hd__decap_3
XFILLER_126_775 VGND VGND VPWR VPWR sky130_fd_sc_hd__decap_3
XTAP_TAPCELL_ROW_78_1383 VGND VPWR sky130_fd_sc_hd__tapvpwrvgnd_1
XFILLER_113_436 VGND VGND VPWR VPWR sky130_fd_sc_hd__decap_3
XFILLER_98_147 VGND VGND VPWR VPWR sky130_fd_sc_hd__fill_1
X_4270_ _8584_/Q _3769_/X _4269_/X _3739_/B _4460_/A VGND VGND VPWR VPWR _4270_/X
+ sky130_fd_sc_hd__o221a_2
XFILLER_101_609 VGND VGND VPWR VPWR sky130_fd_sc_hd__decap_3
XFILLER_113_458 VGND VGND VPWR VPWR sky130_fd_sc_hd__fill_2
XFILLER_113_469 VGND VGND VPWR VPWR sky130_fd_sc_hd__decap_3
XFILLER_67_501 VGND VGND VPWR VPWR sky130_fd_sc_hd__decap_3
XTAP_TAPCELL_ROW_91_1561 VGND VPWR sky130_fd_sc_hd__tapvpwrvgnd_1
XTAP_TAPCELL_ROW_91_1572 VGND VPWR sky130_fd_sc_hd__tapvpwrvgnd_1
XFILLER_39_225 VGND VGND VPWR VPWR sky130_fd_sc_hd__fill_2
XFILLER_67_534 VGND VGND VPWR VPWR sky130_fd_sc_hd__decap_3
XFILLER_94_320 VGND VGND VPWR VPWR sky130_fd_sc_hd__fill_2
Xclkbuf_leaf_9_CLK clkload0/A VGND VGND VPWR VPWR _8483_/CLK sky130_fd_sc_hd__clkbuf_8
Xclkbuf_5_15__f_CLK clkbuf_4_7_0_CLK/X VGND VGND VPWR VPWR clkload5/A sky130_fd_sc_hd__clkbuf_16
XFILLER_54_217 VGND VGND VPWR VPWR sky130_fd_sc_hd__decap_3
XFILLER_55_729 VGND VGND VPWR VPWR sky130_fd_sc_hd__decap_3
XFILLER_82_526 VGND VGND VPWR VPWR sky130_fd_sc_hd__decap_3
X_7960_ _8780_/CLK _7960_/D fanout721/X VGND VGND VPWR VPWR _7960_/Q sky130_fd_sc_hd__dfrtp_2
XFILLER_63_740 VGND VGND VPWR VPWR sky130_fd_sc_hd__decap_3
XFILLER_82_548 VGND VGND VPWR VPWR sky130_fd_sc_hd__fill_1
X_7891_ _8427_/CLK _7891_/D load_slew655/X VGND VGND VPWR VPWR _7891_/Q sky130_fd_sc_hd__dfrtp_2
X_6911_ _6911_/A VGND VGND VPWR VPWR _8495_/D sky130_fd_sc_hd__buf_6
XFILLER_23_615 VGND VGND VPWR VPWR sky130_fd_sc_hd__fill_1
XFILLER_35_475 VGND VGND VPWR VPWR sky130_fd_sc_hd__decap_3
X_6842_ _6842_/A VGND VGND VPWR VPWR _8462_/D sky130_fd_sc_hd__buf_6
XFILLER_23_626 VGND VGND VPWR VPWR sky130_fd_sc_hd__decap_3
XFILLER_62_261 VGND VGND VPWR VPWR sky130_fd_sc_hd__fill_1
XFILLER_90_592 VGND VGND VPWR VPWR sky130_fd_sc_hd__decap_3
X_3985_ _7656_/Q _4634_/A2 _4622_/B1 _7575_/Q _4120_/A VGND VGND VPWR VPWR _3985_/X
+ sky130_fd_sc_hd__o221a_2
X_6773_ _6773_/A VGND VGND VPWR VPWR _8430_/D sky130_fd_sc_hd__buf_2
XFILLER_10_309 VGND VGND VPWR VPWR sky130_fd_sc_hd__decap_3
XFILLER_31_670 VGND VGND VPWR VPWR sky130_fd_sc_hd__fill_2
XPHY_EDGE_ROW_99_Left_235 VGND VGND VPWR VPWR sky130_fd_sc_hd__decap_3
X_8512_ _8593_/CLK _8512_/D load_slew712/X VGND VGND VPWR VPWR _8512_/Q sky130_fd_sc_hd__dfrtp_2
X_5724_ _7902_/Q _5031_/A _5742_/S VGND VGND VPWR VPWR _5725_/A sky130_fd_sc_hd__mux2_2
XFILLER_109_709 VGND VGND VPWR VPWR sky130_fd_sc_hd__decap_3
X_8443_ _8689_/CLK _8443_/D fanout553/X VGND VGND VPWR VPWR _8443_/Q sky130_fd_sc_hd__dfrtp_2
X_5655_ _5655_/A VGND VGND VPWR VPWR _7870_/D sky130_fd_sc_hd__buf_1
XTAP_TAPCELL_ROW_100_1690 VGND VPWR sky130_fd_sc_hd__tapvpwrvgnd_1
X_8374_ _8695_/CLK _8374_/D fanout747/X VGND VGND VPWR VPWR _8374_/Q sky130_fd_sc_hd__dfrtp_2
X_4606_ _4666_/A1 _4595_/X _4598_/X _4601_/X _4605_/X VGND VGND VPWR VPWR _4606_/X
+ sky130_fd_sc_hd__o32a_2
XFILLER_116_230 VGND VGND VPWR VPWR sky130_fd_sc_hd__decap_3
XFILLER_129_591 VGND VGND VPWR VPWR sky130_fd_sc_hd__decap_3
X_7325_ _7451_/S VGND VGND VPWR VPWR _7344_/S sky130_fd_sc_hd__clkbuf_2
X_5586_ _5586_/A VGND VGND VPWR VPWR _7837_/D sky130_fd_sc_hd__buf_1
XFILLER_117_797 VGND VGND VPWR VPWR sky130_fd_sc_hd__fill_1
XFILLER_132_701 VGND VGND VPWR VPWR sky130_fd_sc_hd__decap_3
X_4537_ _4526_/S _4532_/X _4534_/X _4536_/X VGND VGND VPWR VPWR _4537_/X sky130_fd_sc_hd__a22o_2
XFILLER_104_447 VGND VGND VPWR VPWR sky130_fd_sc_hd__decap_3
XFILLER_131_211 VGND VGND VPWR VPWR sky130_fd_sc_hd__decap_3
XFILLER_132_734 VGND VGND VPWR VPWR sky130_fd_sc_hd__decap_3
X_7256_ _7269_/A VGND VGND VPWR VPWR _7256_/X sky130_fd_sc_hd__clkbuf_1
X_4468_ _7781_/Q _7862_/Q _4497_/S VGND VGND VPWR VPWR _4468_/X sky130_fd_sc_hd__mux2_2
XFILLER_131_255 VGND VGND VPWR VPWR sky130_fd_sc_hd__decap_3
XFILLER_132_778 VGND VGND VPWR VPWR sky130_fd_sc_hd__decap_3
XFILLER_77_29 VGND VGND VPWR VPWR sky130_fd_sc_hd__decap_3
XFILLER_89_169 VGND VGND VPWR VPWR sky130_fd_sc_hd__decap_3
XTAP_TAPCELL_ROW_51_1000 VGND VPWR sky130_fd_sc_hd__tapvpwrvgnd_1
X_7187_ _7188_/A1 _4977_/X _7187_/A3 _7187_/B1 hold830/X VGND VGND VPWR VPWR _8628_/D
+ sky130_fd_sc_hd__a32o_2
X_6207_ _6312_/S VGND VGND VPWR VPWR _6226_/S sky130_fd_sc_hd__buf_6
XFILLER_112_480 VGND VGND VPWR VPWR sky130_fd_sc_hd__fill_1
XFILLER_131_299 VGND VGND VPWR VPWR sky130_fd_sc_hd__decap_3
XTAP_TAPCELL_ROW_51_1011 VGND VPWR sky130_fd_sc_hd__tapvpwrvgnd_1
X_6138_ _6138_/A VGND VGND VPWR VPWR _8133_/D sky130_fd_sc_hd__buf_1
X_4399_ _8018_/Q _4399_/A2 _3916_/B _7937_/Q _4444_/A1 VGND VGND VPWR VPWR _4399_/X
+ sky130_fd_sc_hd__o221a_2
XFILLER_100_631 VGND VGND VPWR VPWR sky130_fd_sc_hd__fill_1
XFILLER_133_24 VGND VGND VPWR VPWR sky130_fd_sc_hd__decap_3
XFILLER_133_57 VGND VGND VPWR VPWR sky130_fd_sc_hd__decap_3
XFILLER_58_567 VGND VGND VPWR VPWR sky130_fd_sc_hd__decap_3
XTAP_TAPCELL_ROW_5_357 VGND VPWR sky130_fd_sc_hd__tapvpwrvgnd_1
XTAP_TAPCELL_ROW_5_368 VGND VPWR sky130_fd_sc_hd__tapvpwrvgnd_1
Xhold1010 _7889_/Q VGND VGND VPWR VPWR _5696_/A0 sky130_fd_sc_hd__dlygate4sd3_1
Xhold1021 _7522_/Q VGND VGND VPWR VPWR _4796_/A1 sky130_fd_sc_hd__dlygate4sd3_1
Xhold1032 _7534_/Q VGND VGND VPWR VPWR _4846_/A1 sky130_fd_sc_hd__dlygate4sd3_1
Xload_slew290 fanout289/X VGND VGND VPWR VPWR _4526_/S sky130_fd_sc_hd__buf_4
XFILLER_39_781 VGND VGND VPWR VPWR sky130_fd_sc_hd__decap_3
XFILLER_58_589 VGND VGND VPWR VPWR sky130_fd_sc_hd__decap_3
XFILLER_85_386 VGND VGND VPWR VPWR sky130_fd_sc_hd__decap_3
Xhold1043 _7535_/Q VGND VGND VPWR VPWR _4850_/A1 sky130_fd_sc_hd__dlygate4sd3_1
Xhold1054 _8730_/Q VGND VGND VPWR VPWR _7342_/A0 sky130_fd_sc_hd__dlygate4sd3_1
Xhold1065 _8589_/Q VGND VGND VPWR VPWR _7109_/A1 sky130_fd_sc_hd__dlygate4sd3_1
X_6069_ _6069_/A VGND VGND VPWR VPWR _8100_/D sky130_fd_sc_hd__buf_1
XFILLER_73_559 VGND VGND VPWR VPWR sky130_fd_sc_hd__fill_1
XFILLER_26_44 VGND VGND VPWR VPWR sky130_fd_sc_hd__decap_3
XFILLER_54_773 VGND VGND VPWR VPWR sky130_fd_sc_hd__fill_1
XTAP_TAPCELL_ROW_44_908 VGND VPWR sky130_fd_sc_hd__tapvpwrvgnd_1
XFILLER_14_637 VGND VGND VPWR VPWR sky130_fd_sc_hd__fill_1
XFILLER_26_77 VGND VGND VPWR VPWR sky130_fd_sc_hd__decap_3
XFILLER_54_795 VGND VGND VPWR VPWR sky130_fd_sc_hd__fill_1
XFILLER_41_434 VGND VGND VPWR VPWR sky130_fd_sc_hd__decap_3
XTAP_TAPCELL_ROW_24_632 VGND VPWR sky130_fd_sc_hd__tapvpwrvgnd_1
XFILLER_42_32 VGND VGND VPWR VPWR sky130_fd_sc_hd__fill_2
XFILLER_42_43 VGND VGND VPWR VPWR sky130_fd_sc_hd__decap_3
XTAP_TAPCELL_ROW_62_1162 VGND VPWR sky130_fd_sc_hd__tapvpwrvgnd_1
XFILLER_22_692 VGND VGND VPWR VPWR sky130_fd_sc_hd__decap_3
XFILLER_127_517 VGND VGND VPWR VPWR sky130_fd_sc_hd__decap_3
XFILLER_5_302 VGND VGND VPWR VPWR sky130_fd_sc_hd__fill_2
XTAP_TAPCELL_ROW_118_1940 VGND VPWR sky130_fd_sc_hd__tapvpwrvgnd_1
XTAP_TAPCELL_ROW_118_1951 VGND VPWR sky130_fd_sc_hd__tapvpwrvgnd_1
XFILLER_135_561 VGND VGND VPWR VPWR sky130_fd_sc_hd__decap_3
XFILLER_122_200 VGND VGND VPWR VPWR sky130_fd_sc_hd__fill_1
XFILLER_123_756 VGND VGND VPWR VPWR sky130_fd_sc_hd__decap_3
XFILLER_135_583 VGND VGND VPWR VPWR sky130_fd_sc_hd__decap_3
XFILLER_3_15 VGND VGND VPWR VPWR sky130_fd_sc_hd__decap_3
XFILLER_68_309 VGND VGND VPWR VPWR sky130_fd_sc_hd__fill_1
XFILLER_110_417 VGND VGND VPWR VPWR sky130_fd_sc_hd__decap_3
XFILLER_3_48 VGND VGND VPWR VPWR sky130_fd_sc_hd__decap_3
XFILLER_49_501 VGND VGND VPWR VPWR sky130_fd_sc_hd__decap_3
XFILLER_95_128 VGND VGND VPWR VPWR sky130_fd_sc_hd__fill_1
XFILLER_95_139 VGND VGND VPWR VPWR sky130_fd_sc_hd__decap_3
XFILLER_49_534 VGND VGND VPWR VPWR sky130_fd_sc_hd__decap_3
XFILLER_49_589 VGND VGND VPWR VPWR sky130_fd_sc_hd__decap_3
XFILLER_64_515 VGND VGND VPWR VPWR sky130_fd_sc_hd__decap_3
XFILLER_123_90 VGND VGND VPWR VPWR sky130_fd_sc_hd__decap_3
XFILLER_44_250 VGND VGND VPWR VPWR sky130_fd_sc_hd__fill_2
XFILLER_51_209 VGND VGND VPWR VPWR sky130_fd_sc_hd__fill_2
XFILLER_17_497 VGND VGND VPWR VPWR sky130_fd_sc_hd__decap_3
XFILLER_91_389 VGND VGND VPWR VPWR sky130_fd_sc_hd__decap_3
XFILLER_32_489 VGND VGND VPWR VPWR sky130_fd_sc_hd__decap_3
X_3770_ _8703_/Q _8784_/Q _3778_/S VGND VGND VPWR VPWR _3770_/X sky130_fd_sc_hd__mux2_2
XFILLER_9_641 VGND VGND VPWR VPWR sky130_fd_sc_hd__decap_3
XFILLER_118_539 VGND VGND VPWR VPWR sky130_fd_sc_hd__decap_3
XFILLER_12_191 VGND VGND VPWR VPWR sky130_fd_sc_hd__fill_2
XFILLER_9_685 VGND VGND VPWR VPWR sky130_fd_sc_hd__decap_3
XPHY_EDGE_ROW_132_Right_132 VGND VGND VPWR VPWR sky130_fd_sc_hd__decap_3
X_5440_ _7769_/Q _4810_/A _5440_/S VGND VGND VPWR VPWR _5441_/A sky130_fd_sc_hd__mux2_2
XFILLER_8_184 VGND VGND VPWR VPWR sky130_fd_sc_hd__fill_2
XFILLER_8_195 VGND VGND VPWR VPWR sky130_fd_sc_hd__fill_1
XTAP_TAPCELL_ROW_93_1601 VGND VPWR sky130_fd_sc_hd__tapvpwrvgnd_1
XFILLER_114_701 VGND VGND VPWR VPWR sky130_fd_sc_hd__fill_2
X_5371_ _7736_/Q _5014_/A _5377_/S VGND VGND VPWR VPWR _5372_/A sky130_fd_sc_hd__mux2_2
XFILLER_113_222 VGND VGND VPWR VPWR sky130_fd_sc_hd__fill_2
XFILLER_114_745 VGND VGND VPWR VPWR sky130_fd_sc_hd__decap_3
XFILLER_126_583 VGND VGND VPWR VPWR sky130_fd_sc_hd__decap_3
X_8090_ _8739_/CLK _8090_/D load_slew509/X VGND VGND VPWR VPWR _8090_/Q sky130_fd_sc_hd__dfrtp_2
X_7110_ _7110_/A VGND VGND VPWR VPWR _8589_/D sky130_fd_sc_hd__buf_2
X_4322_ _4681_/A _4320_/X _4321_/X VGND VGND VPWR VPWR _4322_/X sky130_fd_sc_hd__o21a_2
X_7041_ _7041_/A VGND VGND VPWR VPWR _8556_/D sky130_fd_sc_hd__buf_2
X_4253_ _4605_/A1 _4250_/X _4252_/X _4336_/C1 VGND VGND VPWR VPWR _4253_/X sky130_fd_sc_hd__o211a_2
XFILLER_113_277 VGND VGND VPWR VPWR sky130_fd_sc_hd__decap_3
XFILLER_28_707 VGND VGND VPWR VPWR sky130_fd_sc_hd__decap_3
XFILLER_67_331 VGND VGND VPWR VPWR sky130_fd_sc_hd__decap_3
XFILLER_95_651 VGND VGND VPWR VPWR sky130_fd_sc_hd__decap_3
X_4184_ _4198_/A _4184_/B VGND VGND VPWR VPWR _4184_/X sky130_fd_sc_hd__or2_2
XFILLER_95_684 VGND VGND VPWR VPWR sky130_fd_sc_hd__decap_3
XTAP_TAPCELL_ROW_2_316 VGND VPWR sky130_fd_sc_hd__tapvpwrvgnd_1
XTAP_TAPCELL_ROW_2_327 VGND VPWR sky130_fd_sc_hd__tapvpwrvgnd_1
XFILLER_103_49 VGND VGND VPWR VPWR sky130_fd_sc_hd__decap_3
XFILLER_27_239 VGND VGND VPWR VPWR sky130_fd_sc_hd__fill_1
XFILLER_55_559 VGND VGND VPWR VPWR sky130_fd_sc_hd__fill_1
XFILLER_94_194 VGND VGND VPWR VPWR sky130_fd_sc_hd__fill_2
X_7943_ _8765_/CLK _7943_/D load_slew582/X VGND VGND VPWR VPWR _7943_/Q sky130_fd_sc_hd__dfrtp_2
XFILLER_23_423 VGND VGND VPWR VPWR sky130_fd_sc_hd__decap_3
XFILLER_35_250 VGND VGND VPWR VPWR sky130_fd_sc_hd__decap_3
XFILLER_51_721 VGND VGND VPWR VPWR sky130_fd_sc_hd__decap_3
XFILLER_51_732 VGND VGND VPWR VPWR sky130_fd_sc_hd__fill_1
X_7874_ _8775_/CLK _7874_/D load_slew727/X VGND VGND VPWR VPWR _7874_/Q sky130_fd_sc_hd__dfrtp_2
X_6825_ _6825_/A VGND VGND VPWR VPWR _8455_/D sky130_fd_sc_hd__buf_2
XFILLER_11_607 VGND VGND VPWR VPWR sky130_fd_sc_hd__decap_3
XFILLER_11_629 VGND VGND VPWR VPWR sky130_fd_sc_hd__decap_3
XFILLER_50_253 VGND VGND VPWR VPWR sky130_fd_sc_hd__decap_3
X_3968_ _3958_/A _3966_/X _3967_/X VGND VGND VPWR VPWR _3968_/X sky130_fd_sc_hd__o21a_2
X_6756_ _6756_/A VGND VGND VPWR VPWR _8422_/D sky130_fd_sc_hd__buf_2
X_5707_ _7894_/Q _4999_/A _5721_/S VGND VGND VPWR VPWR _5708_/A sky130_fd_sc_hd__mux2_2
XFILLER_109_517 VGND VGND VPWR VPWR sky130_fd_sc_hd__fill_2
XFILLER_12_24 VGND VGND VPWR VPWR sky130_fd_sc_hd__decap_3
XFILLER_12_35 VGND VGND VPWR VPWR sky130_fd_sc_hd__decap_3
X_3899_ _8388_/Q _8469_/Q _8550_/Q _8631_/Q _4007_/S _3984_/A VGND VGND VPWR VPWR
+ _3899_/X sky130_fd_sc_hd__mux4_2
X_6687_ _6687_/A VGND VGND VPWR VPWR _8389_/D sky130_fd_sc_hd__buf_2
XFILLER_128_24 VGND VGND VPWR VPWR sky130_fd_sc_hd__decap_3
XFILLER_128_35 VGND VGND VPWR VPWR sky130_fd_sc_hd__decap_3
XFILLER_12_68 VGND VGND VPWR VPWR sky130_fd_sc_hd__decap_3
X_8426_ _8669_/CLK _8426_/D load_slew636/X VGND VGND VPWR VPWR _8426_/Q sky130_fd_sc_hd__dfrtp_2
X_5638_ _7862_/Q _4861_/A _5654_/S VGND VGND VPWR VPWR _5639_/A sky130_fd_sc_hd__mux2_2
XFILLER_124_509 VGND VGND VPWR VPWR sky130_fd_sc_hd__decap_3
XFILLER_128_68 VGND VGND VPWR VPWR sky130_fd_sc_hd__decap_3
XTAP_TAPCELL_ROW_131_2126 VGND VPWR sky130_fd_sc_hd__tapvpwrvgnd_1
X_8357_ _8798_/CLK _8357_/D fanout575/X VGND VGND VPWR VPWR _8357_/Q sky130_fd_sc_hd__dfrtp_2
X_5569_ _5569_/A VGND VGND VPWR VPWR _7829_/D sky130_fd_sc_hd__buf_1
XFILLER_105_723 VGND VGND VPWR VPWR sky130_fd_sc_hd__decap_3
XFILLER_132_531 VGND VGND VPWR VPWR sky130_fd_sc_hd__fill_1
X_7308_ _7308_/A VGND VGND VPWR VPWR _8713_/D sky130_fd_sc_hd__buf_1
XFILLER_120_704 VGND VGND VPWR VPWR sky130_fd_sc_hd__decap_3
XFILLER_132_542 VGND VGND VPWR VPWR sky130_fd_sc_hd__decap_3
XTAP_TAPCELL_ROW_113_1870 VGND VPWR sky130_fd_sc_hd__tapvpwrvgnd_1
X_8288_ _8757_/CLK _8288_/D load_slew742/X VGND VGND VPWR VPWR _8288_/Q sky130_fd_sc_hd__dfrtp_2
XFILLER_104_277 VGND VGND VPWR VPWR sky130_fd_sc_hd__decap_3
XFILLER_132_575 VGND VGND VPWR VPWR sky130_fd_sc_hd__decap_3
XTAP_TAPCELL_ROW_113_1881 VGND VPWR sky130_fd_sc_hd__tapvpwrvgnd_1
Xfanout620 fanout624/X VGND VGND VPWR VPWR fanout620/X sky130_fd_sc_hd__clkdlybuf4s25_1
X_7239_ _7239_/A1 _4803_/X _7230_/X _7231_/X hold813/X VGND VGND VPWR VPWR _8668_/D
+ sky130_fd_sc_hd__a32o_2
Xfanout653 fanout685/X VGND VGND VPWR VPWR fanout653/X sky130_fd_sc_hd__clkdlybuf4s25_1
Xfanout664 fanout665/X VGND VGND VPWR VPWR fanout664/X sky130_fd_sc_hd__clkdlybuf4s25_1
Xfanout675 fanout677/X VGND VGND VPWR VPWR fanout675/X sky130_fd_sc_hd__clkdlybuf4s25_1
XFILLER_100_461 VGND VGND VPWR VPWR sky130_fd_sc_hd__fill_2
XFILLER_19_729 VGND VGND VPWR VPWR sky130_fd_sc_hd__decap_3
XFILLER_37_32 VGND VGND VPWR VPWR sky130_fd_sc_hd__decap_3
XFILLER_58_375 VGND VGND VPWR VPWR sky130_fd_sc_hd__decap_3
XTAP_TAPCELL_ROW_129_2099 VGND VPWR sky130_fd_sc_hd__tapvpwrvgnd_1
XTAP_TAPCELL_ROW_29_702 VGND VPWR sky130_fd_sc_hd__tapvpwrvgnd_1
Xfanout686 fanout694/X VGND VGND VPWR VPWR fanout686/X sky130_fd_sc_hd__clkdlybuf4s25_1
Xfanout697 fanout702/X VGND VGND VPWR VPWR fanout697/X sky130_fd_sc_hd__clkdlybuf4s25_1
XFILLER_100_472 VGND VGND VPWR VPWR sky130_fd_sc_hd__decap_3
XFILLER_37_76 VGND VGND VPWR VPWR sky130_fd_sc_hd__decap_3
XFILLER_73_367 VGND VGND VPWR VPWR sky130_fd_sc_hd__fill_1
XFILLER_42_710 VGND VGND VPWR VPWR sky130_fd_sc_hd__decap_3
XFILLER_73_389 VGND VGND VPWR VPWR sky130_fd_sc_hd__decap_3
XFILLER_26_283 VGND VGND VPWR VPWR sky130_fd_sc_hd__fill_1
XFILLER_53_31 VGND VGND VPWR VPWR sky130_fd_sc_hd__fill_1
XFILLER_53_64 VGND VGND VPWR VPWR sky130_fd_sc_hd__decap_3
XFILLER_10_640 VGND VGND VPWR VPWR sky130_fd_sc_hd__decap_3
XFILLER_10_651 VGND VGND VPWR VPWR sky130_fd_sc_hd__decap_3
XFILLER_10_684 VGND VGND VPWR VPWR sky130_fd_sc_hd__decap_3
XFILLER_5_110 VGND VGND VPWR VPWR sky130_fd_sc_hd__fill_2
XFILLER_6_622 VGND VGND VPWR VPWR sky130_fd_sc_hd__decap_3
XFILLER_5_143 VGND VGND VPWR VPWR sky130_fd_sc_hd__decap_3
XFILLER_6_666 VGND VGND VPWR VPWR sky130_fd_sc_hd__decap_3
XFILLER_5_165 VGND VGND VPWR VPWR sky130_fd_sc_hd__decap_3
XFILLER_6_699 VGND VGND VPWR VPWR sky130_fd_sc_hd__fill_1
XTAP_TAPCELL_ROW_75_1342 VGND VPWR sky130_fd_sc_hd__tapvpwrvgnd_1
XFILLER_123_564 VGND VGND VPWR VPWR sky130_fd_sc_hd__fill_1
XFILLER_78_50 VGND VGND VPWR VPWR sky130_fd_sc_hd__fill_1
XFILLER_123_597 VGND VGND VPWR VPWR sky130_fd_sc_hd__decap_3
XFILLER_68_117 VGND VGND VPWR VPWR sky130_fd_sc_hd__decap_3
XFILLER_78_72 VGND VGND VPWR VPWR sky130_fd_sc_hd__decap_3
XFILLER_1_393 VGND VGND VPWR VPWR sky130_fd_sc_hd__fill_2
XFILLER_49_320 VGND VGND VPWR VPWR sky130_fd_sc_hd__decap_3
XFILLER_77_673 VGND VGND VPWR VPWR sky130_fd_sc_hd__fill_1
XFILLER_77_684 VGND VGND VPWR VPWR sky130_fd_sc_hd__decap_3
XFILLER_64_312 VGND VGND VPWR VPWR sky130_fd_sc_hd__fill_2
XFILLER_18_751 VGND VGND VPWR VPWR sky130_fd_sc_hd__decap_3
XFILLER_18_762 VGND VGND VPWR VPWR sky130_fd_sc_hd__decap_3
XFILLER_37_559 VGND VGND VPWR VPWR sky130_fd_sc_hd__fill_1
XFILLER_91_142 VGND VGND VPWR VPWR sky130_fd_sc_hd__decap_3
XFILLER_17_272 VGND VGND VPWR VPWR sky130_fd_sc_hd__decap_3
XFILLER_91_175 VGND VGND VPWR VPWR sky130_fd_sc_hd__decap_3
X_4940_ _4940_/A _4944_/B VGND VGND VPWR VPWR _4941_/A sky130_fd_sc_hd__and2_2
XFILLER_45_592 VGND VGND VPWR VPWR sky130_fd_sc_hd__decap_3
XTAP_TAPCELL_ROW_86_1493 VGND VPWR sky130_fd_sc_hd__tapvpwrvgnd_1
X_4871_ _4871_/A VGND VGND VPWR VPWR _4871_/X sky130_fd_sc_hd__buf_1
XFILLER_32_253 VGND VGND VPWR VPWR sky130_fd_sc_hd__fill_2
X_3822_ _3827_/A1 _3802_/X _3809_/X _3813_/X _3821_/X VGND VGND VPWR VPWR _3822_/X
+ sky130_fd_sc_hd__o32a_2
X_7590_ _8410_/CLK _7590_/D load_slew524/X VGND VGND VPWR VPWR _7590_/Q sky130_fd_sc_hd__dfrtp_2
X_6610_ _4849_/X _8355_/Q _6612_/S VGND VGND VPWR VPWR _6611_/A sky130_fd_sc_hd__mux2_2
XFILLER_60_595 VGND VGND VPWR VPWR sky130_fd_sc_hd__decap_3
X_6541_ _4711_/X _8322_/Q _6549_/S VGND VGND VPWR VPWR _6542_/A sky130_fd_sc_hd__mux2_2
XFILLER_118_303 VGND VGND VPWR VPWR sky130_fd_sc_hd__decap_3
X_3753_ _3758_/A VGND VGND VPWR VPWR _4465_/A sky130_fd_sc_hd__clkbuf_2
XFILLER_9_482 VGND VGND VPWR VPWR sky130_fd_sc_hd__decap_3
X_6472_ _4917_/X _8290_/Q _6482_/S VGND VGND VPWR VPWR _6473_/A sky130_fd_sc_hd__mux2_2
XFILLER_106_509 VGND VGND VPWR VPWR sky130_fd_sc_hd__decap_3
XFILLER_133_317 VGND VGND VPWR VPWR sky130_fd_sc_hd__decap_3
X_8211_ _8776_/CLK _8211_/D load_slew731/X VGND VGND VPWR VPWR _8211_/Q sky130_fd_sc_hd__dfrtp_2
X_5423_ _5423_/A VGND VGND VPWR VPWR _7760_/D sky130_fd_sc_hd__buf_1
X_8142_ _8547_/CLK _8142_/D load_slew673/X VGND VGND VPWR VPWR _8142_/Q sky130_fd_sc_hd__dfrtp_2
X_5354_ _7728_/Q _4980_/A _5356_/S VGND VGND VPWR VPWR _5355_/A sky130_fd_sc_hd__mux2_2
XFILLER_102_704 VGND VGND VPWR VPWR sky130_fd_sc_hd__fill_1
XFILLER_99_242 VGND VGND VPWR VPWR sky130_fd_sc_hd__fill_1
X_4305_ _8425_/Q _8506_/Q _4305_/S VGND VGND VPWR VPWR _4305_/X sky130_fd_sc_hd__mux2_2
XFILLER_102_726 VGND VGND VPWR VPWR sky130_fd_sc_hd__fill_2
XFILLER_87_404 VGND VGND VPWR VPWR sky130_fd_sc_hd__fill_1
XFILLER_87_426 VGND VGND VPWR VPWR sky130_fd_sc_hd__decap_3
X_8073_ _8721_/CLK _8073_/D load_slew587/X VGND VGND VPWR VPWR _8073_/Q sky130_fd_sc_hd__dfrtp_2
X_5285_ _7696_/Q _4845_/X _5289_/S VGND VGND VPWR VPWR _5286_/A sky130_fd_sc_hd__mux2_2
XFILLER_101_225 VGND VGND VPWR VPWR sky130_fd_sc_hd__decap_3
XFILLER_114_15 VGND VGND VPWR VPWR sky130_fd_sc_hd__decap_3
XFILLER_4_80 VGND VGND VPWR VPWR sky130_fd_sc_hd__decap_3
XFILLER_4_91 VGND VGND VPWR VPWR sky130_fd_sc_hd__decap_3
X_7024_ _7024_/A VGND VGND VPWR VPWR _8548_/D sky130_fd_sc_hd__buf_2
X_4236_ _8419_/Q _8500_/Q _8581_/Q _8662_/Q _4266_/S _4261_/A VGND VGND VPWR VPWR
+ _4236_/X sky130_fd_sc_hd__mux4_2
XFILLER_83_610 VGND VGND VPWR VPWR sky130_fd_sc_hd__decap_3
X_4167_ _4030_/S _4166_/X _3848_/X VGND VGND VPWR VPWR _4167_/X sky130_fd_sc_hd__o21a_2
XFILLER_95_470 VGND VGND VPWR VPWR sky130_fd_sc_hd__decap_3
XFILLER_28_559 VGND VGND VPWR VPWR sky130_fd_sc_hd__decap_3
X_4098_ _7748_/Q _7829_/Q _7910_/Q _7991_/Q _4098_/S0 _4036_/A VGND VGND VPWR VPWR
+ _4098_/X sky130_fd_sc_hd__mux4_2
XFILLER_24_710 VGND VGND VPWR VPWR sky130_fd_sc_hd__fill_1
XFILLER_43_529 VGND VGND VPWR VPWR sky130_fd_sc_hd__decap_3
XFILLER_70_326 VGND VGND VPWR VPWR sky130_fd_sc_hd__decap_3
XFILLER_82_164 VGND VGND VPWR VPWR sky130_fd_sc_hd__fill_1
XFILLER_82_186 VGND VGND VPWR VPWR sky130_fd_sc_hd__decap_3
X_7926_ _8662_/CLK _7926_/D load_slew621/X VGND VGND VPWR VPWR _7926_/Q sky130_fd_sc_hd__dfrtp_2
XFILLER_130_47 VGND VGND VPWR VPWR sky130_fd_sc_hd__decap_3
XFILLER_23_231 VGND VGND VPWR VPWR sky130_fd_sc_hd__decap_3
XFILLER_24_743 VGND VGND VPWR VPWR sky130_fd_sc_hd__fill_2
XFILLER_24_754 VGND VGND VPWR VPWR sky130_fd_sc_hd__fill_2
XFILLER_82_197 VGND VGND VPWR VPWR sky130_fd_sc_hd__decap_3
X_7857_ _8019_/CLK _7857_/D load_slew714/X VGND VGND VPWR VPWR _7857_/Q sky130_fd_sc_hd__dfrtp_2
XFILLER_11_415 VGND VGND VPWR VPWR sky130_fd_sc_hd__decap_3
XFILLER_90_29 VGND VGND VPWR VPWR sky130_fd_sc_hd__decap_3
XTAP_TAPCELL_ROW_34_771 VGND VPWR sky130_fd_sc_hd__tapvpwrvgnd_1
X_6808_ _6808_/A VGND VGND VPWR VPWR _8447_/D sky130_fd_sc_hd__buf_2
XFILLER_23_23 VGND VGND VPWR VPWR sky130_fd_sc_hd__decap_3
X_7788_ _8608_/CLK _7788_/D wire552/X VGND VGND VPWR VPWR _7788_/Q sky130_fd_sc_hd__dfrtp_2
XFILLER_135_6 VGND VGND VPWR VPWR sky130_fd_sc_hd__decap_3
XFILLER_23_78 VGND VGND VPWR VPWR sky130_fd_sc_hd__decap_3
X_6739_ _6739_/A VGND VGND VPWR VPWR _8414_/D sky130_fd_sc_hd__buf_2
XFILLER_109_358 VGND VGND VPWR VPWR sky130_fd_sc_hd__decap_3
XFILLER_99_49 VGND VGND VPWR VPWR sky130_fd_sc_hd__decap_3
X_8409_ _8733_/CLK _8409_/D load_slew486/X VGND VGND VPWR VPWR _8409_/Q sky130_fd_sc_hd__dfrtp_2
XFILLER_2_124 VGND VGND VPWR VPWR sky130_fd_sc_hd__decap_3
XFILLER_3_647 VGND VGND VPWR VPWR sky130_fd_sc_hd__decap_3
XFILLER_105_564 VGND VGND VPWR VPWR sky130_fd_sc_hd__decap_3
XFILLER_132_361 VGND VGND VPWR VPWR sky130_fd_sc_hd__decap_3
XTAP_TAPCELL_ROW_57_1094 VGND VPWR sky130_fd_sc_hd__tapvpwrvgnd_1
XFILLER_132_394 VGND VGND VPWR VPWR sky130_fd_sc_hd__decap_3
XFILLER_78_448 VGND VGND VPWR VPWR sky130_fd_sc_hd__fill_1
XFILLER_58_150 VGND VGND VPWR VPWR sky130_fd_sc_hd__decap_3
XFILLER_59_673 VGND VGND VPWR VPWR sky130_fd_sc_hd__decap_3
XFILLER_93_418 VGND VGND VPWR VPWR sky130_fd_sc_hd__decap_3
XTAP_TAPCELL_ROW_70_1272 VGND VPWR sky130_fd_sc_hd__tapvpwrvgnd_1
Xfanout461 _4449_/S VGND VGND VPWR VPWR _4414_/S sky130_fd_sc_hd__clkdlybuf4s25_1
Xfanout472 fanout474/X VGND VGND VPWR VPWR fanout472/X sky130_fd_sc_hd__clkdlybuf4s25_1
Xfanout483 fanout487/X VGND VGND VPWR VPWR fanout483/X sky130_fd_sc_hd__clkdlybuf4s25_1
XFILLER_46_301 VGND VGND VPWR VPWR sky130_fd_sc_hd__decap_3
XFILLER_46_312 VGND VGND VPWR VPWR sky130_fd_sc_hd__fill_1
XFILLER_0_27 VGND VGND VPWR VPWR sky130_fd_sc_hd__fill_1
XFILLER_0_38 VGND VGND VPWR VPWR sky130_fd_sc_hd__decap_3
XFILLER_104_70 VGND VGND VPWR VPWR sky130_fd_sc_hd__decap_3
XFILLER_58_194 VGND VGND VPWR VPWR sky130_fd_sc_hd__fill_2
XFILLER_61_326 VGND VGND VPWR VPWR sky130_fd_sc_hd__decap_3
XFILLER_61_337 VGND VGND VPWR VPWR sky130_fd_sc_hd__decap_3
XFILLER_64_85 VGND VGND VPWR VPWR sky130_fd_sc_hd__decap_3
XFILLER_9_36 VGND VGND VPWR VPWR sky130_fd_sc_hd__decap_3
XFILLER_14_286 VGND VGND VPWR VPWR sky130_fd_sc_hd__fill_2
XFILLER_30_757 VGND VGND VPWR VPWR sky130_fd_sc_hd__fill_1
XFILLER_42_584 VGND VGND VPWR VPWR sky130_fd_sc_hd__decap_3
XFILLER_9_69 VGND VGND VPWR VPWR sky130_fd_sc_hd__decap_3
XFILLER_128_601 VGND VGND VPWR VPWR sky130_fd_sc_hd__decap_3
XTAP_TAPCELL_ROW_12_454 VGND VPWR sky130_fd_sc_hd__tapvpwrvgnd_1
XFILLER_10_470 VGND VGND VPWR VPWR sky130_fd_sc_hd__decap_3
XFILLER_127_111 VGND VGND VPWR VPWR sky130_fd_sc_hd__fill_1
XFILLER_127_122 VGND VGND VPWR VPWR sky130_fd_sc_hd__decap_3
XFILLER_128_634 VGND VGND VPWR VPWR sky130_fd_sc_hd__decap_3
XFILLER_128_645 VGND VGND VPWR VPWR sky130_fd_sc_hd__decap_3
XTAP_TAPCELL_ROW_12_465 VGND VPWR sky130_fd_sc_hd__tapvpwrvgnd_1
XFILLER_115_306 VGND VGND VPWR VPWR sky130_fd_sc_hd__decap_3
XFILLER_128_678 VGND VGND VPWR VPWR sky130_fd_sc_hd__decap_3
Xhold909 _8648_/Q VGND VGND VPWR VPWR hold909/X sky130_fd_sc_hd__dlygate4sd3_1
XFILLER_50_6 VGND VGND VPWR VPWR sky130_fd_sc_hd__fill_1
XFILLER_130_309 VGND VGND VPWR VPWR sky130_fd_sc_hd__decap_3
XFILLER_111_523 VGND VGND VPWR VPWR sky130_fd_sc_hd__fill_1
XFILLER_96_245 VGND VGND VPWR VPWR sky130_fd_sc_hd__decap_3
X_5070_ _4761_/X _7595_/Q _5074_/S VGND VGND VPWR VPWR _5071_/A sky130_fd_sc_hd__mux2_2
XFILLER_29_3 VGND VGND VPWR VPWR sky130_fd_sc_hd__decap_3
XFILLER_56_109 VGND VGND VPWR VPWR sky130_fd_sc_hd__fill_1
XFILLER_96_278 VGND VGND VPWR VPWR sky130_fd_sc_hd__decap_3
XPHY_EDGE_ROW_63_Left_199 VGND VGND VPWR VPWR sky130_fd_sc_hd__decap_3
X_4021_ _4019_/X _4020_/X _4514_/S VGND VGND VPWR VPWR _4021_/X sky130_fd_sc_hd__mux2_2
XFILLER_49_183 VGND VGND VPWR VPWR sky130_fd_sc_hd__decap_3
XTAP_TAPCELL_ROW_88_1522 VGND VPWR sky130_fd_sc_hd__tapvpwrvgnd_1
XFILLER_65_676 VGND VGND VPWR VPWR sky130_fd_sc_hd__fill_2
XFILLER_80_624 VGND VGND VPWR VPWR sky130_fd_sc_hd__fill_1
XFILLER_80_635 VGND VGND VPWR VPWR sky130_fd_sc_hd__decap_3
X_8760_ _8760_/CLK _8760_/D load_slew718/X VGND VGND VPWR VPWR _8760_/Q sky130_fd_sc_hd__dfrtp_2
X_5972_ _8054_/Q input3/X _5990_/S VGND VGND VPWR VPWR _5973_/A sky130_fd_sc_hd__mux2_2
XFILLER_18_592 VGND VGND VPWR VPWR sky130_fd_sc_hd__decap_3
XFILLER_52_337 VGND VGND VPWR VPWR sky130_fd_sc_hd__decap_3
XFILLER_64_197 VGND VGND VPWR VPWR sky130_fd_sc_hd__decap_3
X_7711_ _8450_/CLK _7711_/D load_slew742/X VGND VGND VPWR VPWR _7711_/Q sky130_fd_sc_hd__dfrtp_2
X_4923_ _4923_/A VGND VGND VPWR VPWR _7552_/D sky130_fd_sc_hd__buf_1
X_8691_ _8697_/CLK _8691_/D fanout736/X VGND VGND VPWR VPWR _8691_/Q sky130_fd_sc_hd__dfrtp_2
XFILLER_21_746 VGND VGND VPWR VPWR sky130_fd_sc_hd__decap_3
XFILLER_33_595 VGND VGND VPWR VPWR sky130_fd_sc_hd__fill_1
X_7642_ _8624_/CLK _7642_/D wire669/X VGND VGND VPWR VPWR _7642_/Q sky130_fd_sc_hd__dfrtp_2
X_4854_ _4853_/X _4854_/A1 _4862_/S VGND VGND VPWR VPWR _4855_/A sky130_fd_sc_hd__mux2_2
XFILLER_20_256 VGND VGND VPWR VPWR sky130_fd_sc_hd__decap_3
XFILLER_21_779 VGND VGND VPWR VPWR sky130_fd_sc_hd__decap_3
XTAP_TAPCELL_ROW_31_730 VGND VPWR sky130_fd_sc_hd__tapvpwrvgnd_1
X_3805_ _3805_/A VGND VGND VPWR VPWR _3805_/X sky130_fd_sc_hd__clkbuf_2
X_7573_ _8798_/CLK _7573_/D wire600/X VGND VGND VPWR VPWR _7573_/Q sky130_fd_sc_hd__dfrtp_2
X_4785_ _4785_/A VGND VGND VPWR VPWR _7519_/D sky130_fd_sc_hd__buf_1
XFILLER_118_100 VGND VGND VPWR VPWR sky130_fd_sc_hd__decap_3
XFILLER_119_623 VGND VGND VPWR VPWR sky130_fd_sc_hd__fill_2
X_3736_ _8378_/Q _8459_/Q _8540_/Q _8621_/Q _3747_/S _3825_/A VGND VGND VPWR VPWR
+ _3736_/X sky130_fd_sc_hd__mux4_2
X_6524_ _5019_/X _8314_/Q _6528_/S VGND VGND VPWR VPWR _6525_/A sky130_fd_sc_hd__mux2_2
XFILLER_109_37 VGND VGND VPWR VPWR sky130_fd_sc_hd__decap_3
XFILLER_119_667 VGND VGND VPWR VPWR sky130_fd_sc_hd__decap_3
XFILLER_134_604 VGND VGND VPWR VPWR sky130_fd_sc_hd__decap_3
XTAP_TAPCELL_ROW_99_1673 VGND VPWR sky130_fd_sc_hd__tapvpwrvgnd_1
XTAP_TAPCELL_ROW_99_1684 VGND VPWR sky130_fd_sc_hd__tapvpwrvgnd_1
XFILLER_133_125 VGND VGND VPWR VPWR sky130_fd_sc_hd__decap_3
XFILLER_134_626 VGND VGND VPWR VPWR sky130_fd_sc_hd__decap_3
XFILLER_134_648 VGND VGND VPWR VPWR sky130_fd_sc_hd__decap_3
Xclkload60 _8621_/CLK VGND VGND VPWR VPWR clkload60/X sky130_fd_sc_hd__clkbuf_8
Xclkload71 _8761_/CLK VGND VGND VPWR VPWR clkload71/Y sky130_fd_sc_hd__bufinv_16
X_6455_ _4883_/X _8282_/Q _6461_/S VGND VGND VPWR VPWR _6456_/A sky130_fd_sc_hd__mux2_2
XFILLER_133_158 VGND VGND VPWR VPWR sky130_fd_sc_hd__decap_3
X_6386_ _4745_/X _8249_/Q _6398_/S VGND VGND VPWR VPWR _6387_/A sky130_fd_sc_hd__mux2_2
X_5406_ _5406_/A VGND VGND VPWR VPWR _7752_/D sky130_fd_sc_hd__buf_1
XFILLER_114_361 VGND VGND VPWR VPWR sky130_fd_sc_hd__decap_3
XFILLER_133_169 VGND VGND VPWR VPWR sky130_fd_sc_hd__decap_3
X_8125_ _8698_/CLK _8125_/D load_slew740/X VGND VGND VPWR VPWR _8125_/Q sky130_fd_sc_hd__dfrtp_2
X_5337_ _5505_/S VGND VGND VPWR VPWR _5356_/S sky130_fd_sc_hd__buf_2
XFILLER_0_639 VGND VGND VPWR VPWR sky130_fd_sc_hd__decap_3
XFILLER_125_36 VGND VGND VPWR VPWR sky130_fd_sc_hd__decap_3
XFILLER_88_757 VGND VGND VPWR VPWR sky130_fd_sc_hd__decap_3
X_8056_ _8785_/CLK _8056_/D load_slew678/X VGND VGND VPWR VPWR _8056_/Q sky130_fd_sc_hd__dfrtp_2
X_5268_ _7688_/Q _4811_/X _5268_/S VGND VGND VPWR VPWR _5269_/A sky130_fd_sc_hd__mux2_2
XFILLER_102_578 VGND VGND VPWR VPWR sky130_fd_sc_hd__decap_3
XFILLER_102_589 VGND VGND VPWR VPWR sky130_fd_sc_hd__fill_1
XFILLER_125_69 VGND VGND VPWR VPWR sky130_fd_sc_hd__decap_3
XFILLER_87_278 VGND VGND VPWR VPWR sky130_fd_sc_hd__fill_2
X_7007_ _4945_/X hold940/X _7025_/S VGND VGND VPWR VPWR _7008_/A sky130_fd_sc_hd__mux2_1
X_4219_ _4216_/X _4217_/X _4218_/X _4221_/A VGND VGND VPWR VPWR _4219_/X sky130_fd_sc_hd__a22o_2
XFILLER_18_12 VGND VGND VPWR VPWR sky130_fd_sc_hd__decap_3
X_5199_ _7655_/Q _5015_/X _5205_/S VGND VGND VPWR VPWR _5200_/A sky130_fd_sc_hd__mux2_2
XFILLER_18_56 VGND VGND VPWR VPWR sky130_fd_sc_hd__decap_3
XTAP_TAPCELL_ROW_126_2058 VGND VPWR sky130_fd_sc_hd__tapvpwrvgnd_1
XTAP_TAPCELL_ROW_39_841 VGND VPWR sky130_fd_sc_hd__tapvpwrvgnd_1
XFILLER_55_175 VGND VGND VPWR VPWR sky130_fd_sc_hd__decap_3
XFILLER_56_698 VGND VGND VPWR VPWR sky130_fd_sc_hd__fill_2
XFILLER_43_337 VGND VGND VPWR VPWR sky130_fd_sc_hd__fill_1
XFILLER_70_134 VGND VGND VPWR VPWR sky130_fd_sc_hd__decap_3
XFILLER_71_668 VGND VGND VPWR VPWR sky130_fd_sc_hd__decap_3
X_7909_ _8804_/CLK _7909_/D fanout490/X VGND VGND VPWR VPWR _7909_/Q sky130_fd_sc_hd__dfrtp_2
XFILLER_11_201 VGND VGND VPWR VPWR sky130_fd_sc_hd__decap_3
XFILLER_70_189 VGND VGND VPWR VPWR sky130_fd_sc_hd__decap_3
XTAP_TAPCELL_ROW_121_1980 VGND VPWR sky130_fd_sc_hd__tapvpwrvgnd_1
Xclkbuf_4_3_0_CLK clkbuf_0_CLK/X VGND VGND VPWR VPWR clkbuf_4_3_0_CLK/X sky130_fd_sc_hd__clkbuf_8
XFILLER_11_234 VGND VGND VPWR VPWR sky130_fd_sc_hd__decap_3
XFILLER_11_245 VGND VGND VPWR VPWR sky130_fd_sc_hd__decap_3
XFILLER_12_757 VGND VGND VPWR VPWR sky130_fd_sc_hd__decap_3
XFILLER_133_3 VGND VGND VPWR VPWR sky130_fd_sc_hd__decap_3
XFILLER_8_728 VGND VGND VPWR VPWR sky130_fd_sc_hd__decap_3
XTAP_TAPCELL_ROW_121_1991 VGND VPWR sky130_fd_sc_hd__tapvpwrvgnd_1
XFILLER_11_278 VGND VGND VPWR VPWR sky130_fd_sc_hd__fill_2
XFILLER_50_10 VGND VGND VPWR VPWR sky130_fd_sc_hd__decap_3
XFILLER_109_155 VGND VGND VPWR VPWR sky130_fd_sc_hd__fill_1
XTAP_TAPCELL_ROW_59_1112 VGND VPWR sky130_fd_sc_hd__tapvpwrvgnd_1
XTAP_TAPCELL_ROW_59_1123 VGND VPWR sky130_fd_sc_hd__tapvpwrvgnd_1
XFILLER_124_158 VGND VGND VPWR VPWR sky130_fd_sc_hd__decap_3
XTAP_TAPCELL_ROW_72_1301 VGND VPWR sky130_fd_sc_hd__tapvpwrvgnd_1
XFILLER_112_309 VGND VGND VPWR VPWR sky130_fd_sc_hd__decap_3
XFILLER_132_180 VGND VGND VPWR VPWR sky130_fd_sc_hd__decap_3
XFILLER_59_85 VGND VGND VPWR VPWR sky130_fd_sc_hd__fill_1
XFILLER_78_223 VGND VGND VPWR VPWR sky130_fd_sc_hd__decap_3
XFILLER_120_342 VGND VGND VPWR VPWR sky130_fd_sc_hd__decap_3
XFILLER_15_9 VGND VGND VPWR VPWR sky130_fd_sc_hd__decap_3
XFILLER_94_749 VGND VGND VPWR VPWR sky130_fd_sc_hd__decap_3
Xfanout291 _3853_/C1 VGND VGND VPWR VPWR _3894_/A1 sky130_fd_sc_hd__clkdlybuf4s25_1
XFILLER_75_51 VGND VGND VPWR VPWR sky130_fd_sc_hd__decap_3
XFILLER_47_698 VGND VGND VPWR VPWR sky130_fd_sc_hd__decap_3
XFILLER_46_197 VGND VGND VPWR VPWR sky130_fd_sc_hd__fill_2
XFILLER_61_134 VGND VGND VPWR VPWR sky130_fd_sc_hd__decap_3
XTAP_TAPCELL_ROW_17_524 VGND VPWR sky130_fd_sc_hd__tapvpwrvgnd_1
XTAP_TAPCELL_ROW_17_535 VGND VPWR sky130_fd_sc_hd__tapvpwrvgnd_1
XFILLER_131_90 VGND VGND VPWR VPWR sky130_fd_sc_hd__decap_3
XTAP_TAPCELL_ROW_83_1452 VGND VPWR sky130_fd_sc_hd__tapvpwrvgnd_1
XFILLER_15_573 VGND VGND VPWR VPWR sky130_fd_sc_hd__decap_3
XFILLER_91_72 VGND VGND VPWR VPWR sky130_fd_sc_hd__fill_1
XFILLER_91_94 VGND VGND VPWR VPWR sky130_fd_sc_hd__decap_3
XFILLER_30_598 VGND VGND VPWR VPWR sky130_fd_sc_hd__decap_3
X_4570_ _8367_/Q _4652_/A2 _4652_/B1 _8286_/Q VGND VGND VPWR VPWR _4570_/X sky130_fd_sc_hd__o22a_2
XFILLER_128_442 VGND VGND VPWR VPWR sky130_fd_sc_hd__decap_3
XFILLER_7_750 VGND VGND VPWR VPWR sky130_fd_sc_hd__decap_3
XFILLER_115_103 VGND VGND VPWR VPWR sky130_fd_sc_hd__decap_3
XFILLER_128_475 VGND VGND VPWR VPWR sky130_fd_sc_hd__fill_1
XFILLER_128_486 VGND VGND VPWR VPWR sky130_fd_sc_hd__decap_3
XFILLER_6_271 VGND VGND VPWR VPWR sky130_fd_sc_hd__fill_1
XFILLER_7_783 VGND VGND VPWR VPWR sky130_fd_sc_hd__fill_1
XFILLER_7_794 VGND VGND VPWR VPWR sky130_fd_sc_hd__decap_3
XFILLER_6_293 VGND VGND VPWR VPWR sky130_fd_sc_hd__decap_3
X_6240_ _6240_/A VGND VGND VPWR VPWR _8180_/D sky130_fd_sc_hd__buf_6
XFILLER_115_169 VGND VGND VPWR VPWR sky130_fd_sc_hd__decap_3
XFILLER_130_106 VGND VGND VPWR VPWR sky130_fd_sc_hd__decap_3
XFILLER_131_629 VGND VGND VPWR VPWR sky130_fd_sc_hd__decap_3
X_6171_ _6171_/A VGND VGND VPWR VPWR _8147_/D sky130_fd_sc_hd__buf_6
XFILLER_130_139 VGND VGND VPWR VPWR sky130_fd_sc_hd__fill_1
XFILLER_69_234 VGND VGND VPWR VPWR sky130_fd_sc_hd__decap_3
XPHY_EDGE_ROW_71_Left_207 VGND VGND VPWR VPWR sky130_fd_sc_hd__decap_3
X_5122_ _5122_/A VGND VGND VPWR VPWR _7619_/D sky130_fd_sc_hd__buf_1
XFILLER_85_716 VGND VGND VPWR VPWR sky130_fd_sc_hd__decap_3
Xload_slew642 fanout641/X VGND VGND VPWR VPWR load_slew642/X sky130_fd_sc_hd__clkbuf_2
XFILLER_111_375 VGND VGND VPWR VPWR sky130_fd_sc_hd__decap_3
XFILLER_97_598 VGND VGND VPWR VPWR sky130_fd_sc_hd__decap_3
X_5053_ _4727_/X hold969/X _5053_/S VGND VGND VPWR VPWR _5054_/A sky130_fd_sc_hd__mux2_2
XFILLER_37_120 VGND VGND VPWR VPWR sky130_fd_sc_hd__decap_3
XFILLER_38_643 VGND VGND VPWR VPWR sky130_fd_sc_hd__fill_1
XFILLER_38_654 VGND VGND VPWR VPWR sky130_fd_sc_hd__decap_3
XFILLER_93_760 VGND VGND VPWR VPWR sky130_fd_sc_hd__decap_3
X_4004_ _8721_/Q _8802_/Q _4007_/S VGND VGND VPWR VPWR _4004_/X sky130_fd_sc_hd__mux2_2
XFILLER_1_81 VGND VGND VPWR VPWR sky130_fd_sc_hd__decap_3
XFILLER_53_613 VGND VGND VPWR VPWR sky130_fd_sc_hd__decap_3
XFILLER_65_484 VGND VGND VPWR VPWR sky130_fd_sc_hd__decap_3
XTAP_TAPCELL_ROW_36_800 VGND VPWR sky130_fd_sc_hd__tapvpwrvgnd_1
XFILLER_53_635 VGND VGND VPWR VPWR sky130_fd_sc_hd__decap_3
XFILLER_53_657 VGND VGND VPWR VPWR sky130_fd_sc_hd__decap_3
XFILLER_92_292 VGND VGND VPWR VPWR sky130_fd_sc_hd__decap_3
XFILLER_40_307 VGND VGND VPWR VPWR sky130_fd_sc_hd__fill_1
X_8743_ _8743_/CLK _8743_/D fanout615/X VGND VGND VPWR VPWR _8743_/Q sky130_fd_sc_hd__dfrtp_2
X_5955_ _5958_/A1 _5947_/X _4925_/X _5948_/X hold760/X VGND VGND VPWR VPWR _8039_/D
+ sky130_fd_sc_hd__a32o_2
XPHY_EDGE_ROW_80_Left_216 VGND VGND VPWR VPWR sky130_fd_sc_hd__decap_3
X_8674_ _8676_/CLK _8674_/D load_slew699/X VGND VGND VPWR VPWR _8674_/Q sky130_fd_sc_hd__dfrtp_2
X_5886_ _5881_/X _5882_/X _4691_/X _5883_/X hold759/X VGND VGND VPWR VPWR _7985_/D
+ sky130_fd_sc_hd__a32o_2
X_4906_ _4951_/A VGND VGND VPWR VPWR _4944_/B sky130_fd_sc_hd__clkbuf_1
X_7625_ _8684_/CLK _7625_/D load_slew558/X VGND VGND VPWR VPWR _7625_/Q sky130_fd_sc_hd__dfrtp_2
X_4837_ _4837_/A VGND VGND VPWR VPWR _4837_/X sky130_fd_sc_hd__buf_1
XFILLER_5_709 VGND VGND VPWR VPWR sky130_fd_sc_hd__decap_3
X_7556_ _8781_/CLK _7556_/D fanout749/A VGND VGND VPWR VPWR _7556_/Q sky130_fd_sc_hd__dfrtp_2
X_4768_ _4768_/A _4776_/B VGND VGND VPWR VPWR _4769_/A sky130_fd_sc_hd__and2_2
XFILLER_107_626 VGND VGND VPWR VPWR sky130_fd_sc_hd__decap_3
XFILLER_119_497 VGND VGND VPWR VPWR sky130_fd_sc_hd__decap_3
XFILLER_134_401 VGND VGND VPWR VPWR sky130_fd_sc_hd__decap_3
XFILLER_20_24 VGND VGND VPWR VPWR sky130_fd_sc_hd__decap_3
X_3719_ _8053_/Q input2/X _3719_/C VGND VGND VPWR VPWR _3719_/X sky130_fd_sc_hd__and3b_2
X_7487_ _5015_/X _8799_/Q _7495_/S VGND VGND VPWR VPWR _7488_/A sky130_fd_sc_hd__mux2_2
X_6507_ _4985_/X _8306_/Q _6507_/S VGND VGND VPWR VPWR _6508_/A sky130_fd_sc_hd__mux2_2
X_4699_ _7497_/S VGND VGND VPWR VPWR _4736_/S sky130_fd_sc_hd__buf_2
XFILLER_134_445 VGND VGND VPWR VPWR sky130_fd_sc_hd__decap_3
XFILLER_20_35 VGND VGND VPWR VPWR sky130_fd_sc_hd__decap_3
XFILLER_20_68 VGND VGND VPWR VPWR sky130_fd_sc_hd__decap_3
X_6438_ _4849_/X _8274_/Q _6440_/S VGND VGND VPWR VPWR _6439_/A sky130_fd_sc_hd__mux2_2
XFILLER_134_467 VGND VGND VPWR VPWR sky130_fd_sc_hd__fill_1
XFILLER_134_489 VGND VGND VPWR VPWR sky130_fd_sc_hd__decap_3
XFILLER_0_414 VGND VGND VPWR VPWR sky130_fd_sc_hd__decap_3
XFILLER_88_521 VGND VGND VPWR VPWR sky130_fd_sc_hd__decap_3
XTAP_TAPCELL_ROW_54_1042 VGND VPWR sky130_fd_sc_hd__tapvpwrvgnd_1
XTAP_TAPCELL_ROW_54_1053 VGND VPWR sky130_fd_sc_hd__tapvpwrvgnd_1
X_8108_ _8756_/CLK _8108_/D load_slew722/X VGND VGND VPWR VPWR _8108_/Q sky130_fd_sc_hd__dfrtp_2
X_6369_ _4711_/X _8241_/Q _6377_/S VGND VGND VPWR VPWR _6370_/A sky130_fd_sc_hd__mux2_2
XFILLER_130_640 VGND VGND VPWR VPWR sky130_fd_sc_hd__decap_3
XFILLER_130_651 VGND VGND VPWR VPWR sky130_fd_sc_hd__decap_3
XFILLER_48_418 VGND VGND VPWR VPWR sky130_fd_sc_hd__fill_2
XFILLER_76_716 VGND VGND VPWR VPWR sky130_fd_sc_hd__decap_3
XFILLER_88_565 VGND VGND VPWR VPWR sky130_fd_sc_hd__decap_3
XFILLER_130_684 VGND VGND VPWR VPWR sky130_fd_sc_hd__decap_3
XFILLER_75_204 VGND VGND VPWR VPWR sky130_fd_sc_hd__decap_3
XFILLER_88_587 VGND VGND VPWR VPWR sky130_fd_sc_hd__fill_1
X_8039_ _8778_/CLK _8039_/D load_slew729/X VGND VGND VPWR VPWR _8039_/Q sky130_fd_sc_hd__dfrtp_2
XFILLER_29_632 VGND VGND VPWR VPWR sky130_fd_sc_hd__decap_3
XFILLER_75_248 VGND VGND VPWR VPWR sky130_fd_sc_hd__decap_3
XFILLER_91_719 VGND VGND VPWR VPWR sky130_fd_sc_hd__fill_1
XFILLER_56_473 VGND VGND VPWR VPWR sky130_fd_sc_hd__decap_3
XFILLER_56_484 VGND VGND VPWR VPWR sky130_fd_sc_hd__fill_2
XFILLER_84_760 VGND VGND VPWR VPWR sky130_fd_sc_hd__decap_3
XFILLER_28_197 VGND VGND VPWR VPWR sky130_fd_sc_hd__decap_3
XFILLER_71_443 VGND VGND VPWR VPWR sky130_fd_sc_hd__decap_3
XFILLER_83_281 VGND VGND VPWR VPWR sky130_fd_sc_hd__decap_3
XPHY_EDGE_ROW_119_Left_255 VGND VGND VPWR VPWR sky130_fd_sc_hd__decap_3
XFILLER_43_167 VGND VGND VPWR VPWR sky130_fd_sc_hd__fill_1
XFILLER_45_76 VGND VGND VPWR VPWR sky130_fd_sc_hd__decap_3
XFILLER_129_217 VGND VGND VPWR VPWR sky130_fd_sc_hd__decap_3
XFILLER_12_554 VGND VGND VPWR VPWR sky130_fd_sc_hd__decap_3
XFILLER_61_31 VGND VGND VPWR VPWR sky130_fd_sc_hd__decap_3
XFILLER_129_228 VGND VGND VPWR VPWR sky130_fd_sc_hd__decap_3
XFILLER_12_598 VGND VGND VPWR VPWR sky130_fd_sc_hd__decap_3
XFILLER_61_53 VGND VGND VPWR VPWR sky130_fd_sc_hd__decap_3
XFILLER_8_536 VGND VGND VPWR VPWR sky130_fd_sc_hd__decap_3
XFILLER_6_15 VGND VGND VPWR VPWR sky130_fd_sc_hd__decap_3
XANTENNA_8 _4617_/B1 VGND VGND VPWR VPWR sky130_fd_sc_hd__diode_2
XFILLER_125_423 VGND VGND VPWR VPWR sky130_fd_sc_hd__decap_3
XFILLER_4_731 VGND VGND VPWR VPWR sky130_fd_sc_hd__decap_3
XFILLER_6_59 VGND VGND VPWR VPWR sky130_fd_sc_hd__decap_3
XPHY_EDGE_ROW_128_Left_264 VGND VGND VPWR VPWR sky130_fd_sc_hd__decap_3
XFILLER_106_670 VGND VGND VPWR VPWR sky130_fd_sc_hd__fill_1
XFILLER_4_775 VGND VGND VPWR VPWR sky130_fd_sc_hd__decap_3
XFILLER_112_139 VGND VGND VPWR VPWR sky130_fd_sc_hd__fill_1
XFILLER_79_565 VGND VGND VPWR VPWR sky130_fd_sc_hd__decap_3
XFILLER_120_150 VGND VGND VPWR VPWR sky130_fd_sc_hd__decap_3
XFILLER_67_727 VGND VGND VPWR VPWR sky130_fd_sc_hd__fill_1
XFILLER_67_738 VGND VGND VPWR VPWR sky130_fd_sc_hd__decap_3
XFILLER_13_6 VGND VGND VPWR VPWR sky130_fd_sc_hd__decap_3
XFILLER_82_719 VGND VGND VPWR VPWR sky130_fd_sc_hd__decap_3
XFILLER_94_546 VGND VGND VPWR VPWR sky130_fd_sc_hd__decap_3
XFILLER_35_613 VGND VGND VPWR VPWR sky130_fd_sc_hd__decap_3
XFILLER_75_782 VGND VGND VPWR VPWR sky130_fd_sc_hd__fill_2
XFILLER_19_175 VGND VGND VPWR VPWR sky130_fd_sc_hd__fill_1
XFILLER_62_410 VGND VGND VPWR VPWR sky130_fd_sc_hd__fill_2
XFILLER_62_421 VGND VGND VPWR VPWR sky130_fd_sc_hd__fill_1
XFILLER_34_134 VGND VGND VPWR VPWR sky130_fd_sc_hd__decap_3
XFILLER_50_605 VGND VGND VPWR VPWR sky130_fd_sc_hd__fill_2
XFILLER_62_454 VGND VGND VPWR VPWR sky130_fd_sc_hd__decap_3
XFILLER_22_318 VGND VGND VPWR VPWR sky130_fd_sc_hd__decap_3
XFILLER_34_189 VGND VGND VPWR VPWR sky130_fd_sc_hd__decap_3
X_5740_ _7910_/Q _4723_/A _5742_/S VGND VGND VPWR VPWR _5741_/A sky130_fd_sc_hd__mux2_2
X_7410_ _8762_/Q _4856_/A _7428_/S VGND VGND VPWR VPWR _7411_/A sky130_fd_sc_hd__mux2_2
X_5671_ _7878_/Q _4929_/A _5675_/S VGND VGND VPWR VPWR _5672_/A sky130_fd_sc_hd__mux2_2
XFILLER_129_762 VGND VGND VPWR VPWR sky130_fd_sc_hd__decap_3
X_8390_ _8801_/CLK _8390_/D fanout607/X VGND VGND VPWR VPWR _8390_/Q sky130_fd_sc_hd__dfrtp_2
X_4622_ _8696_/Q _4634_/A2 _4622_/B1 _8615_/Q _4669_/S VGND VGND VPWR VPWR _4622_/X
+ sky130_fd_sc_hd__o221a_2
XTAP_TAPCELL_ROW_96_1632 VGND VPWR sky130_fd_sc_hd__tapvpwrvgnd_1
XTAP_TAPCELL_ROW_96_1643 VGND VPWR sky130_fd_sc_hd__tapvpwrvgnd_1
Xmax_cap211 _5933_/X VGND VGND VPWR VPWR _5944_/A1 sky130_fd_sc_hd__buf_2
Xmax_cap200 _3768_/X VGND VGND VPWR VPWR _4295_/A2 sky130_fd_sc_hd__buf_6
X_7341_ _7341_/A VGND VGND VPWR VPWR _8729_/D sky130_fd_sc_hd__buf_1
X_4553_ _8447_/Q _8528_/Q _8609_/Q _8690_/Q _4554_/S _4503_/A VGND VGND VPWR VPWR
+ _4553_/X sky130_fd_sc_hd__mux4_2
Xmax_cap244 _3889_/X VGND VGND VPWR VPWR _4642_/A2 sky130_fd_sc_hd__buf_6
Xmax_cap233 _7228_/X VGND VGND VPWR VPWR _7239_/A1 sky130_fd_sc_hd__buf_2
Xmax_cap222 _4818_/B VGND VGND VPWR VPWR _4810_/B sky130_fd_sc_hd__buf_2
X_7272_ _7267_/X _4903_/X _7269_/X _7270_/X hold780/X VGND VGND VPWR VPWR _8692_/D
+ sky130_fd_sc_hd__a32o_2
X_4484_ _8440_/Q _8521_/Q _8602_/Q _8683_/Q _4523_/S0 _4531_/S1 VGND VGND VPWR VPWR
+ _4484_/X sky130_fd_sc_hd__mux4_2
XFILLER_104_607 VGND VGND VPWR VPWR sky130_fd_sc_hd__decap_3
XFILLER_89_318 VGND VGND VPWR VPWR sky130_fd_sc_hd__decap_3
Xmax_cap266 _3890_/X VGND VGND VPWR VPWR _4682_/C1 sky130_fd_sc_hd__buf_6
Xmax_cap255 _3784_/X VGND VGND VPWR VPWR _4286_/A2 sky130_fd_sc_hd__buf_6
X_6223_ _6223_/A VGND VGND VPWR VPWR _8172_/D sky130_fd_sc_hd__buf_6
XFILLER_106_16 VGND VGND VPWR VPWR sky130_fd_sc_hd__fill_1
XFILLER_106_38 VGND VGND VPWR VPWR sky130_fd_sc_hd__decap_3
XFILLER_97_340 VGND VGND VPWR VPWR sky130_fd_sc_hd__decap_3
X_6154_ _6154_/A VGND VGND VPWR VPWR _8139_/D sky130_fd_sc_hd__buf_6
XFILLER_111_172 VGND VGND VPWR VPWR sky130_fd_sc_hd__decap_3
X_6085_ _8108_/Q _4832_/A _6095_/S VGND VGND VPWR VPWR _6086_/A sky130_fd_sc_hd__mux2_2
X_5105_ _5105_/A VGND VGND VPWR VPWR _7611_/D sky130_fd_sc_hd__buf_1
Xload_slew494 fanout493/X VGND VGND VPWR VPWR load_slew494/X sky130_fd_sc_hd__buf_4
X_5036_ _5036_/A VGND VGND VPWR VPWR _5036_/X sky130_fd_sc_hd__buf_1
XFILLER_122_26 VGND VGND VPWR VPWR sky130_fd_sc_hd__fill_2
XFILLER_66_760 VGND VGND VPWR VPWR sky130_fd_sc_hd__decap_3
XTAP_TAPCELL_ROW_123_2017 VGND VPWR sky130_fd_sc_hd__tapvpwrvgnd_1
XTAP_TAPCELL_ROW_49_980 VGND VPWR sky130_fd_sc_hd__tapvpwrvgnd_1
XFILLER_25_145 VGND VGND VPWR VPWR sky130_fd_sc_hd__fill_1
XFILLER_25_167 VGND VGND VPWR VPWR sky130_fd_sc_hd__fill_1
XFILLER_53_465 VGND VGND VPWR VPWR sky130_fd_sc_hd__decap_3
XFILLER_80_240 VGND VGND VPWR VPWR sky130_fd_sc_hd__fill_1
XFILLER_81_752 VGND VGND VPWR VPWR sky130_fd_sc_hd__decap_3
XFILLER_81_785 VGND VGND VPWR VPWR sky130_fd_sc_hd__fill_1
XTAP_TAPCELL_ROW_0_277 VGND VPWR sky130_fd_sc_hd__tapvpwrvgnd_1
XTAP_TAPCELL_ROW_0_288 VGND VPWR sky130_fd_sc_hd__tapvpwrvgnd_1
X_6987_ _6987_/A VGND VGND VPWR VPWR _8531_/D sky130_fd_sc_hd__buf_6
XFILLER_13_329 VGND VGND VPWR VPWR sky130_fd_sc_hd__decap_3
XFILLER_15_24 VGND VGND VPWR VPWR sky130_fd_sc_hd__decap_3
XFILLER_15_57 VGND VGND VPWR VPWR sky130_fd_sc_hd__decap_3
XFILLER_40_126 VGND VGND VPWR VPWR sky130_fd_sc_hd__decap_3
XFILLER_41_649 VGND VGND VPWR VPWR sky130_fd_sc_hd__decap_3
XFILLER_80_262 VGND VGND VPWR VPWR sky130_fd_sc_hd__decap_3
XFILLER_80_284 VGND VGND VPWR VPWR sky130_fd_sc_hd__decap_3
XTAP_TAPCELL_ROW_0_299 VGND VPWR sky130_fd_sc_hd__tapvpwrvgnd_1
XTAP_TAPCELL_ROW_105_1761 VGND VPWR sky130_fd_sc_hd__tapvpwrvgnd_1
X_8726_ _8730_/CLK _8726_/D fanout506/X VGND VGND VPWR VPWR _8726_/Q sky130_fd_sc_hd__dfrtp_2
X_5938_ _5944_/A1 _5944_/A2 _4866_/X _5944_/B1 hold789/X VGND VGND VPWR VPWR _8025_/D
+ sky130_fd_sc_hd__a32o_2
XFILLER_21_340 VGND VGND VPWR VPWR sky130_fd_sc_hd__decap_3
X_8657_ _8657_/CLK _8657_/D load_slew513/X VGND VGND VPWR VPWR _8657_/Q sky130_fd_sc_hd__dfrtp_2
X_5869_ _5947_/A VGND VGND VPWR VPWR _5869_/X sky130_fd_sc_hd__clkbuf_1
XFILLER_21_384 VGND VGND VPWR VPWR sky130_fd_sc_hd__decap_3
XFILLER_31_12 VGND VGND VPWR VPWR sky130_fd_sc_hd__decap_3
X_8588_ _8750_/CLK _8588_/D load_slew636/X VGND VGND VPWR VPWR _8588_/Q sky130_fd_sc_hd__dfrtp_2
X_7608_ _8793_/CLK _7608_/D load_slew640/X VGND VGND VPWR VPWR _7608_/Q sky130_fd_sc_hd__dfrtp_2
XFILLER_107_401 VGND VGND VPWR VPWR sky130_fd_sc_hd__fill_1
XFILLER_135_710 VGND VGND VPWR VPWR sky130_fd_sc_hd__decap_3
X_7539_ _8764_/CLK _7539_/D load_slew563/X VGND VGND VPWR VPWR _7539_/Q sky130_fd_sc_hd__dfrtp_2
XFILLER_135_732 VGND VGND VPWR VPWR sky130_fd_sc_hd__decap_3
XTAP_TAPCELL_ROW_134_2168 VGND VPWR sky130_fd_sc_hd__tapvpwrvgnd_1
XFILLER_107_467 VGND VGND VPWR VPWR sky130_fd_sc_hd__fill_1
XFILLER_134_253 VGND VGND VPWR VPWR sky130_fd_sc_hd__decap_3
XFILLER_0_200 VGND VGND VPWR VPWR sky130_fd_sc_hd__fill_1
XFILLER_122_426 VGND VGND VPWR VPWR sky130_fd_sc_hd__decap_3
XFILLER_1_712 VGND VGND VPWR VPWR sky130_fd_sc_hd__decap_3
XFILLER_0_233 VGND VGND VPWR VPWR sky130_fd_sc_hd__decap_3
XFILLER_1_756 VGND VGND VPWR VPWR sky130_fd_sc_hd__decap_3
Xoutput89 _3915_/X VGND VGND VPWR VPWR rdata[11] sky130_fd_sc_hd__clkdlybuf4s25_1
XFILLER_49_738 VGND VGND VPWR VPWR sky130_fd_sc_hd__decap_3
XTAP_TAPCELL_ROW_8_399 VGND VPWR sky130_fd_sc_hd__tapvpwrvgnd_1
XFILLER_102_194 VGND VGND VPWR VPWR sky130_fd_sc_hd__fill_2
XFILLER_130_492 VGND VGND VPWR VPWR sky130_fd_sc_hd__decap_3
XFILLER_76_557 VGND VGND VPWR VPWR sky130_fd_sc_hd__decap_3
XFILLER_56_53 VGND VGND VPWR VPWR sky130_fd_sc_hd__fill_2
XFILLER_63_218 VGND VGND VPWR VPWR sky130_fd_sc_hd__decap_3
XFILLER_44_421 VGND VGND VPWR VPWR sky130_fd_sc_hd__fill_1
XTAP_TAPCELL_ROW_67_1233 VGND VPWR sky130_fd_sc_hd__tapvpwrvgnd_1
XFILLER_17_657 VGND VGND VPWR VPWR sky130_fd_sc_hd__decap_3
XFILLER_17_679 VGND VGND VPWR VPWR sky130_fd_sc_hd__decap_3
XFILLER_44_465 VGND VGND VPWR VPWR sky130_fd_sc_hd__decap_3
XFILLER_71_251 VGND VGND VPWR VPWR sky130_fd_sc_hd__fill_1
XPHY_EDGE_ROW_113_Right_113 VGND VGND VPWR VPWR sky130_fd_sc_hd__decap_3
XFILLER_31_104 VGND VGND VPWR VPWR sky130_fd_sc_hd__decap_3
XFILLER_71_273 VGND VGND VPWR VPWR sky130_fd_sc_hd__decap_3
XFILLER_71_284 VGND VGND VPWR VPWR sky130_fd_sc_hd__decap_3
XTAP_TAPCELL_ROW_27_674 VGND VPWR sky130_fd_sc_hd__tapvpwrvgnd_1
XTAP_TAPCELL_ROW_80_1411 VGND VPWR sky130_fd_sc_hd__tapvpwrvgnd_1
XFILLER_31_159 VGND VGND VPWR VPWR sky130_fd_sc_hd__decap_3
XFILLER_72_85 VGND VGND VPWR VPWR sky130_fd_sc_hd__decap_3
XFILLER_12_373 VGND VGND VPWR VPWR sky130_fd_sc_hd__decap_3
XFILLER_12_395 VGND VGND VPWR VPWR sky130_fd_sc_hd__decap_3
XFILLER_125_231 VGND VGND VPWR VPWR sky130_fd_sc_hd__fill_1
XFILLER_126_787 VGND VGND VPWR VPWR sky130_fd_sc_hd__decap_3
XTAP_TAPCELL_ROW_78_1384 VGND VPWR sky130_fd_sc_hd__tapvpwrvgnd_1
XFILLER_99_638 VGND VGND VPWR VPWR sky130_fd_sc_hd__decap_3
XFILLER_79_340 VGND VGND VPWR VPWR sky130_fd_sc_hd__decap_3
XFILLER_97_60 VGND VGND VPWR VPWR sky130_fd_sc_hd__fill_2
XTAP_TAPCELL_ROW_91_1562 VGND VPWR sky130_fd_sc_hd__tapvpwrvgnd_1
XTAP_TAPCELL_ROW_91_1573 VGND VPWR sky130_fd_sc_hd__tapvpwrvgnd_1
XFILLER_79_373 VGND VGND VPWR VPWR sky130_fd_sc_hd__fill_2
XFILLER_79_384 VGND VGND VPWR VPWR sky130_fd_sc_hd__decap_3
XFILLER_11_3 VGND VGND VPWR VPWR sky130_fd_sc_hd__decap_3
XFILLER_121_481 VGND VGND VPWR VPWR sky130_fd_sc_hd__fill_1
XFILLER_39_248 VGND VGND VPWR VPWR sky130_fd_sc_hd__decap_3
XFILLER_94_343 VGND VGND VPWR VPWR sky130_fd_sc_hd__fill_2
XFILLER_94_354 VGND VGND VPWR VPWR sky130_fd_sc_hd__fill_1
XFILLER_94_365 VGND VGND VPWR VPWR sky130_fd_sc_hd__decap_3
XFILLER_47_281 VGND VGND VPWR VPWR sky130_fd_sc_hd__decap_3
XFILLER_54_229 VGND VGND VPWR VPWR sky130_fd_sc_hd__fill_1
X_7890_ _8545_/CLK _7890_/D wire657/A VGND VGND VPWR VPWR _7890_/Q sky130_fd_sc_hd__dfrtp_2
X_6910_ _4757_/X _8495_/Q _6916_/S VGND VGND VPWR VPWR _6911_/A sky130_fd_sc_hd__mux2_4
XFILLER_62_240 VGND VGND VPWR VPWR sky130_fd_sc_hd__decap_3
X_6841_ _4961_/X _8462_/Q _6853_/S VGND VGND VPWR VPWR _6842_/A sky130_fd_sc_hd__mux2_4
XFILLER_35_487 VGND VGND VPWR VPWR sky130_fd_sc_hd__decap_3
XFILLER_50_424 VGND VGND VPWR VPWR sky130_fd_sc_hd__fill_1
XFILLER_90_571 VGND VGND VPWR VPWR sky130_fd_sc_hd__decap_3
XFILLER_22_126 VGND VGND VPWR VPWR sky130_fd_sc_hd__fill_2
XFILLER_22_137 VGND VGND VPWR VPWR sky130_fd_sc_hd__decap_3
X_3984_ _3984_/A _3984_/B VGND VGND VPWR VPWR _3984_/X sky130_fd_sc_hd__or2_2
X_8511_ _8680_/CLK _8511_/D load_slew691/X VGND VGND VPWR VPWR _8511_/Q sky130_fd_sc_hd__dfrtp_2
X_6772_ _8430_/Q _4823_/A _6786_/S VGND VGND VPWR VPWR _6773_/A sky130_fd_sc_hd__mux2_2
X_5723_ _5849_/S VGND VGND VPWR VPWR _5742_/S sky130_fd_sc_hd__buf_2
X_8442_ _8685_/CLK _8442_/D wire574/X VGND VGND VPWR VPWR _8442_/Q sky130_fd_sc_hd__dfrtp_2
X_5654_ _7870_/Q _4895_/A _5654_/S VGND VGND VPWR VPWR _5655_/A sky130_fd_sc_hd__mux2_2
XFILLER_129_570 VGND VGND VPWR VPWR sky130_fd_sc_hd__decap_3
XFILLER_30_192 VGND VGND VPWR VPWR sky130_fd_sc_hd__decap_3
XTAP_TAPCELL_ROW_100_1691 VGND VPWR sky130_fd_sc_hd__tapvpwrvgnd_1
X_8373_ _8778_/CLK _8373_/D load_slew731/X VGND VGND VPWR VPWR _8373_/Q sky130_fd_sc_hd__dfrtp_2
X_4605_ _4605_/A1 _4603_/X _4604_/X _4673_/S VGND VGND VPWR VPWR _4605_/X sky130_fd_sc_hd__a31o_2
X_7324_ _7324_/A VGND VGND VPWR VPWR _8721_/D sky130_fd_sc_hd__buf_1
X_5585_ _7837_/Q _4757_/A _5591_/S VGND VGND VPWR VPWR _5586_/A sky130_fd_sc_hd__mux2_2
XFILLER_116_264 VGND VGND VPWR VPWR sky130_fd_sc_hd__decap_3
XFILLER_117_15 VGND VGND VPWR VPWR sky130_fd_sc_hd__fill_2
XFILLER_132_713 VGND VGND VPWR VPWR sky130_fd_sc_hd__decap_3
X_4536_ _3828_/X _4535_/X _4545_/B1 VGND VGND VPWR VPWR _4536_/X sky130_fd_sc_hd__o21a_2
XFILLER_131_223 VGND VGND VPWR VPWR sky130_fd_sc_hd__fill_1
XFILLER_132_746 VGND VGND VPWR VPWR sky130_fd_sc_hd__decap_3
X_7255_ _7254_/X _4853_/X _7255_/A3 _7255_/B1 hold824/X VGND VGND VPWR VPWR _8680_/D
+ sky130_fd_sc_hd__a32o_2
X_4467_ _4467_/A1 _4460_/X _4462_/X _4466_/X VGND VGND VPWR VPWR _4467_/X sky130_fd_sc_hd__a31o_2
XFILLER_131_234 VGND VGND VPWR VPWR sky130_fd_sc_hd__decap_3
XFILLER_132_757 VGND VGND VPWR VPWR sky130_fd_sc_hd__decap_3
XTAP_TAPCELL_ROW_51_1001 VGND VPWR sky130_fd_sc_hd__tapvpwrvgnd_1
X_7186_ _7188_/A1 _4973_/X _7187_/A3 _7187_/B1 hold852/X VGND VGND VPWR VPWR _8627_/D
+ sky130_fd_sc_hd__a32o_2
X_6206_ _6206_/A VGND VGND VPWR VPWR _8164_/D sky130_fd_sc_hd__buf_6
X_4398_ _4415_/A _4398_/B VGND VGND VPWR VPWR _4398_/X sky130_fd_sc_hd__or2_2
XFILLER_131_267 VGND VGND VPWR VPWR sky130_fd_sc_hd__fill_1
XFILLER_98_682 VGND VGND VPWR VPWR sky130_fd_sc_hd__decap_3
XTAP_TAPCELL_ROW_51_1012 VGND VPWR sky130_fd_sc_hd__tapvpwrvgnd_1
Xhold1000 _7525_/Q VGND VGND VPWR VPWR _4808_/A1 sky130_fd_sc_hd__dlygate4sd3_1
X_6137_ _8133_/Q _4936_/A _6137_/S VGND VGND VPWR VPWR _6138_/A sky130_fd_sc_hd__mux2_2
XFILLER_133_36 VGND VGND VPWR VPWR sky130_fd_sc_hd__decap_3
XTAP_TAPCELL_ROW_5_358 VGND VPWR sky130_fd_sc_hd__tapvpwrvgnd_1
XTAP_TAPCELL_ROW_5_369 VGND VPWR sky130_fd_sc_hd__tapvpwrvgnd_1
Xhold1011 _8244_/Q VGND VGND VPWR VPWR _6375_/A1 sky130_fd_sc_hd__dlygate4sd3_1
Xhold1022 _8057_/Q VGND VGND VPWR VPWR _5978_/A0 sky130_fd_sc_hd__dlygate4sd3_1
Xhold1033 _8266_/Q VGND VGND VPWR VPWR _6422_/A1 sky130_fd_sc_hd__dlygate4sd3_1
XFILLER_133_69 VGND VGND VPWR VPWR sky130_fd_sc_hd__decap_3
XFILLER_45_218 VGND VGND VPWR VPWR sky130_fd_sc_hd__decap_3
XFILLER_46_719 VGND VGND VPWR VPWR sky130_fd_sc_hd__decap_3
XFILLER_73_505 VGND VGND VPWR VPWR sky130_fd_sc_hd__decap_3
XFILLER_93_29 VGND VGND VPWR VPWR sky130_fd_sc_hd__decap_3
Xhold1044 _7549_/Q VGND VGND VPWR VPWR _4910_/A1 sky130_fd_sc_hd__dlygate4sd3_1
Xhold1055 _8756_/Q VGND VGND VPWR VPWR _7397_/A0 sky130_fd_sc_hd__dlygate4sd3_1
Xhold1066 _7886_/Q VGND VGND VPWR VPWR _5690_/A0 sky130_fd_sc_hd__dlygate4sd3_1
X_6068_ _8100_/Q _4798_/A _6074_/S VGND VGND VPWR VPWR _6069_/A sky130_fd_sc_hd__mux2_2
XFILLER_26_12 VGND VGND VPWR VPWR sky130_fd_sc_hd__decap_3
XFILLER_38_281 VGND VGND VPWR VPWR sky130_fd_sc_hd__decap_3
XFILLER_45_229 VGND VGND VPWR VPWR sky130_fd_sc_hd__decap_3
XFILLER_73_538 VGND VGND VPWR VPWR sky130_fd_sc_hd__decap_3
X_5019_ _5019_/A VGND VGND VPWR VPWR _5019_/X sky130_fd_sc_hd__buf_1
XFILLER_26_56 VGND VGND VPWR VPWR sky130_fd_sc_hd__decap_3
XFILLER_54_741 VGND VGND VPWR VPWR sky130_fd_sc_hd__decap_3
XFILLER_54_763 VGND VGND VPWR VPWR sky130_fd_sc_hd__decap_3
XTAP_TAPCELL_ROW_44_909 VGND VPWR sky130_fd_sc_hd__tapvpwrvgnd_1
XFILLER_53_251 VGND VGND VPWR VPWR sky130_fd_sc_hd__decap_3
XFILLER_81_582 VGND VGND VPWR VPWR sky130_fd_sc_hd__decap_3
XFILLER_41_446 VGND VGND VPWR VPWR sky130_fd_sc_hd__fill_2
XTAP_TAPCELL_ROW_24_622 VGND VPWR sky130_fd_sc_hd__tapvpwrvgnd_1
XTAP_TAPCELL_ROW_24_633 VGND VPWR sky130_fd_sc_hd__tapvpwrvgnd_1
XTAP_TAPCELL_ROW_62_1163 VGND VPWR sky130_fd_sc_hd__tapvpwrvgnd_1
X_8709_ _8709_/CLK _8709_/D fanout674/X VGND VGND VPWR VPWR _8709_/Q sky130_fd_sc_hd__dfrtp_2
XFILLER_127_529 VGND VGND VPWR VPWR sky130_fd_sc_hd__decap_3
XFILLER_21_192 VGND VGND VPWR VPWR sky130_fd_sc_hd__fill_2
XFILLER_42_88 VGND VGND VPWR VPWR sky130_fd_sc_hd__fill_2
XFILLER_5_325 VGND VGND VPWR VPWR sky130_fd_sc_hd__decap_3
XTAP_TAPCELL_ROW_118_1941 VGND VPWR sky130_fd_sc_hd__tapvpwrvgnd_1
Xclkbuf_5_21__f_CLK clkbuf_4_10_0_CLK/X VGND VGND VPWR VPWR clkload7/A sky130_fd_sc_hd__clkbuf_16
XFILLER_135_573 VGND VGND VPWR VPWR sky130_fd_sc_hd__fill_2
XFILLER_5_358 VGND VGND VPWR VPWR sky130_fd_sc_hd__decap_3
XFILLER_122_223 VGND VGND VPWR VPWR sky130_fd_sc_hd__fill_2
XFILLER_123_735 VGND VGND VPWR VPWR sky130_fd_sc_hd__decap_3
XFILLER_135_595 VGND VGND VPWR VPWR sky130_fd_sc_hd__fill_2
XFILLER_122_256 VGND VGND VPWR VPWR sky130_fd_sc_hd__fill_2
XFILLER_123_768 VGND VGND VPWR VPWR sky130_fd_sc_hd__decap_3
XFILLER_3_27 VGND VGND VPWR VPWR sky130_fd_sc_hd__decap_3
XFILLER_96_619 VGND VGND VPWR VPWR sky130_fd_sc_hd__decap_3
XFILLER_107_81 VGND VGND VPWR VPWR sky130_fd_sc_hd__decap_3
XFILLER_95_107 VGND VGND VPWR VPWR sky130_fd_sc_hd__fill_2
XFILLER_67_63 VGND VGND VPWR VPWR sky130_fd_sc_hd__decap_3
XFILLER_37_719 VGND VGND VPWR VPWR sky130_fd_sc_hd__decap_3
XFILLER_76_365 VGND VGND VPWR VPWR sky130_fd_sc_hd__decap_3
XFILLER_91_302 VGND VGND VPWR VPWR sky130_fd_sc_hd__decap_3
XFILLER_57_590 VGND VGND VPWR VPWR sky130_fd_sc_hd__fill_2
XFILLER_17_432 VGND VGND VPWR VPWR sky130_fd_sc_hd__decap_3
XFILLER_83_51 VGND VGND VPWR VPWR sky130_fd_sc_hd__decap_3
XFILLER_45_774 VGND VGND VPWR VPWR sky130_fd_sc_hd__decap_3
XFILLER_45_785 VGND VGND VPWR VPWR sky130_fd_sc_hd__decap_3
XFILLER_60_722 VGND VGND VPWR VPWR sky130_fd_sc_hd__decap_3
XFILLER_72_560 VGND VGND VPWR VPWR sky130_fd_sc_hd__decap_3
XFILLER_32_457 VGND VGND VPWR VPWR sky130_fd_sc_hd__decap_3
XFILLER_9_620 VGND VGND VPWR VPWR sky130_fd_sc_hd__decap_3
XFILLER_13_682 VGND VGND VPWR VPWR sky130_fd_sc_hd__decap_3
XFILLER_9_653 VGND VGND VPWR VPWR sky130_fd_sc_hd__decap_3
XFILLER_118_507 VGND VGND VPWR VPWR sky130_fd_sc_hd__decap_3
XFILLER_118_529 VGND VGND VPWR VPWR sky130_fd_sc_hd__decap_3
XFILLER_8_141 VGND VGND VPWR VPWR sky130_fd_sc_hd__decap_3
XFILLER_8_163 VGND VGND VPWR VPWR sky130_fd_sc_hd__decap_3
XFILLER_9_697 VGND VGND VPWR VPWR sky130_fd_sc_hd__decap_3
XFILLER_99_402 VGND VGND VPWR VPWR sky130_fd_sc_hd__decap_3
X_5370_ _5370_/A VGND VGND VPWR VPWR _7735_/D sky130_fd_sc_hd__buf_1
XFILLER_126_595 VGND VGND VPWR VPWR sky130_fd_sc_hd__decap_3
XFILLER_99_435 VGND VGND VPWR VPWR sky130_fd_sc_hd__decap_3
X_4321_ _8011_/Q _3811_/X _3817_/X _7930_/Q _4684_/C1 VGND VGND VPWR VPWR _4321_/X
+ sky130_fd_sc_hd__o221a_2
XFILLER_99_479 VGND VGND VPWR VPWR sky130_fd_sc_hd__decap_3
X_7040_ _5015_/X _8556_/Q _7046_/S VGND VGND VPWR VPWR _7041_/A sky130_fd_sc_hd__mux2_2
X_4252_ _4252_/A _4252_/B VGND VGND VPWR VPWR _4252_/X sky130_fd_sc_hd__or2_2
XFILLER_101_418 VGND VGND VPWR VPWR sky130_fd_sc_hd__decap_3
XFILLER_95_630 VGND VGND VPWR VPWR sky130_fd_sc_hd__decap_3
X_4183_ _8090_/Q _8171_/Q _4183_/S VGND VGND VPWR VPWR _4184_/B sky130_fd_sc_hd__mux2_2
XTAP_TAPCELL_ROW_2_317 VGND VPWR sky130_fd_sc_hd__tapvpwrvgnd_1
XFILLER_36_730 VGND VGND VPWR VPWR sky130_fd_sc_hd__decap_3
XFILLER_82_313 VGND VGND VPWR VPWR sky130_fd_sc_hd__fill_2
X_7942_ _8029_/CLK _7942_/D load_slew570/X VGND VGND VPWR VPWR _7942_/Q sky130_fd_sc_hd__dfrtp_2
XFILLER_35_262 VGND VGND VPWR VPWR sky130_fd_sc_hd__decap_3
XFILLER_36_785 VGND VGND VPWR VPWR sky130_fd_sc_hd__decap_3
XFILLER_36_796 VGND VGND VPWR VPWR sky130_fd_sc_hd__decap_3
XFILLER_63_582 VGND VGND VPWR VPWR sky130_fd_sc_hd__fill_1
X_7873_ _8450_/CLK _7873_/D fanout741/X VGND VGND VPWR VPWR _7873_/Q sky130_fd_sc_hd__dfrtp_2
XFILLER_23_446 VGND VGND VPWR VPWR sky130_fd_sc_hd__fill_2
XFILLER_35_284 VGND VGND VPWR VPWR sky130_fd_sc_hd__decap_3
XFILLER_50_210 VGND VGND VPWR VPWR sky130_fd_sc_hd__fill_2
XTAP_TAPCELL_ROW_102_1720 VGND VPWR sky130_fd_sc_hd__tapvpwrvgnd_1
X_6824_ _8455_/Q _4928_/A _6828_/S VGND VGND VPWR VPWR _6825_/A sky130_fd_sc_hd__mux2_2
X_3967_ _8313_/Q _4560_/A2 _3800_/X _8232_/Q _4465_/A VGND VGND VPWR VPWR _3967_/X
+ sky130_fd_sc_hd__o221a_2
X_6755_ _8422_/Q _4790_/A _6765_/S VGND VGND VPWR VPWR _6756_/A sky130_fd_sc_hd__mux2_2
X_5706_ _5706_/A VGND VGND VPWR VPWR _7893_/D sky130_fd_sc_hd__buf_1
X_3898_ _8064_/Q _8145_/Q _8226_/Q _8307_/Q _4100_/S _4151_/A VGND VGND VPWR VPWR
+ _3898_/X sky130_fd_sc_hd__mux4_2
X_8425_ _8668_/CLK _8425_/D fanout635/X VGND VGND VPWR VPWR _8425_/Q sky130_fd_sc_hd__dfrtp_2
X_6686_ _8389_/Q input5/X _6702_/S VGND VGND VPWR VPWR _6687_/A sky130_fd_sc_hd__mux2_2
XFILLER_12_47 VGND VGND VPWR VPWR sky130_fd_sc_hd__decap_3
X_5637_ _5637_/A VGND VGND VPWR VPWR _7861_/D sky130_fd_sc_hd__buf_1
XFILLER_128_47 VGND VGND VPWR VPWR sky130_fd_sc_hd__decap_3
XTAP_TAPCELL_ROW_131_2127 VGND VPWR sky130_fd_sc_hd__tapvpwrvgnd_1
X_8356_ _8518_/CLK _8356_/D load_slew704/X VGND VGND VPWR VPWR _8356_/Q sky130_fd_sc_hd__dfrtp_2
X_5568_ _7829_/Q _4723_/A _5570_/S VGND VGND VPWR VPWR _5569_/A sky130_fd_sc_hd__mux2_2
XFILLER_104_212 VGND VGND VPWR VPWR sky130_fd_sc_hd__decap_3
XFILLER_105_735 VGND VGND VPWR VPWR sky130_fd_sc_hd__fill_1
XFILLER_117_573 VGND VGND VPWR VPWR sky130_fd_sc_hd__fill_1
XFILLER_132_510 VGND VGND VPWR VPWR sky130_fd_sc_hd__decap_3
XFILLER_2_306 VGND VGND VPWR VPWR sky130_fd_sc_hd__fill_2
XFILLER_88_29 VGND VGND VPWR VPWR sky130_fd_sc_hd__fill_2
X_8287_ _8756_/CLK _8287_/D fanout725/X VGND VGND VPWR VPWR _8287_/Q sky130_fd_sc_hd__dfrtp_2
X_7307_ _8713_/Q input5/X _7323_/S VGND VGND VPWR VPWR _7308_/A sky130_fd_sc_hd__mux2_2
X_4519_ _4519_/A VGND VGND VPWR VPWR _4519_/X sky130_fd_sc_hd__buf_1
XFILLER_104_245 VGND VGND VPWR VPWR sky130_fd_sc_hd__decap_3
XFILLER_104_256 VGND VGND VPWR VPWR sky130_fd_sc_hd__decap_3
XFILLER_105_768 VGND VGND VPWR VPWR sky130_fd_sc_hd__fill_1
XFILLER_132_554 VGND VGND VPWR VPWR sky130_fd_sc_hd__decap_3
X_7238_ _7228_/X _4799_/X _7230_/X _7231_/X hold857/X VGND VGND VPWR VPWR _8667_/D
+ sky130_fd_sc_hd__a32o_2
X_5499_ _7797_/Q _4928_/A _5503_/S VGND VGND VPWR VPWR _5500_/A sky130_fd_sc_hd__mux2_2
XFILLER_104_289 VGND VGND VPWR VPWR sky130_fd_sc_hd__decap_3
XFILLER_132_587 VGND VGND VPWR VPWR sky130_fd_sc_hd__fill_1
XFILLER_132_598 VGND VGND VPWR VPWR sky130_fd_sc_hd__decap_3
XTAP_TAPCELL_ROW_113_1871 VGND VPWR sky130_fd_sc_hd__tapvpwrvgnd_1
Xfanout632 fanout634/X VGND VGND VPWR VPWR fanout632/X sky130_fd_sc_hd__clkdlybuf4s25_1
Xfanout643 fanout653/X VGND VGND VPWR VPWR fanout643/X sky130_fd_sc_hd__clkdlybuf4s25_1
Xfanout654 wire657/X VGND VGND VPWR VPWR fanout654/X sky130_fd_sc_hd__clkdlybuf4s25_1
Xfanout665 fanout685/X VGND VGND VPWR VPWR fanout665/X sky130_fd_sc_hd__clkdlybuf4s25_1
X_7169_ _7169_/A VGND VGND VPWR VPWR _8617_/D sky130_fd_sc_hd__buf_2
XFILLER_58_365 VGND VGND VPWR VPWR sky130_fd_sc_hd__fill_1
XTAP_TAPCELL_ROW_29_703 VGND VPWR sky130_fd_sc_hd__tapvpwrvgnd_1
Xfanout698 wire701/X VGND VGND VPWR VPWR fanout698/X sky130_fd_sc_hd__clkdlybuf4s25_1
XFILLER_18_229 VGND VGND VPWR VPWR sky130_fd_sc_hd__fill_2
XFILLER_37_66 VGND VGND VPWR VPWR sky130_fd_sc_hd__fill_1
XFILLER_73_335 VGND VGND VPWR VPWR sky130_fd_sc_hd__fill_1
XFILLER_37_88 VGND VGND VPWR VPWR sky130_fd_sc_hd__decap_3
XFILLER_26_262 VGND VGND VPWR VPWR sky130_fd_sc_hd__decap_3
XFILLER_54_582 VGND VGND VPWR VPWR sky130_fd_sc_hd__decap_3
XFILLER_42_755 VGND VGND VPWR VPWR sky130_fd_sc_hd__fill_1
XFILLER_53_87 VGND VGND VPWR VPWR sky130_fd_sc_hd__decap_3
XFILLER_10_663 VGND VGND VPWR VPWR sky130_fd_sc_hd__decap_3
XFILLER_6_601 VGND VGND VPWR VPWR sky130_fd_sc_hd__decap_3
XFILLER_10_696 VGND VGND VPWR VPWR sky130_fd_sc_hd__decap_3
XFILLER_127_337 VGND VGND VPWR VPWR sky130_fd_sc_hd__decap_3
XFILLER_5_122 VGND VGND VPWR VPWR sky130_fd_sc_hd__decap_3
XFILLER_6_634 VGND VGND VPWR VPWR sky130_fd_sc_hd__decap_3
XFILLER_6_645 VGND VGND VPWR VPWR sky130_fd_sc_hd__decap_3
XFILLER_6_678 VGND VGND VPWR VPWR sky130_fd_sc_hd__decap_3
XTAP_TAPCELL_ROW_75_1343 VGND VPWR sky130_fd_sc_hd__tapvpwrvgnd_1
XFILLER_123_532 VGND VGND VPWR VPWR sky130_fd_sc_hd__decap_3
XFILLER_96_416 VGND VGND VPWR VPWR sky130_fd_sc_hd__decap_3
XFILLER_96_427 VGND VGND VPWR VPWR sky130_fd_sc_hd__decap_3
XFILLER_49_310 VGND VGND VPWR VPWR sky130_fd_sc_hd__decap_3
XFILLER_49_332 VGND VGND VPWR VPWR sky130_fd_sc_hd__fill_1
XFILLER_77_663 VGND VGND VPWR VPWR sky130_fd_sc_hd__fill_1
XFILLER_64_324 VGND VGND VPWR VPWR sky130_fd_sc_hd__fill_1
XFILLER_76_173 VGND VGND VPWR VPWR sky130_fd_sc_hd__fill_1
XFILLER_92_611 VGND VGND VPWR VPWR sky130_fd_sc_hd__decap_3
XFILLER_94_61 VGND VGND VPWR VPWR sky130_fd_sc_hd__decap_3
XFILLER_94_72 VGND VGND VPWR VPWR sky130_fd_sc_hd__decap_3
XFILLER_18_730 VGND VGND VPWR VPWR sky130_fd_sc_hd__decap_3
XFILLER_76_195 VGND VGND VPWR VPWR sky130_fd_sc_hd__fill_1
XFILLER_91_154 VGND VGND VPWR VPWR sky130_fd_sc_hd__fill_1
XFILLER_94_94 VGND VGND VPWR VPWR sky130_fd_sc_hd__fill_2
XFILLER_17_251 VGND VGND VPWR VPWR sky130_fd_sc_hd__decap_3
XFILLER_91_187 VGND VGND VPWR VPWR sky130_fd_sc_hd__decap_3
XFILLER_92_699 VGND VGND VPWR VPWR sky130_fd_sc_hd__fill_1
XFILLER_32_232 VGND VGND VPWR VPWR sky130_fd_sc_hd__decap_3
XTAP_TAPCELL_ROW_86_1494 VGND VPWR sky130_fd_sc_hd__tapvpwrvgnd_1
X_4870_ _4870_/A _4902_/B VGND VGND VPWR VPWR _4871_/A sky130_fd_sc_hd__and2_2
XFILLER_33_788 VGND VGND VPWR VPWR sky130_fd_sc_hd__fill_2
X_3821_ _3865_/S _3815_/X _3818_/X _4605_/A1 VGND VGND VPWR VPWR _3821_/X sky130_fd_sc_hd__a31o_2
XFILLER_20_416 VGND VGND VPWR VPWR sky130_fd_sc_hd__decap_3
XFILLER_20_427 VGND VGND VPWR VPWR sky130_fd_sc_hd__fill_2
XFILLER_33_799 VGND VGND VPWR VPWR sky130_fd_sc_hd__decap_3
XTAP_TAPCELL_ROW_15_496 VGND VPWR sky130_fd_sc_hd__tapvpwrvgnd_1
X_6540_ _6540_/A VGND VGND VPWR VPWR _8321_/D sky130_fd_sc_hd__buf_2
X_3752_ _3889_/A VGND VGND VPWR VPWR _3752_/X sky130_fd_sc_hd__clkbuf_2
XFILLER_9_494 VGND VGND VPWR VPWR sky130_fd_sc_hd__decap_3
X_6471_ _6471_/A VGND VGND VPWR VPWR _8289_/D sky130_fd_sc_hd__buf_2
X_8210_ _8777_/CLK _8210_/D fanout743/X VGND VGND VPWR VPWR _8210_/Q sky130_fd_sc_hd__dfrtp_2
X_5422_ _7760_/Q _4772_/A _5440_/S VGND VGND VPWR VPWR _5423_/A sky130_fd_sc_hd__mux2_2
XFILLER_133_329 VGND VGND VPWR VPWR sky130_fd_sc_hd__decap_3
X_8141_ _8783_/CLK _8141_/D wire680/X VGND VGND VPWR VPWR _8141_/Q sky130_fd_sc_hd__dfrtp_2
X_5353_ _5353_/A VGND VGND VPWR VPWR _7727_/D sky130_fd_sc_hd__buf_1
XFILLER_114_543 VGND VGND VPWR VPWR sky130_fd_sc_hd__decap_3
X_4304_ _4330_/A _4302_/X _4303_/X VGND VGND VPWR VPWR _4304_/X sky130_fd_sc_hd__o21a_2
XFILLER_114_565 VGND VGND VPWR VPWR sky130_fd_sc_hd__decap_3
XFILLER_114_587 VGND VGND VPWR VPWR sky130_fd_sc_hd__fill_1
XFILLER_99_287 VGND VGND VPWR VPWR sky130_fd_sc_hd__decap_3
X_8072_ _8796_/CLK _8072_/D fanout609/X VGND VGND VPWR VPWR _8072_/Q sky130_fd_sc_hd__dfrtp_2
X_5284_ _5284_/A VGND VGND VPWR VPWR _7695_/D sky130_fd_sc_hd__buf_1
XFILLER_101_215 VGND VGND VPWR VPWR sky130_fd_sc_hd__decap_3
XFILLER_114_598 VGND VGND VPWR VPWR sky130_fd_sc_hd__decap_3
XFILLER_87_438 VGND VGND VPWR VPWR sky130_fd_sc_hd__decap_3
X_7023_ _4981_/X _8548_/Q _7025_/S VGND VGND VPWR VPWR _7024_/A sky130_fd_sc_hd__mux2_2
X_4235_ _8095_/Q _8176_/Q _8257_/Q _8338_/Q _4226_/S _4227_/A VGND VGND VPWR VPWR
+ _4235_/X sky130_fd_sc_hd__mux4_2
X_4166_ _8088_/Q _8169_/Q _8250_/Q _8331_/Q _4166_/S0 _4166_/S1 VGND VGND VPWR VPWR
+ _4166_/X sky130_fd_sc_hd__mux4_2
XFILLER_55_302 VGND VGND VPWR VPWR sky130_fd_sc_hd__fill_1
XFILLER_55_324 VGND VGND VPWR VPWR sky130_fd_sc_hd__decap_3
XFILLER_68_696 VGND VGND VPWR VPWR sky130_fd_sc_hd__decap_3
XFILLER_82_110 VGND VGND VPWR VPWR sky130_fd_sc_hd__decap_3
XFILLER_95_482 VGND VGND VPWR VPWR sky130_fd_sc_hd__decap_3
XFILLER_55_346 VGND VGND VPWR VPWR sky130_fd_sc_hd__decap_3
X_4097_ _7667_/Q _4399_/A2 _3775_/X _7586_/Q _3776_/X VGND VGND VPWR VPWR _4097_/X
+ sky130_fd_sc_hd__o221a_2
XFILLER_130_15 VGND VGND VPWR VPWR sky130_fd_sc_hd__decap_3
XFILLER_36_560 VGND VGND VPWR VPWR sky130_fd_sc_hd__decap_3
XFILLER_82_154 VGND VGND VPWR VPWR sky130_fd_sc_hd__fill_1
X_7925_ _8745_/CLK _7925_/D wire618/X VGND VGND VPWR VPWR _7925_/Q sky130_fd_sc_hd__dfrtp_2
XFILLER_130_59 VGND VGND VPWR VPWR sky130_fd_sc_hd__decap_3
XFILLER_51_541 VGND VGND VPWR VPWR sky130_fd_sc_hd__fill_2
X_7856_ _8757_/CLK _7856_/D fanout715/X VGND VGND VPWR VPWR _7856_/Q sky130_fd_sc_hd__dfrtp_2
XFILLER_23_243 VGND VGND VPWR VPWR sky130_fd_sc_hd__decap_3
X_6807_ _8447_/Q _4894_/A _6807_/S VGND VGND VPWR VPWR _6808_/A sky130_fd_sc_hd__mux2_2
XFILLER_23_287 VGND VGND VPWR VPWR sky130_fd_sc_hd__fill_1
XFILLER_23_35 VGND VGND VPWR VPWR sky130_fd_sc_hd__decap_3
XTAP_TAPCELL_ROW_34_772 VGND VPWR sky130_fd_sc_hd__tapvpwrvgnd_1
X_7787_ _8683_/CLK _7787_/D fanout564/X VGND VGND VPWR VPWR _7787_/Q sky130_fd_sc_hd__dfrtp_2
X_4999_ _4999_/A VGND VGND VPWR VPWR _4999_/X sky130_fd_sc_hd__buf_1
XFILLER_23_57 VGND VGND VPWR VPWR sky130_fd_sc_hd__decap_3
XFILLER_7_409 VGND VGND VPWR VPWR sky130_fd_sc_hd__decap_3
X_6738_ _8414_/Q _4756_/A _6744_/S VGND VGND VPWR VPWR _6739_/A sky130_fd_sc_hd__mux2_2
XFILLER_128_6 VGND VGND VPWR VPWR sky130_fd_sc_hd__decap_3
X_6669_ _8381_/Q _4960_/A _6681_/S VGND VGND VPWR VPWR _6670_/A sky130_fd_sc_hd__mux2_2
XTAP_TAPCELL_ROW_115_1900 VGND VPWR sky130_fd_sc_hd__tapvpwrvgnd_1
X_8408_ _8732_/CLK _8408_/D fanout479/X VGND VGND VPWR VPWR _8408_/Q sky130_fd_sc_hd__dfrtp_2
XFILLER_124_318 VGND VGND VPWR VPWR sky130_fd_sc_hd__fill_1
XFILLER_2_103 VGND VGND VPWR VPWR sky130_fd_sc_hd__decap_3
XFILLER_3_604 VGND VGND VPWR VPWR sky130_fd_sc_hd__decap_3
XFILLER_3_626 VGND VGND VPWR VPWR sky130_fd_sc_hd__decap_3
X_8339_ _8427_/CLK _8339_/D fanout632/X VGND VGND VPWR VPWR _8339_/Q sky130_fd_sc_hd__dfrtp_2
XFILLER_132_340 VGND VGND VPWR VPWR sky130_fd_sc_hd__decap_3
XFILLER_3_659 VGND VGND VPWR VPWR sky130_fd_sc_hd__decap_3
XTAP_TAPCELL_ROW_57_1084 VGND VPWR sky130_fd_sc_hd__tapvpwrvgnd_1
XTAP_TAPCELL_ROW_57_1095 VGND VPWR sky130_fd_sc_hd__tapvpwrvgnd_1
XFILLER_48_32 VGND VGND VPWR VPWR sky130_fd_sc_hd__decap_3
XFILLER_120_557 VGND VGND VPWR VPWR sky130_fd_sc_hd__fill_1
XFILLER_19_505 VGND VGND VPWR VPWR sky130_fd_sc_hd__decap_3
XFILLER_47_803 VGND VGND VPWR VPWR sky130_fd_sc_hd__fill_1
XTAP_TAPCELL_ROW_70_1273 VGND VPWR sky130_fd_sc_hd__tapvpwrvgnd_1
Xfanout451 wire454/A VGND VGND VPWR VPWR _3861_/S sky130_fd_sc_hd__clkdlybuf4s25_1
XFILLER_100_270 VGND VGND VPWR VPWR sky130_fd_sc_hd__fill_1
XFILLER_101_782 VGND VGND VPWR VPWR sky130_fd_sc_hd__fill_2
XFILLER_58_162 VGND VGND VPWR VPWR sky130_fd_sc_hd__decap_3
Xfanout495 fanout497/X VGND VGND VPWR VPWR fanout495/X sky130_fd_sc_hd__clkdlybuf4s25_1
XFILLER_100_281 VGND VGND VPWR VPWR sky130_fd_sc_hd__decap_3
XPHY_EDGE_ROW_100_Left_236 VGND VGND VPWR VPWR sky130_fd_sc_hd__decap_3
XFILLER_27_571 VGND VGND VPWR VPWR sky130_fd_sc_hd__decap_3
XFILLER_34_519 VGND VGND VPWR VPWR sky130_fd_sc_hd__decap_3
XFILLER_73_165 VGND VGND VPWR VPWR sky130_fd_sc_hd__decap_3
XFILLER_74_699 VGND VGND VPWR VPWR sky130_fd_sc_hd__fill_1
XFILLER_14_265 VGND VGND VPWR VPWR sky130_fd_sc_hd__decap_3
XFILLER_42_563 VGND VGND VPWR VPWR sky130_fd_sc_hd__decap_3
XFILLER_9_15 VGND VGND VPWR VPWR sky130_fd_sc_hd__decap_3
XFILLER_120_81 VGND VGND VPWR VPWR sky130_fd_sc_hd__decap_3
XFILLER_9_48 VGND VGND VPWR VPWR sky130_fd_sc_hd__decap_3
XFILLER_128_613 VGND VGND VPWR VPWR sky130_fd_sc_hd__decap_3
XFILLER_80_52 VGND VGND VPWR VPWR sky130_fd_sc_hd__fill_2
XFILLER_80_63 VGND VGND VPWR VPWR sky130_fd_sc_hd__fill_1
XTAP_TAPCELL_ROW_12_455 VGND VPWR sky130_fd_sc_hd__tapvpwrvgnd_1
XTAP_TAPCELL_ROW_12_466 VGND VPWR sky130_fd_sc_hd__tapvpwrvgnd_1
XFILLER_127_156 VGND VGND VPWR VPWR sky130_fd_sc_hd__decap_3
XFILLER_128_657 VGND VGND VPWR VPWR sky130_fd_sc_hd__decap_3
XFILLER_13_90 VGND VGND VPWR VPWR sky130_fd_sc_hd__decap_3
XFILLER_127_178 VGND VGND VPWR VPWR sky130_fd_sc_hd__decap_3
XFILLER_129_90 VGND VGND VPWR VPWR sky130_fd_sc_hd__decap_3
XFILLER_6_464 VGND VGND VPWR VPWR sky130_fd_sc_hd__decap_3
XFILLER_123_340 VGND VGND VPWR VPWR sky130_fd_sc_hd__fill_1
XFILLER_69_416 VGND VGND VPWR VPWR sky130_fd_sc_hd__decap_3
XFILLER_2_681 VGND VGND VPWR VPWR sky130_fd_sc_hd__decap_3
XFILLER_69_449 VGND VGND VPWR VPWR sky130_fd_sc_hd__decap_3
XFILLER_96_235 VGND VGND VPWR VPWR sky130_fd_sc_hd__fill_1
XFILLER_49_140 VGND VGND VPWR VPWR sky130_fd_sc_hd__decap_3
XFILLER_65_600 VGND VGND VPWR VPWR sky130_fd_sc_hd__decap_3
XFILLER_84_408 VGND VGND VPWR VPWR sky130_fd_sc_hd__decap_3
X_4020_ _8074_/Q _8155_/Q _8236_/Q _8317_/Q _3719_/C _3705_/C VGND VGND VPWR VPWR
+ _4020_/X sky130_fd_sc_hd__mux4_2
XFILLER_49_162 VGND VGND VPWR VPWR sky130_fd_sc_hd__decap_3
XTAP_TAPCELL_ROW_88_1523 VGND VPWR sky130_fd_sc_hd__tapvpwrvgnd_1
XFILLER_37_335 VGND VGND VPWR VPWR sky130_fd_sc_hd__fill_1
XFILLER_64_121 VGND VGND VPWR VPWR sky130_fd_sc_hd__decap_3
XFILLER_65_655 VGND VGND VPWR VPWR sky130_fd_sc_hd__decap_3
XFILLER_92_430 VGND VGND VPWR VPWR sky130_fd_sc_hd__fill_2
XFILLER_80_614 VGND VGND VPWR VPWR sky130_fd_sc_hd__decap_3
X_5971_ _6139_/S VGND VGND VPWR VPWR _5990_/S sky130_fd_sc_hd__buf_2
XFILLER_80_658 VGND VGND VPWR VPWR sky130_fd_sc_hd__decap_3
X_8690_ _8771_/CLK _8690_/D load_slew570/X VGND VGND VPWR VPWR _8690_/Q sky130_fd_sc_hd__dfrtp_2
X_7710_ _8693_/CLK _7710_/D load_slew740/X VGND VGND VPWR VPWR _7710_/Q sky130_fd_sc_hd__dfrtp_2
X_4922_ _4921_/X _4922_/A1 _7453_/S VGND VGND VPWR VPWR _4923_/A sky130_fd_sc_hd__mux2_2
X_7641_ _8627_/CLK _7641_/D load_slew667/X VGND VGND VPWR VPWR _7641_/Q sky130_fd_sc_hd__dfrtp_2
XFILLER_100_29 VGND VGND VPWR VPWR sky130_fd_sc_hd__decap_3
XTAP_TAPCELL_ROW_31_720 VGND VPWR sky130_fd_sc_hd__tapvpwrvgnd_1
X_4853_ _4853_/A VGND VGND VPWR VPWR _4853_/X sky130_fd_sc_hd__buf_1
XTAP_TAPCELL_ROW_31_731 VGND VPWR sky130_fd_sc_hd__tapvpwrvgnd_1
X_3804_ _3817_/A VGND VGND VPWR VPWR _3805_/A sky130_fd_sc_hd__clkbuf_2
X_7572_ _8800_/CLK _7572_/D load_slew593/X VGND VGND VPWR VPWR _7572_/Q sky130_fd_sc_hd__dfrtp_2
X_4784_ _4782_/X _7519_/Q _4820_/S VGND VGND VPWR VPWR _4785_/A sky130_fd_sc_hd__mux2_2
X_3735_ _4460_/A VGND VGND VPWR VPWR _3735_/X sky130_fd_sc_hd__clkbuf_2
X_6523_ _6523_/A VGND VGND VPWR VPWR _8313_/D sky130_fd_sc_hd__buf_2
XFILLER_119_679 VGND VGND VPWR VPWR sky130_fd_sc_hd__decap_3
XFILLER_9_291 VGND VGND VPWR VPWR sky130_fd_sc_hd__decap_3
XTAP_TAPCELL_ROW_99_1674 VGND VPWR sky130_fd_sc_hd__tapvpwrvgnd_1
XTAP_TAPCELL_ROW_99_1685 VGND VPWR sky130_fd_sc_hd__tapvpwrvgnd_1
X_6454_ _6454_/A VGND VGND VPWR VPWR _8281_/D sky130_fd_sc_hd__buf_2
XFILLER_118_178 VGND VGND VPWR VPWR sky130_fd_sc_hd__fill_2
XFILLER_134_616 VGND VGND VPWR VPWR sky130_fd_sc_hd__fill_1
XFILLER_134_638 VGND VGND VPWR VPWR sky130_fd_sc_hd__decap_3
Xclkload50 _8624_/CLK VGND VGND VPWR VPWR clkload50/X sky130_fd_sc_hd__clkbuf_4
Xclkload61 _8785_/CLK VGND VGND VPWR VPWR clkload61/Y sky130_fd_sc_hd__clkinv_2
X_5405_ _7752_/Q _4739_/A _5419_/S VGND VGND VPWR VPWR _5406_/A sky130_fd_sc_hd__mux2_2
XFILLER_133_137 VGND VGND VPWR VPWR sky130_fd_sc_hd__decap_3
Xclkload72 _8757_/CLK VGND VGND VPWR VPWR clkload72/X sky130_fd_sc_hd__clkbuf_4
X_6385_ _6385_/A VGND VGND VPWR VPWR _8248_/D sky130_fd_sc_hd__buf_2
XFILLER_102_502 VGND VGND VPWR VPWR sky130_fd_sc_hd__decap_3
XFILLER_125_15 VGND VGND VPWR VPWR sky130_fd_sc_hd__decap_3
XFILLER_88_725 VGND VGND VPWR VPWR sky130_fd_sc_hd__decap_3
Xclkbuf_leaf_142_CLK clkbuf_leaf_1_CLK/A VGND VGND VPWR VPWR _8655_/CLK sky130_fd_sc_hd__clkbuf_8
X_8124_ _8694_/CLK _8124_/D fanout719/X VGND VGND VPWR VPWR _8124_/Q sky130_fd_sc_hd__dfrtp_2
X_5336_ _5336_/A VGND VGND VPWR VPWR _5463_/A sky130_fd_sc_hd__clkbuf_1
XFILLER_114_384 VGND VGND VPWR VPWR sky130_fd_sc_hd__decap_3
XFILLER_125_48 VGND VGND VPWR VPWR sky130_fd_sc_hd__decap_3
XTAP_TAPCELL_ROW_110_1830 VGND VPWR sky130_fd_sc_hd__tapvpwrvgnd_1
X_8055_ _8792_/CLK _8055_/D fanout656/A VGND VGND VPWR VPWR _8055_/Q sky130_fd_sc_hd__dfrtp_2
X_5267_ _5267_/A VGND VGND VPWR VPWR _7687_/D sky130_fd_sc_hd__buf_1
XFILLER_102_557 VGND VGND VPWR VPWR sky130_fd_sc_hd__decap_3
XFILLER_29_803 VGND VGND VPWR VPWR sky130_fd_sc_hd__fill_1
XFILLER_87_246 VGND VGND VPWR VPWR sky130_fd_sc_hd__decap_3
X_7006_ _7174_/S VGND VGND VPWR VPWR _7025_/S sky130_fd_sc_hd__buf_4
X_4218_ _8741_/Q _7516_/Q _7597_/Q _7678_/Q _4226_/S _4227_/A VGND VGND VPWR VPWR
+ _4218_/X sky130_fd_sc_hd__mux4_2
XFILLER_18_24 VGND VGND VPWR VPWR sky130_fd_sc_hd__decap_3
XFILLER_18_35 VGND VGND VPWR VPWR sky130_fd_sc_hd__decap_3
XFILLER_28_302 VGND VGND VPWR VPWR sky130_fd_sc_hd__decap_3
X_5198_ _5198_/A VGND VGND VPWR VPWR _7654_/D sky130_fd_sc_hd__buf_1
XFILLER_18_68 VGND VGND VPWR VPWR sky130_fd_sc_hd__decap_3
XFILLER_56_666 VGND VGND VPWR VPWR sky130_fd_sc_hd__decap_3
XFILLER_83_441 VGND VGND VPWR VPWR sky130_fd_sc_hd__decap_3
XTAP_TAPCELL_ROW_126_2059 VGND VPWR sky130_fd_sc_hd__tapvpwrvgnd_1
XTAP_TAPCELL_ROW_39_842 VGND VPWR sky130_fd_sc_hd__tapvpwrvgnd_1
X_4149_ _4146_/X _4147_/X _4148_/X _4335_/A VGND VGND VPWR VPWR _4149_/X sky130_fd_sc_hd__a22o_2
XFILLER_28_379 VGND VGND VPWR VPWR sky130_fd_sc_hd__decap_3
XFILLER_43_316 VGND VGND VPWR VPWR sky130_fd_sc_hd__decap_3
X_7908_ _8727_/CLK _7908_/D load_slew533/X VGND VGND VPWR VPWR _7908_/Q sky130_fd_sc_hd__dfrtp_2
XFILLER_11_213 VGND VGND VPWR VPWR sky130_fd_sc_hd__fill_2
XFILLER_12_747 VGND VGND VPWR VPWR sky130_fd_sc_hd__decap_3
X_7839_ _8748_/CLK _7839_/D fanout539/X VGND VGND VPWR VPWR _7839_/Q sky130_fd_sc_hd__dfrtp_2
XFILLER_11_257 VGND VGND VPWR VPWR sky130_fd_sc_hd__decap_3
XFILLER_12_769 VGND VGND VPWR VPWR sky130_fd_sc_hd__decap_3
XFILLER_51_393 VGND VGND VPWR VPWR sky130_fd_sc_hd__decap_3
XFILLER_8_707 VGND VGND VPWR VPWR sky130_fd_sc_hd__decap_3
XTAP_TAPCELL_ROW_121_1981 VGND VPWR sky130_fd_sc_hd__tapvpwrvgnd_1
XTAP_TAPCELL_ROW_121_1992 VGND VPWR sky130_fd_sc_hd__tapvpwrvgnd_1
XFILLER_126_3 VGND VGND VPWR VPWR sky130_fd_sc_hd__decap_3
XFILLER_7_239 VGND VGND VPWR VPWR sky130_fd_sc_hd__decap_3
Xclkload0 clkload0/A VGND VGND VPWR VPWR clkload0/X sky130_fd_sc_hd__clkbuf_8
XFILLER_50_55 VGND VGND VPWR VPWR sky130_fd_sc_hd__fill_1
XTAP_TAPCELL_ROW_59_1113 VGND VPWR sky130_fd_sc_hd__tapvpwrvgnd_1
XTAP_TAPCELL_ROW_59_1124 VGND VPWR sky130_fd_sc_hd__tapvpwrvgnd_1
XFILLER_125_638 VGND VGND VPWR VPWR sky130_fd_sc_hd__fill_2
XFILLER_50_77 VGND VGND VPWR VPWR sky130_fd_sc_hd__decap_3
XFILLER_124_137 VGND VGND VPWR VPWR sky130_fd_sc_hd__decap_3
XFILLER_105_351 VGND VGND VPWR VPWR sky130_fd_sc_hd__decap_3
XFILLER_133_671 VGND VGND VPWR VPWR sky130_fd_sc_hd__fill_1
XFILLER_79_725 VGND VGND VPWR VPWR sky130_fd_sc_hd__decap_3
XTAP_TAPCELL_ROW_72_1302 VGND VPWR sky130_fd_sc_hd__tapvpwrvgnd_1
Xclkbuf_leaf_133_CLK clkload2/A VGND VGND VPWR VPWR _8410_/CLK sky130_fd_sc_hd__clkbuf_8
XFILLER_120_321 VGND VGND VPWR VPWR sky130_fd_sc_hd__decap_3
XFILLER_133_682 VGND VGND VPWR VPWR sky130_fd_sc_hd__decap_3
XFILLER_59_53 VGND VGND VPWR VPWR sky130_fd_sc_hd__decap_3
XFILLER_132_192 VGND VGND VPWR VPWR sky130_fd_sc_hd__decap_3
XFILLER_59_97 VGND VGND VPWR VPWR sky130_fd_sc_hd__fill_1
Xfanout281 _4300_/A1 VGND VGND VPWR VPWR _3733_/A sky130_fd_sc_hd__clkdlybuf4s25_1
XFILLER_47_633 VGND VGND VPWR VPWR sky130_fd_sc_hd__decap_3
XFILLER_75_63 VGND VGND VPWR VPWR sky130_fd_sc_hd__fill_2
XFILLER_19_368 VGND VGND VPWR VPWR sky130_fd_sc_hd__decap_3
XFILLER_74_463 VGND VGND VPWR VPWR sky130_fd_sc_hd__decap_3
XFILLER_34_338 VGND VGND VPWR VPWR sky130_fd_sc_hd__fill_2
XFILLER_62_636 VGND VGND VPWR VPWR sky130_fd_sc_hd__decap_3
XTAP_TAPCELL_ROW_17_525 VGND VPWR sky130_fd_sc_hd__tapvpwrvgnd_1
XTAP_TAPCELL_ROW_17_536 VGND VPWR sky130_fd_sc_hd__tapvpwrvgnd_1
XTAP_TAPCELL_ROW_83_1453 VGND VPWR sky130_fd_sc_hd__tapvpwrvgnd_1
XFILLER_15_585 VGND VGND VPWR VPWR sky130_fd_sc_hd__decap_3
XFILLER_30_500 VGND VGND VPWR VPWR sky130_fd_sc_hd__fill_1
XFILLER_30_533 VGND VGND VPWR VPWR sky130_fd_sc_hd__fill_2
XFILLER_128_421 VGND VGND VPWR VPWR sky130_fd_sc_hd__decap_3
XFILLER_11_780 VGND VGND VPWR VPWR sky130_fd_sc_hd__decap_3
XFILLER_11_791 VGND VGND VPWR VPWR sky130_fd_sc_hd__decap_3
XFILLER_128_454 VGND VGND VPWR VPWR sky130_fd_sc_hd__decap_3
XFILLER_128_498 VGND VGND VPWR VPWR sky130_fd_sc_hd__decap_3
XFILLER_7_762 VGND VGND VPWR VPWR sky130_fd_sc_hd__decap_3
Xwire693 wire693/A VGND VGND VPWR VPWR wire693/X sky130_fd_sc_hd__clkbuf_4
Xclkbuf_leaf_124_CLK clkbuf_leaf_91_CLK/A VGND VGND VPWR VPWR _8668_/CLK sky130_fd_sc_hd__clkbuf_8
X_6170_ _4999_/X _8147_/Q _6184_/S VGND VGND VPWR VPWR _6171_/A sky130_fd_sc_hd__mux2_4
XFILLER_123_181 VGND VGND VPWR VPWR sky130_fd_sc_hd__fill_1
XFILLER_130_118 VGND VGND VPWR VPWR sky130_fd_sc_hd__decap_3
Xload_slew621 fanout620/X VGND VGND VPWR VPWR load_slew621/X sky130_fd_sc_hd__clkbuf_4
Xload_slew610 fanout609/X VGND VGND VPWR VPWR fanout607/A sky130_fd_sc_hd__buf_2
X_5121_ _4861_/X _7619_/Q _5137_/S VGND VGND VPWR VPWR _5122_/A sky130_fd_sc_hd__mux2_2
XFILLER_111_343 VGND VGND VPWR VPWR sky130_fd_sc_hd__decap_3
XFILLER_57_408 VGND VGND VPWR VPWR sky130_fd_sc_hd__decap_3
XFILLER_69_268 VGND VGND VPWR VPWR sky130_fd_sc_hd__fill_2
XFILLER_97_555 VGND VGND VPWR VPWR sky130_fd_sc_hd__decap_3
XFILLER_111_387 VGND VGND VPWR VPWR sky130_fd_sc_hd__fill_2
XFILLER_69_279 VGND VGND VPWR VPWR sky130_fd_sc_hd__fill_1
XPHY_EDGE_ROW_127_Right_127 VGND VGND VPWR VPWR sky130_fd_sc_hd__decap_3
Xload_slew687 fanout686/X VGND VGND VPWR VPWR load_slew687/X sky130_fd_sc_hd__buf_4
Xload_slew676 fanout675/X VGND VGND VPWR VPWR load_slew676/X sky130_fd_sc_hd__buf_4
X_5052_ _5052_/A VGND VGND VPWR VPWR _7586_/D sky130_fd_sc_hd__buf_1
X_4003_ _4467_/A1 _3998_/X _4000_/X _4002_/X VGND VGND VPWR VPWR _4003_/X sky130_fd_sc_hd__a22o_2
XFILLER_1_60 VGND VGND VPWR VPWR sky130_fd_sc_hd__decap_3
XFILLER_37_143 VGND VGND VPWR VPWR sky130_fd_sc_hd__decap_3
XFILLER_37_165 VGND VGND VPWR VPWR sky130_fd_sc_hd__decap_3
XFILLER_53_603 VGND VGND VPWR VPWR sky130_fd_sc_hd__fill_2
XFILLER_65_452 VGND VGND VPWR VPWR sky130_fd_sc_hd__fill_1
XFILLER_93_783 VGND VGND VPWR VPWR sky130_fd_sc_hd__fill_1
XTAP_TAPCELL_ROW_36_801 VGND VPWR sky130_fd_sc_hd__tapvpwrvgnd_1
XFILLER_1_93 VGND VGND VPWR VPWR sky130_fd_sc_hd__decap_3
XFILLER_37_187 VGND VGND VPWR VPWR sky130_fd_sc_hd__decap_3
XFILLER_92_271 VGND VGND VPWR VPWR sky130_fd_sc_hd__decap_3
X_8742_ _8742_/CLK _8742_/D load_slew616/X VGND VGND VPWR VPWR _8742_/Q sky130_fd_sc_hd__dfrtp_2
XFILLER_18_390 VGND VGND VPWR VPWR sky130_fd_sc_hd__fill_2
XFILLER_53_669 VGND VGND VPWR VPWR sky130_fd_sc_hd__decap_3
X_5954_ _5946_/X _5958_/A2 _4921_/X _5958_/B1 hold822/X VGND VGND VPWR VPWR _8038_/D
+ sky130_fd_sc_hd__a32o_2
XFILLER_21_500 VGND VGND VPWR VPWR sky130_fd_sc_hd__decap_3
XFILLER_80_488 VGND VGND VPWR VPWR sky130_fd_sc_hd__fill_2
X_8673_ _8680_/CLK _8673_/D fanout694/X VGND VGND VPWR VPWR _8673_/Q sky130_fd_sc_hd__dfrtp_2
X_5885_ _5893_/A1 _5893_/A2 _5036_/X _5893_/B1 hold782/X VGND VGND VPWR VPWR _7984_/D
+ sky130_fd_sc_hd__a32o_2
X_4905_ _4905_/A VGND VGND VPWR VPWR _7548_/D sky130_fd_sc_hd__buf_1
XFILLER_21_533 VGND VGND VPWR VPWR sky130_fd_sc_hd__fill_1
X_7624_ _8768_/CLK _7624_/D fanout567/X VGND VGND VPWR VPWR _7624_/Q sky130_fd_sc_hd__dfrtp_2
X_4836_ _4836_/A _4852_/B VGND VGND VPWR VPWR _4837_/A sky130_fd_sc_hd__and2_2
X_7555_ _8780_/CLK _7555_/D load_slew722/X VGND VGND VPWR VPWR _7555_/Q sky130_fd_sc_hd__dfrtp_2
Xclkbuf_5_2__f_CLK clkbuf_4_1_0_CLK/X VGND VGND VPWR VPWR clkbuf_leaf_8_CLK/A sky130_fd_sc_hd__clkbuf_16
X_6506_ _6506_/A VGND VGND VPWR VPWR _8305_/D sky130_fd_sc_hd__buf_2
X_4767_ _4767_/A VGND VGND VPWR VPWR _7515_/D sky130_fd_sc_hd__buf_1
XFILLER_134_424 VGND VGND VPWR VPWR sky130_fd_sc_hd__decap_3
XFILLER_4_209 VGND VGND VPWR VPWR sky130_fd_sc_hd__decap_3
X_3718_ _7004_/A _7177_/A VGND VGND VPWR VPWR _8048_/D sky130_fd_sc_hd__xnor2_2
X_7486_ _7486_/A VGND VGND VPWR VPWR _8798_/D sky130_fd_sc_hd__buf_1
X_4698_ _6314_/A _7004_/B _7004_/C _5947_/A VGND VGND VPWR VPWR _7497_/S sky130_fd_sc_hd__nand4_2
XFILLER_106_126 VGND VGND VPWR VPWR sky130_fd_sc_hd__decap_3
XFILLER_134_457 VGND VGND VPWR VPWR sky130_fd_sc_hd__decap_3
XFILLER_20_47 VGND VGND VPWR VPWR sky130_fd_sc_hd__decap_3
X_6437_ _6437_/A VGND VGND VPWR VPWR _8273_/D sky130_fd_sc_hd__buf_2
XFILLER_103_800 VGND VGND VPWR VPWR sky130_fd_sc_hd__decap_3
Xclkbuf_leaf_115_CLK clkbuf_5_17__f_CLK/X VGND VGND VPWR VPWR _8744_/CLK sky130_fd_sc_hd__clkbuf_8
X_6368_ _6368_/A VGND VGND VPWR VPWR _8240_/D sky130_fd_sc_hd__buf_2
XFILLER_102_321 VGND VGND VPWR VPWR sky130_fd_sc_hd__decap_3
XFILLER_96_29 VGND VGND VPWR VPWR sky130_fd_sc_hd__decap_3
XTAP_TAPCELL_ROW_54_1043 VGND VPWR sky130_fd_sc_hd__tapvpwrvgnd_1
XTAP_TAPCELL_ROW_54_1054 VGND VPWR sky130_fd_sc_hd__tapvpwrvgnd_1
X_8107_ _8773_/CLK _8107_/D load_slew712/X VGND VGND VPWR VPWR _8107_/Q sky130_fd_sc_hd__dfrtp_2
X_5319_ _7712_/Q _4913_/X _5331_/S VGND VGND VPWR VPWR _5320_/A sky130_fd_sc_hd__mux2_2
XFILLER_130_663 VGND VGND VPWR VPWR sky130_fd_sc_hd__decap_3
XFILLER_29_12 VGND VGND VPWR VPWR sky130_fd_sc_hd__decap_3
X_6299_ _6299_/A VGND VGND VPWR VPWR _8208_/D sky130_fd_sc_hd__buf_6
XFILLER_102_365 VGND VGND VPWR VPWR sky130_fd_sc_hd__decap_3
XFILLER_130_696 VGND VGND VPWR VPWR sky130_fd_sc_hd__decap_3
XFILLER_29_45 VGND VGND VPWR VPWR sky130_fd_sc_hd__decap_3
XFILLER_29_611 VGND VGND VPWR VPWR sky130_fd_sc_hd__fill_1
XFILLER_75_216 VGND VGND VPWR VPWR sky130_fd_sc_hd__decap_3
X_8038_ _8698_/CLK _8038_/D load_slew748/X VGND VGND VPWR VPWR _8038_/Q sky130_fd_sc_hd__dfrtp_2
XFILLER_29_644 VGND VGND VPWR VPWR sky130_fd_sc_hd__decap_3
XFILLER_29_688 VGND VGND VPWR VPWR sky130_fd_sc_hd__decap_3
XFILLER_84_772 VGND VGND VPWR VPWR sky130_fd_sc_hd__fill_2
XFILLER_90_208 VGND VGND VPWR VPWR sky130_fd_sc_hd__fill_1
XFILLER_43_113 VGND VGND VPWR VPWR sky130_fd_sc_hd__decap_3
XFILLER_45_88 VGND VGND VPWR VPWR sky130_fd_sc_hd__decap_3
XFILLER_12_511 VGND VGND VPWR VPWR sky130_fd_sc_hd__decap_3
XFILLER_24_371 VGND VGND VPWR VPWR sky130_fd_sc_hd__decap_3
XFILLER_8_504 VGND VGND VPWR VPWR sky130_fd_sc_hd__decap_3
XFILLER_8_548 VGND VGND VPWR VPWR sky130_fd_sc_hd__decap_3
XTAP_TAPCELL_ROW_22_594 VGND VPWR sky130_fd_sc_hd__tapvpwrvgnd_1
XANTENNA_9 _4525_/S VGND VGND VPWR VPWR sky130_fd_sc_hd__diode_2
XFILLER_125_413 VGND VGND VPWR VPWR sky130_fd_sc_hd__fill_1
XFILLER_4_710 VGND VGND VPWR VPWR sky130_fd_sc_hd__decap_3
XFILLER_6_27 VGND VGND VPWR VPWR sky130_fd_sc_hd__fill_1
XFILLER_6_38 VGND VGND VPWR VPWR sky130_fd_sc_hd__decap_3
XFILLER_125_435 VGND VGND VPWR VPWR sky130_fd_sc_hd__decap_3
XFILLER_4_743 VGND VGND VPWR VPWR sky130_fd_sc_hd__decap_3
XFILLER_3_231 VGND VGND VPWR VPWR sky130_fd_sc_hd__fill_1
Xclkbuf_leaf_106_CLK clkbuf_5_20__f_CLK/X VGND VGND VPWR VPWR _8622_/CLK sky130_fd_sc_hd__clkbuf_8
XFILLER_10_80 VGND VGND VPWR VPWR sky130_fd_sc_hd__decap_3
XFILLER_10_91 VGND VGND VPWR VPWR sky130_fd_sc_hd__decap_3
XFILLER_4_787 VGND VGND VPWR VPWR sky130_fd_sc_hd__decap_3
XFILLER_126_80 VGND VGND VPWR VPWR sky130_fd_sc_hd__decap_3
XFILLER_126_91 VGND VGND VPWR VPWR sky130_fd_sc_hd__decap_3
XFILLER_39_419 VGND VGND VPWR VPWR sky130_fd_sc_hd__decap_3
XFILLER_86_62 VGND VGND VPWR VPWR sky130_fd_sc_hd__fill_2
XFILLER_86_73 VGND VGND VPWR VPWR sky130_fd_sc_hd__decap_3
XFILLER_94_536 VGND VGND VPWR VPWR sky130_fd_sc_hd__fill_1
XFILLER_19_121 VGND VGND VPWR VPWR sky130_fd_sc_hd__decap_3
XFILLER_86_95 VGND VGND VPWR VPWR sky130_fd_sc_hd__decap_3
XFILLER_19_165 VGND VGND VPWR VPWR sky130_fd_sc_hd__decap_3
XFILLER_81_219 VGND VGND VPWR VPWR sky130_fd_sc_hd__fill_1
XFILLER_19_187 VGND VGND VPWR VPWR sky130_fd_sc_hd__decap_3
XFILLER_47_496 VGND VGND VPWR VPWR sky130_fd_sc_hd__decap_3
XFILLER_62_466 VGND VGND VPWR VPWR sky130_fd_sc_hd__fill_1
XFILLER_34_168 VGND VGND VPWR VPWR sky130_fd_sc_hd__decap_3
XFILLER_62_477 VGND VGND VPWR VPWR sky130_fd_sc_hd__decap_3
XFILLER_15_393 VGND VGND VPWR VPWR sky130_fd_sc_hd__decap_3
XFILLER_30_330 VGND VGND VPWR VPWR sky130_fd_sc_hd__decap_3
XFILLER_42_190 VGND VGND VPWR VPWR sky130_fd_sc_hd__decap_3
X_5670_ _5670_/A VGND VGND VPWR VPWR _7877_/D sky130_fd_sc_hd__buf_1
XFILLER_30_363 VGND VGND VPWR VPWR sky130_fd_sc_hd__fill_1
XFILLER_89_3 VGND VGND VPWR VPWR sky130_fd_sc_hd__decap_3
XTAP_TAPCELL_ROW_41_870 VGND VPWR sky130_fd_sc_hd__tapvpwrvgnd_1
X_4621_ _4621_/A _4621_/B VGND VGND VPWR VPWR _4621_/X sky130_fd_sc_hd__or2_2
XFILLER_129_741 VGND VGND VPWR VPWR sky130_fd_sc_hd__decap_3
XFILLER_30_374 VGND VGND VPWR VPWR sky130_fd_sc_hd__decap_3
XFILLER_128_251 VGND VGND VPWR VPWR sky130_fd_sc_hd__fill_1
XFILLER_129_774 VGND VGND VPWR VPWR sky130_fd_sc_hd__decap_3
XFILLER_129_785 VGND VGND VPWR VPWR sky130_fd_sc_hd__decap_3
XTAP_TAPCELL_ROW_96_1633 VGND VPWR sky130_fd_sc_hd__tapvpwrvgnd_1
Xmax_cap201 _7270_/X VGND VGND VPWR VPWR _7280_/B1 sky130_fd_sc_hd__buf_2
X_7340_ _8729_/Q _4718_/A _7344_/S VGND VGND VPWR VPWR _7341_/A sky130_fd_sc_hd__mux2_2
X_4552_ _4552_/A1 _4550_/X _4551_/X VGND VGND VPWR VPWR _4552_/X sky130_fd_sc_hd__o21a_2
XFILLER_116_424 VGND VGND VPWR VPWR sky130_fd_sc_hd__decap_3
XFILLER_128_295 VGND VGND VPWR VPWR sky130_fd_sc_hd__decap_3
XFILLER_7_581 VGND VGND VPWR VPWR sky130_fd_sc_hd__decap_3
Xmax_cap223 _4764_/B VGND VGND VPWR VPWR _4776_/B sky130_fd_sc_hd__buf_2
Xmax_cap212 _5920_/X VGND VGND VPWR VPWR _5931_/A1 sky130_fd_sc_hd__buf_2
X_7271_ _7267_/X _4899_/X _7269_/X _7270_/X hold859/X VGND VGND VPWR VPWR _8691_/D
+ sky130_fd_sc_hd__a32o_2
X_4483_ _8116_/Q _8197_/Q _8278_/Q _8359_/Q _4528_/S _4531_/S1 VGND VGND VPWR VPWR
+ _4483_/X sky130_fd_sc_hd__mux4_2
Xmax_cap267 _3871_/X VGND VGND VPWR VPWR _4120_/A sky130_fd_sc_hd__buf_6
Xmax_cap256 _3775_/X VGND VGND VPWR VPWR _4645_/B1 sky130_fd_sc_hd__buf_6
Xmax_cap245 _3877_/X VGND VGND VPWR VPWR _4545_/B1 sky130_fd_sc_hd__buf_6
X_6222_ _4761_/X _8172_/Q _6226_/S VGND VGND VPWR VPWR _6223_/A sky130_fd_sc_hd__mux2_4
XFILLER_131_427 VGND VGND VPWR VPWR sky130_fd_sc_hd__decap_3
XFILLER_131_449 VGND VGND VPWR VPWR sky130_fd_sc_hd__decap_3
XFILLER_97_352 VGND VGND VPWR VPWR sky130_fd_sc_hd__decap_3
Xload_slew440 _4314_/S VGND VGND VPWR VPWR _4305_/S sky130_fd_sc_hd__buf_4
X_6153_ _4965_/X _8139_/Q _6163_/S VGND VGND VPWR VPWR _6154_/A sky130_fd_sc_hd__mux2_4
XFILLER_111_162 VGND VGND VPWR VPWR sky130_fd_sc_hd__decap_3
XFILLER_112_696 VGND VGND VPWR VPWR sky130_fd_sc_hd__decap_3
Xclkbuf_4_2_0_CLK clkbuf_0_CLK/X VGND VGND VPWR VPWR clkbuf_4_2_0_CLK/X sky130_fd_sc_hd__clkbuf_8
Xload_slew473 fanout472/X VGND VGND VPWR VPWR _4632_/S sky130_fd_sc_hd__clkbuf_4
Xload_slew462 _4414_/S VGND VGND VPWR VPWR _4402_/S sky130_fd_sc_hd__buf_4
X_6084_ _6084_/A VGND VGND VPWR VPWR _8107_/D sky130_fd_sc_hd__buf_1
X_5104_ _7248_/A2 _7611_/Q _5116_/S VGND VGND VPWR VPWR _5105_/A sky130_fd_sc_hd__mux2_2
XFILLER_111_184 VGND VGND VPWR VPWR sky130_fd_sc_hd__decap_3
XFILLER_85_547 VGND VGND VPWR VPWR sky130_fd_sc_hd__fill_1
XFILLER_97_396 VGND VGND VPWR VPWR sky130_fd_sc_hd__fill_1
Xload_slew484 fanout483/X VGND VGND VPWR VPWR load_slew484/X sky130_fd_sc_hd__buf_4
X_5035_ _5035_/A _5970_/B VGND VGND VPWR VPWR _5036_/A sky130_fd_sc_hd__and2_2
XFILLER_38_452 VGND VGND VPWR VPWR sky130_fd_sc_hd__fill_1
XFILLER_66_772 VGND VGND VPWR VPWR sky130_fd_sc_hd__decap_3
XTAP_TAPCELL_ROW_123_2018 VGND VPWR sky130_fd_sc_hd__tapvpwrvgnd_1
XFILLER_26_636 VGND VGND VPWR VPWR sky130_fd_sc_hd__decap_3
XTAP_TAPCELL_ROW_49_981 VGND VPWR sky130_fd_sc_hd__tapvpwrvgnd_1
XFILLER_53_444 VGND VGND VPWR VPWR sky130_fd_sc_hd__decap_3
XTAP_TAPCELL_ROW_0_278 VGND VPWR sky130_fd_sc_hd__tapvpwrvgnd_1
X_6986_ _4908_/X _8531_/Q _7000_/S VGND VGND VPWR VPWR _6987_/A sky130_fd_sc_hd__mux2_4
XFILLER_15_36 VGND VGND VPWR VPWR sky130_fd_sc_hd__decap_3
XFILLER_41_628 VGND VGND VPWR VPWR sky130_fd_sc_hd__decap_3
XFILLER_53_499 VGND VGND VPWR VPWR sky130_fd_sc_hd__decap_3
XTAP_TAPCELL_ROW_0_289 VGND VPWR sky130_fd_sc_hd__tapvpwrvgnd_1
XTAP_TAPCELL_ROW_105_1762 VGND VPWR sky130_fd_sc_hd__tapvpwrvgnd_1
X_8725_ _8725_/CLK _8725_/D fanout495/X VGND VGND VPWR VPWR _8725_/Q sky130_fd_sc_hd__dfrtp_2
X_5937_ _5933_/X _5934_/X _4861_/X _5935_/X hold907/X VGND VGND VPWR VPWR _8024_/D
+ sky130_fd_sc_hd__a32o_2
XFILLER_15_69 VGND VGND VPWR VPWR sky130_fd_sc_hd__decap_3
X_8656_ _8660_/CLK _8656_/D fanout516/X VGND VGND VPWR VPWR _8656_/Q sky130_fd_sc_hd__dfrtp_2
XFILLER_21_352 VGND VGND VPWR VPWR sky130_fd_sc_hd__fill_2
XFILLER_21_363 VGND VGND VPWR VPWR sky130_fd_sc_hd__decap_3
X_7607_ _8751_/CLK _7607_/D load_slew628/X VGND VGND VPWR VPWR _7607_/Q sky130_fd_sc_hd__dfrtp_2
X_5868_ _5946_/A VGND VGND VPWR VPWR _5868_/X sky130_fd_sc_hd__clkbuf_1
XFILLER_21_396 VGND VGND VPWR VPWR sky130_fd_sc_hd__decap_3
XFILLER_31_35 VGND VGND VPWR VPWR sky130_fd_sc_hd__decap_3
X_8587_ _8668_/CLK _8587_/D load_slew636/X VGND VGND VPWR VPWR _8587_/Q sky130_fd_sc_hd__dfrtp_2
X_5799_ _7938_/Q _4841_/A _5805_/S VGND VGND VPWR VPWR _5800_/A sky130_fd_sc_hd__mux2_2
X_4819_ _4819_/A VGND VGND VPWR VPWR _4819_/X sky130_fd_sc_hd__buf_1
XFILLER_135_722 VGND VGND VPWR VPWR sky130_fd_sc_hd__decap_3
XFILLER_31_57 VGND VGND VPWR VPWR sky130_fd_sc_hd__decap_3
X_7538_ _8765_/CLK _7538_/D load_slew560/X VGND VGND VPWR VPWR _7538_/Q sky130_fd_sc_hd__dfrtp_2
XFILLER_119_284 VGND VGND VPWR VPWR sky130_fd_sc_hd__decap_3
XFILLER_134_221 VGND VGND VPWR VPWR sky130_fd_sc_hd__decap_3
XFILLER_135_744 VGND VGND VPWR VPWR sky130_fd_sc_hd__decap_3
XTAP_TAPCELL_ROW_134_2169 VGND VPWR sky130_fd_sc_hd__tapvpwrvgnd_1
X_7469_ _7469_/A VGND VGND VPWR VPWR _8790_/D sky130_fd_sc_hd__buf_1
XFILLER_134_265 VGND VGND VPWR VPWR sky130_fd_sc_hd__decap_3
XFILLER_135_766 VGND VGND VPWR VPWR sky130_fd_sc_hd__decap_3
XFILLER_135_788 VGND VGND VPWR VPWR sky130_fd_sc_hd__decap_3
XFILLER_134_298 VGND VGND VPWR VPWR sky130_fd_sc_hd__decap_3
XFILLER_1_724 VGND VGND VPWR VPWR sky130_fd_sc_hd__decap_3
XFILLER_1_735 VGND VGND VPWR VPWR sky130_fd_sc_hd__decap_3
XFILLER_0_223 VGND VGND VPWR VPWR sky130_fd_sc_hd__fill_1
XFILLER_1_768 VGND VGND VPWR VPWR sky130_fd_sc_hd__decap_3
XFILLER_49_706 VGND VGND VPWR VPWR sky130_fd_sc_hd__fill_1
XFILLER_130_460 VGND VGND VPWR VPWR sky130_fd_sc_hd__decap_3
XFILLER_29_430 VGND VGND VPWR VPWR sky130_fd_sc_hd__fill_1
XFILLER_76_569 VGND VGND VPWR VPWR sky130_fd_sc_hd__decap_3
XFILLER_29_452 VGND VGND VPWR VPWR sky130_fd_sc_hd__fill_2
XFILLER_29_463 VGND VGND VPWR VPWR sky130_fd_sc_hd__decap_3
XFILLER_17_636 VGND VGND VPWR VPWR sky130_fd_sc_hd__decap_3
XTAP_TAPCELL_ROW_67_1234 VGND VPWR sky130_fd_sc_hd__tapvpwrvgnd_1
XFILLER_17_669 VGND VGND VPWR VPWR sky130_fd_sc_hd__decap_3
XFILLER_44_433 VGND VGND VPWR VPWR sky130_fd_sc_hd__decap_3
XPHY_EDGE_ROW_19_Right_19 VGND VGND VPWR VPWR sky130_fd_sc_hd__decap_3
XFILLER_112_93 VGND VGND VPWR VPWR sky130_fd_sc_hd__decap_3
XFILLER_44_488 VGND VGND VPWR VPWR sky130_fd_sc_hd__decap_3
XFILLER_44_499 VGND VGND VPWR VPWR sky130_fd_sc_hd__decap_3
XFILLER_72_53 VGND VGND VPWR VPWR sky130_fd_sc_hd__decap_3
XTAP_TAPCELL_ROW_27_664 VGND VPWR sky130_fd_sc_hd__tapvpwrvgnd_1
XTAP_TAPCELL_ROW_27_675 VGND VPWR sky130_fd_sc_hd__tapvpwrvgnd_1
XTAP_TAPCELL_ROW_80_1412 VGND VPWR sky130_fd_sc_hd__tapvpwrvgnd_1
XFILLER_12_330 VGND VGND VPWR VPWR sky130_fd_sc_hd__decap_3
XFILLER_31_127 VGND VGND VPWR VPWR sky130_fd_sc_hd__decap_3
XFILLER_71_296 VGND VGND VPWR VPWR sky130_fd_sc_hd__fill_2
XFILLER_12_363 VGND VGND VPWR VPWR sky130_fd_sc_hd__fill_1
XFILLER_75_9 VGND VGND VPWR VPWR sky130_fd_sc_hd__decap_3
XFILLER_113_405 VGND VGND VPWR VPWR sky130_fd_sc_hd__decap_3
XFILLER_21_90 VGND VGND VPWR VPWR sky130_fd_sc_hd__fill_2
XFILLER_99_606 VGND VGND VPWR VPWR sky130_fd_sc_hd__fill_1
XFILLER_99_617 VGND VGND VPWR VPWR sky130_fd_sc_hd__decap_3
XPHY_EDGE_ROW_28_Right_28 VGND VGND VPWR VPWR sky130_fd_sc_hd__decap_3
XTAP_TAPCELL_ROW_78_1385 VGND VPWR sky130_fd_sc_hd__tapvpwrvgnd_1
XFILLER_113_427 VGND VGND VPWR VPWR sky130_fd_sc_hd__decap_3
XFILLER_125_276 VGND VGND VPWR VPWR sky130_fd_sc_hd__decap_3
XFILLER_125_287 VGND VGND VPWR VPWR sky130_fd_sc_hd__fill_1
XFILLER_126_799 VGND VGND VPWR VPWR sky130_fd_sc_hd__decap_3
XFILLER_4_595 VGND VGND VPWR VPWR sky130_fd_sc_hd__decap_3
XFILLER_98_127 VGND VGND VPWR VPWR sky130_fd_sc_hd__fill_2
XFILLER_98_138 VGND VGND VPWR VPWR sky130_fd_sc_hd__fill_2
XFILLER_113_449 VGND VGND VPWR VPWR sky130_fd_sc_hd__decap_3
XFILLER_97_83 VGND VGND VPWR VPWR sky130_fd_sc_hd__decap_3
XTAP_TAPCELL_ROW_91_1563 VGND VPWR sky130_fd_sc_hd__tapvpwrvgnd_1
XFILLER_121_460 VGND VGND VPWR VPWR sky130_fd_sc_hd__decap_3
XFILLER_67_525 VGND VGND VPWR VPWR sky130_fd_sc_hd__decap_3
XFILLER_79_396 VGND VGND VPWR VPWR sky130_fd_sc_hd__decap_3
XFILLER_82_517 VGND VGND VPWR VPWR sky130_fd_sc_hd__decap_3
XFILLER_94_377 VGND VGND VPWR VPWR sky130_fd_sc_hd__decap_3
XFILLER_75_591 VGND VGND VPWR VPWR sky130_fd_sc_hd__fill_1
XPHY_EDGE_ROW_37_Right_37 VGND VGND VPWR VPWR sky130_fd_sc_hd__decap_3
XFILLER_23_606 VGND VGND VPWR VPWR sky130_fd_sc_hd__decap_3
XFILLER_35_455 VGND VGND VPWR VPWR sky130_fd_sc_hd__fill_2
XFILLER_47_293 VGND VGND VPWR VPWR sky130_fd_sc_hd__fill_2
XTAP_TAPCELL_ROW_46_940 VGND VPWR sky130_fd_sc_hd__tapvpwrvgnd_1
X_6840_ _6840_/A VGND VGND VPWR VPWR _8461_/D sky130_fd_sc_hd__buf_6
XFILLER_23_617 VGND VGND VPWR VPWR sky130_fd_sc_hd__decap_3
XFILLER_63_797 VGND VGND VPWR VPWR sky130_fd_sc_hd__decap_3
XFILLER_90_583 VGND VGND VPWR VPWR sky130_fd_sc_hd__decap_3
X_6771_ _6771_/A VGND VGND VPWR VPWR _8429_/D sky130_fd_sc_hd__buf_2
X_3983_ _8719_/Q _8800_/Q _3983_/S VGND VGND VPWR VPWR _3984_/B sky130_fd_sc_hd__mux2_2
X_8510_ _8672_/CLK _8510_/D load_slew687/X VGND VGND VPWR VPWR _8510_/Q sky130_fd_sc_hd__dfrtp_2
X_5722_ _5722_/A VGND VGND VPWR VPWR _7901_/D sky130_fd_sc_hd__buf_1
X_8441_ _8684_/CLK _8441_/D load_slew558/X VGND VGND VPWR VPWR _8441_/Q sky130_fd_sc_hd__dfrtp_2
X_5653_ _5653_/A VGND VGND VPWR VPWR _7869_/D sky130_fd_sc_hd__buf_1
XFILLER_117_700 VGND VGND VPWR VPWR sky130_fd_sc_hd__decap_3
XPHY_EDGE_ROW_46_Right_46 VGND VGND VPWR VPWR sky130_fd_sc_hd__decap_3
XTAP_TAPCELL_ROW_100_1692 VGND VPWR sky130_fd_sc_hd__tapvpwrvgnd_1
X_8372_ _8777_/CLK _8372_/D fanout743/X VGND VGND VPWR VPWR _8372_/Q sky130_fd_sc_hd__dfrtp_2
X_5584_ _5584_/A VGND VGND VPWR VPWR _7836_/D sky130_fd_sc_hd__buf_1
X_4604_ _8370_/Q _4652_/A2 _4652_/B1 _8289_/Q VGND VGND VPWR VPWR _4604_/X sky130_fd_sc_hd__o22a_2
XFILLER_116_221 VGND VGND VPWR VPWR sky130_fd_sc_hd__decap_3
XFILLER_129_582 VGND VGND VPWR VPWR sky130_fd_sc_hd__decap_3
XFILLER_7_81 VGND VGND VPWR VPWR sky130_fd_sc_hd__decap_3
X_7323_ _8721_/Q _5026_/A _7323_/S VGND VGND VPWR VPWR _7324_/A sky130_fd_sc_hd__mux2_2
X_4535_ _8445_/Q _8526_/Q _8607_/Q _8688_/Q _4502_/S wire353/A VGND VGND VPWR VPWR
+ _4535_/X sky130_fd_sc_hd__mux4_2
XFILLER_117_788 VGND VGND VPWR VPWR sky130_fd_sc_hd__decap_3
XFILLER_116_298 VGND VGND VPWR VPWR sky130_fd_sc_hd__decap_3
XFILLER_131_202 VGND VGND VPWR VPWR sky130_fd_sc_hd__decap_3
XFILLER_132_725 VGND VGND VPWR VPWR sky130_fd_sc_hd__decap_3
XFILLER_89_116 VGND VGND VPWR VPWR sky130_fd_sc_hd__decap_3
X_7254_ _7267_/A VGND VGND VPWR VPWR _7254_/X sky130_fd_sc_hd__clkbuf_2
X_4466_ _4462_/A _4463_/X _4465_/X _3848_/X VGND VGND VPWR VPWR _4466_/X sky130_fd_sc_hd__o211a_2
XFILLER_131_246 VGND VGND VPWR VPWR sky130_fd_sc_hd__decap_3
XFILLER_132_769 VGND VGND VPWR VPWR sky130_fd_sc_hd__decap_3
X_7185_ _7188_/A1 _4969_/X _7176_/X _7179_/X hold910/X VGND VGND VPWR VPWR _8626_/D
+ sky130_fd_sc_hd__a32o_2
X_6205_ _4727_/X _8164_/Q _6205_/S VGND VGND VPWR VPWR _6206_/A sky130_fd_sc_hd__mux2_4
X_4397_ _7775_/Q _7856_/Q _4402_/S VGND VGND VPWR VPWR _4398_/B sky130_fd_sc_hd__mux2_2
XFILLER_112_471 VGND VGND VPWR VPWR sky130_fd_sc_hd__decap_3
XFILLER_98_694 VGND VGND VPWR VPWR sky130_fd_sc_hd__decap_3
XTAP_TAPCELL_ROW_51_1002 VGND VPWR sky130_fd_sc_hd__tapvpwrvgnd_1
XTAP_TAPCELL_ROW_51_1013 VGND VPWR sky130_fd_sc_hd__tapvpwrvgnd_1
X_6136_ _6136_/A VGND VGND VPWR VPWR _8132_/D sky130_fd_sc_hd__buf_1
XFILLER_100_622 VGND VGND VPWR VPWR sky130_fd_sc_hd__decap_3
XFILLER_133_15 VGND VGND VPWR VPWR sky130_fd_sc_hd__decap_3
XFILLER_133_48 VGND VGND VPWR VPWR sky130_fd_sc_hd__decap_3
XTAP_TAPCELL_ROW_5_359 VGND VPWR sky130_fd_sc_hd__tapvpwrvgnd_1
Xhold1001 _8583_/Q VGND VGND VPWR VPWR _7097_/A1 sky130_fd_sc_hd__dlygate4sd3_1
Xhold1012 _7612_/Q VGND VGND VPWR VPWR _5106_/A1 sky130_fd_sc_hd__dlygate4sd3_1
Xhold1023 _7678_/Q VGND VGND VPWR VPWR _5247_/A0 sky130_fd_sc_hd__dlygate4sd3_1
XPHY_EDGE_ROW_55_Right_55 VGND VGND VPWR VPWR sky130_fd_sc_hd__decap_3
Xhold1034 _7501_/Q VGND VGND VPWR VPWR _4708_/A1 sky130_fd_sc_hd__dlygate4sd3_1
Xhold1045 _7737_/Q VGND VGND VPWR VPWR _5373_/A0 sky130_fd_sc_hd__dlygate4sd3_1
Xhold1056 _7563_/Q VGND VGND VPWR VPWR _4970_/A1 sky130_fd_sc_hd__dlygate4sd3_1
Xhold1067 _7614_/Q VGND VGND VPWR VPWR _5110_/A1 sky130_fd_sc_hd__dlygate4sd3_1
Xload_slew292 _3894_/A1 VGND VGND VPWR VPWR _3840_/S sky130_fd_sc_hd__buf_4
X_6067_ _6067_/A VGND VGND VPWR VPWR _8099_/D sky130_fd_sc_hd__buf_1
XFILLER_26_24 VGND VGND VPWR VPWR sky130_fd_sc_hd__decap_3
X_5018_ _5018_/A _5026_/B VGND VGND VPWR VPWR _5019_/A sky130_fd_sc_hd__and2_2
XFILLER_26_35 VGND VGND VPWR VPWR sky130_fd_sc_hd__decap_3
XFILLER_26_455 VGND VGND VPWR VPWR sky130_fd_sc_hd__decap_3
XFILLER_38_293 VGND VGND VPWR VPWR sky130_fd_sc_hd__decap_3
XFILLER_53_241 VGND VGND VPWR VPWR sky130_fd_sc_hd__decap_3
XFILLER_26_477 VGND VGND VPWR VPWR sky130_fd_sc_hd__fill_2
XFILLER_26_68 VGND VGND VPWR VPWR sky130_fd_sc_hd__decap_3
XFILLER_41_403 VGND VGND VPWR VPWR sky130_fd_sc_hd__fill_2
XFILLER_81_561 VGND VGND VPWR VPWR sky130_fd_sc_hd__decap_3
XFILLER_81_572 VGND VGND VPWR VPWR sky130_fd_sc_hd__fill_2
XFILLER_13_116 VGND VGND VPWR VPWR sky130_fd_sc_hd__decap_3
XFILLER_41_425 VGND VGND VPWR VPWR sky130_fd_sc_hd__decap_3
XFILLER_41_458 VGND VGND VPWR VPWR sky130_fd_sc_hd__fill_1
XFILLER_81_594 VGND VGND VPWR VPWR sky130_fd_sc_hd__fill_1
XTAP_TAPCELL_ROW_24_623 VGND VPWR sky130_fd_sc_hd__tapvpwrvgnd_1
XTAP_TAPCELL_ROW_24_634 VGND VPWR sky130_fd_sc_hd__tapvpwrvgnd_1
X_6969_ _4875_/X _8523_/Q _6979_/S VGND VGND VPWR VPWR _6970_/A sky130_fd_sc_hd__mux2_4
XTAP_TAPCELL_ROW_62_1164 VGND VPWR sky130_fd_sc_hd__tapvpwrvgnd_1
X_8708_ _8783_/CLK _8708_/D fanout683/X VGND VGND VPWR VPWR _8708_/Q sky130_fd_sc_hd__dfrtp_2
XFILLER_42_67 VGND VGND VPWR VPWR sky130_fd_sc_hd__decap_3
XPHY_EDGE_ROW_64_Right_64 VGND VGND VPWR VPWR sky130_fd_sc_hd__decap_3
X_8639_ _8639_/CLK _8639_/D load_slew605/X VGND VGND VPWR VPWR _8639_/Q sky130_fd_sc_hd__dfrtp_2
XFILLER_127_508 VGND VGND VPWR VPWR sky130_fd_sc_hd__decap_3
XFILLER_107_221 VGND VGND VPWR VPWR sky130_fd_sc_hd__decap_3
XFILLER_5_337 VGND VGND VPWR VPWR sky130_fd_sc_hd__decap_3
XTAP_TAPCELL_ROW_118_1942 VGND VPWR sky130_fd_sc_hd__tapvpwrvgnd_1
XFILLER_108_755 VGND VGND VPWR VPWR sky130_fd_sc_hd__fill_1
XFILLER_123_747 VGND VGND VPWR VPWR sky130_fd_sc_hd__decap_3
XFILLER_122_235 VGND VGND VPWR VPWR sky130_fd_sc_hd__decap_3
Xhold890 _7999_/Q VGND VGND VPWR VPWR hold890/X sky130_fd_sc_hd__dlygate4sd3_1
XFILLER_107_60 VGND VGND VPWR VPWR sky130_fd_sc_hd__decap_3
XFILLER_110_408 VGND VGND VPWR VPWR sky130_fd_sc_hd__decap_3
XFILLER_3_39 VGND VGND VPWR VPWR sky130_fd_sc_hd__decap_3
XFILLER_103_482 VGND VGND VPWR VPWR sky130_fd_sc_hd__decap_3
XFILLER_131_780 VGND VGND VPWR VPWR sky130_fd_sc_hd__decap_3
XFILLER_131_791 VGND VGND VPWR VPWR sky130_fd_sc_hd__decap_3
XFILLER_1_598 VGND VGND VPWR VPWR sky130_fd_sc_hd__decap_3
XFILLER_88_193 VGND VGND VPWR VPWR sky130_fd_sc_hd__decap_3
XPHY_EDGE_ROW_73_Right_73 VGND VGND VPWR VPWR sky130_fd_sc_hd__decap_3
XFILLER_130_290 VGND VGND VPWR VPWR sky130_fd_sc_hd__decap_3
XFILLER_67_97 VGND VGND VPWR VPWR sky130_fd_sc_hd__fill_2
XFILLER_29_260 VGND VGND VPWR VPWR sky130_fd_sc_hd__fill_2
XFILLER_64_539 VGND VGND VPWR VPWR sky130_fd_sc_hd__fill_2
XFILLER_91_314 VGND VGND VPWR VPWR sky130_fd_sc_hd__fill_1
XFILLER_123_81 VGND VGND VPWR VPWR sky130_fd_sc_hd__decap_3
XFILLER_17_455 VGND VGND VPWR VPWR sky130_fd_sc_hd__decap_3
XFILLER_29_293 VGND VGND VPWR VPWR sky130_fd_sc_hd__decap_3
XFILLER_83_41 VGND VGND VPWR VPWR sky130_fd_sc_hd__fill_1
XFILLER_60_734 VGND VGND VPWR VPWR sky130_fd_sc_hd__fill_1
XPHY_EDGE_ROW_82_Right_82 VGND VGND VPWR VPWR sky130_fd_sc_hd__decap_3
XFILLER_12_171 VGND VGND VPWR VPWR sky130_fd_sc_hd__fill_2
XFILLER_40_480 VGND VGND VPWR VPWR sky130_fd_sc_hd__decap_3
XFILLER_9_632 VGND VGND VPWR VPWR sky130_fd_sc_hd__decap_3
XFILLER_9_665 VGND VGND VPWR VPWR sky130_fd_sc_hd__decap_3
XFILLER_9_676 VGND VGND VPWR VPWR sky130_fd_sc_hd__decap_3
XFILLER_8_175 VGND VGND VPWR VPWR sky130_fd_sc_hd__decap_3
XFILLER_8_197 VGND VGND VPWR VPWR sky130_fd_sc_hd__decap_3
XFILLER_126_563 VGND VGND VPWR VPWR sky130_fd_sc_hd__decap_3
XFILLER_126_574 VGND VGND VPWR VPWR sky130_fd_sc_hd__decap_3
X_4320_ _7768_/Q _7849_/Q _4320_/S VGND VGND VPWR VPWR _4320_/X sky130_fd_sc_hd__mux2_2
XFILLER_87_609 VGND VGND VPWR VPWR sky130_fd_sc_hd__decap_3
XFILLER_99_447 VGND VGND VPWR VPWR sky130_fd_sc_hd__fill_1
XFILLER_99_458 VGND VGND VPWR VPWR sky130_fd_sc_hd__fill_2
X_4251_ _8744_/Q _7519_/Q _7600_/Q _7681_/Q _4247_/S _4330_/A VGND VGND VPWR VPWR
+ _4252_/B sky130_fd_sc_hd__mux4_2
XFILLER_113_268 VGND VGND VPWR VPWR sky130_fd_sc_hd__decap_3
XFILLER_79_160 VGND VGND VPWR VPWR sky130_fd_sc_hd__decap_3
XFILLER_86_119 VGND VGND VPWR VPWR sky130_fd_sc_hd__decap_3
XPHY_EDGE_ROW_91_Right_91 VGND VGND VPWR VPWR sky130_fd_sc_hd__decap_3
XFILLER_67_322 VGND VGND VPWR VPWR sky130_fd_sc_hd__decap_3
XFILLER_95_642 VGND VGND VPWR VPWR sky130_fd_sc_hd__decap_3
X_4182_ _8414_/Q _8495_/Q _8576_/Q _8657_/Q _4197_/S _4198_/A VGND VGND VPWR VPWR
+ _4182_/X sky130_fd_sc_hd__mux4_2
XFILLER_94_130 VGND VGND VPWR VPWR sky130_fd_sc_hd__decap_3
XFILLER_94_141 VGND VGND VPWR VPWR sky130_fd_sc_hd__decap_3
XTAP_TAPCELL_ROW_2_318 VGND VPWR sky130_fd_sc_hd__tapvpwrvgnd_1
XFILLER_67_388 VGND VGND VPWR VPWR sky130_fd_sc_hd__decap_3
XFILLER_82_336 VGND VGND VPWR VPWR sky130_fd_sc_hd__fill_2
X_7941_ _8759_/CLK _7941_/D fanout708/X VGND VGND VPWR VPWR _7941_/Q sky130_fd_sc_hd__dfrtp_2
X_7872_ _8530_/CLK _7872_/D fanout739/X VGND VGND VPWR VPWR _7872_/Q sky130_fd_sc_hd__dfrtp_2
XFILLER_50_233 VGND VGND VPWR VPWR sky130_fd_sc_hd__decap_3
XTAP_TAPCELL_ROW_102_1721 VGND VPWR sky130_fd_sc_hd__tapvpwrvgnd_1
X_6823_ _6823_/A VGND VGND VPWR VPWR _8454_/D sky130_fd_sc_hd__buf_2
XFILLER_50_266 VGND VGND VPWR VPWR sky130_fd_sc_hd__decap_3
X_3966_ _8070_/Q _8151_/Q _4550_/S VGND VGND VPWR VPWR _3966_/X sky130_fd_sc_hd__mux2_2
Xclkbuf_leaf_95_CLK clkbuf_leaf_99_CLK/A VGND VGND VPWR VPWR _8462_/CLK sky130_fd_sc_hd__clkbuf_8
X_6754_ _6754_/A VGND VGND VPWR VPWR _8421_/D sky130_fd_sc_hd__buf_2
X_6685_ _6685_/A VGND VGND VPWR VPWR _8388_/D sky130_fd_sc_hd__buf_2
X_5705_ _7893_/Q _4995_/A _5721_/S VGND VGND VPWR VPWR _5706_/A sky130_fd_sc_hd__mux2_2
XFILLER_109_508 VGND VGND VPWR VPWR sky130_fd_sc_hd__decap_3
XFILLER_12_15 VGND VGND VPWR VPWR sky130_fd_sc_hd__decap_3
X_3897_ _3895_/X _3896_/X _4514_/S VGND VGND VPWR VPWR _3897_/X sky130_fd_sc_hd__mux2_2
X_8424_ _8586_/CLK _8424_/D fanout537/X VGND VGND VPWR VPWR _8424_/Q sky130_fd_sc_hd__dfrtp_2
X_5636_ _7861_/Q _4857_/A _5654_/S VGND VGND VPWR VPWR _5637_/A sky130_fd_sc_hd__mux2_2
XFILLER_128_15 VGND VGND VPWR VPWR sky130_fd_sc_hd__decap_3
XFILLER_12_59 VGND VGND VPWR VPWR sky130_fd_sc_hd__decap_3
XFILLER_128_59 VGND VGND VPWR VPWR sky130_fd_sc_hd__decap_3
XTAP_TAPCELL_ROW_131_2128 VGND VPWR sky130_fd_sc_hd__tapvpwrvgnd_1
X_8355_ _8760_/CLK _8355_/D fanout697/X VGND VGND VPWR VPWR _8355_/Q sky130_fd_sc_hd__dfrtp_2
X_5567_ _5567_/A VGND VGND VPWR VPWR _7828_/D sky130_fd_sc_hd__buf_1
XFILLER_132_522 VGND VGND VPWR VPWR sky130_fd_sc_hd__decap_3
X_8286_ _8772_/CLK _8286_/D load_slew720/X VGND VGND VPWR VPWR _8286_/Q sky130_fd_sc_hd__dfrtp_2
X_7306_ _7306_/A VGND VGND VPWR VPWR _8712_/D sky130_fd_sc_hd__buf_1
X_5498_ _5498_/A VGND VGND VPWR VPWR _7796_/D sky130_fd_sc_hd__buf_1
X_4518_ _4514_/X _4517_/X _4591_/S VGND VGND VPWR VPWR _4519_/A sky130_fd_sc_hd__mux2_2
XFILLER_132_533 VGND VGND VPWR VPWR sky130_fd_sc_hd__decap_3
XFILLER_5_9 VGND VGND VPWR VPWR sky130_fd_sc_hd__decap_3
X_7237_ _7228_/X _4795_/X _7242_/A3 _7242_/B1 hold792/X VGND VGND VPWR VPWR _8666_/D
+ sky130_fd_sc_hd__a32o_2
X_4449_ _8761_/Q _7536_/Q _4449_/S VGND VGND VPWR VPWR _4450_/B sky130_fd_sc_hd__mux2_2
XFILLER_104_268 VGND VGND VPWR VPWR sky130_fd_sc_hd__decap_3
XFILLER_132_566 VGND VGND VPWR VPWR sky130_fd_sc_hd__decap_3
XFILLER_58_300 VGND VGND VPWR VPWR sky130_fd_sc_hd__decap_3
XTAP_TAPCELL_ROW_113_1872 VGND VPWR sky130_fd_sc_hd__tapvpwrvgnd_1
Xfanout611 fanout613/X VGND VGND VPWR VPWR fanout611/X sky130_fd_sc_hd__clkdlybuf4s25_1
Xfanout622 fanout624/X VGND VGND VPWR VPWR fanout622/X sky130_fd_sc_hd__clkdlybuf4s25_1
XFILLER_113_791 VGND VGND VPWR VPWR sky130_fd_sc_hd__decap_3
XFILLER_98_480 VGND VGND VPWR VPWR sky130_fd_sc_hd__decap_3
Xfanout644 fanout646/X VGND VGND VPWR VPWR fanout644/X sky130_fd_sc_hd__clkdlybuf4s25_1
Xfanout666 wire669/A VGND VGND VPWR VPWR fanout666/X sky130_fd_sc_hd__clkdlybuf4s25_1
X_7168_ _4929_/X _8617_/Q _7172_/S VGND VGND VPWR VPWR _7169_/A sky130_fd_sc_hd__mux2_2
XFILLER_100_430 VGND VGND VPWR VPWR sky130_fd_sc_hd__decap_3
XFILLER_100_441 VGND VGND VPWR VPWR sky130_fd_sc_hd__decap_3
XFILLER_37_23 VGND VGND VPWR VPWR sky130_fd_sc_hd__decap_3
XFILLER_86_675 VGND VGND VPWR VPWR sky130_fd_sc_hd__decap_3
XTAP_TAPCELL_ROW_29_704 VGND VPWR sky130_fd_sc_hd__tapvpwrvgnd_1
Xfanout677 fanout684/X VGND VGND VPWR VPWR fanout677/X sky130_fd_sc_hd__clkdlybuf4s25_1
Xfanout688 fanout694/X VGND VGND VPWR VPWR fanout688/X sky130_fd_sc_hd__clkdlybuf4s25_1
X_7099_ _4791_/X hold967/X _7109_/S VGND VGND VPWR VPWR _7100_/A sky130_fd_sc_hd__mux2_1
X_6119_ _8124_/Q _4898_/A _6137_/S VGND VGND VPWR VPWR _6120_/A sky130_fd_sc_hd__mux2_2
XFILLER_73_314 VGND VGND VPWR VPWR sky130_fd_sc_hd__fill_2
XFILLER_73_325 VGND VGND VPWR VPWR sky130_fd_sc_hd__decap_3
XFILLER_86_697 VGND VGND VPWR VPWR sky130_fd_sc_hd__decap_3
XFILLER_73_358 VGND VGND VPWR VPWR sky130_fd_sc_hd__decap_3
XFILLER_27_775 VGND VGND VPWR VPWR sky130_fd_sc_hd__decap_3
XFILLER_14_436 VGND VGND VPWR VPWR sky130_fd_sc_hd__decap_3
XFILLER_26_274 VGND VGND VPWR VPWR sky130_fd_sc_hd__decap_3
XFILLER_41_200 VGND VGND VPWR VPWR sky130_fd_sc_hd__fill_1
XFILLER_41_222 VGND VGND VPWR VPWR sky130_fd_sc_hd__fill_2
XFILLER_42_734 VGND VGND VPWR VPWR sky130_fd_sc_hd__decap_3
XFILLER_53_22 VGND VGND VPWR VPWR sky130_fd_sc_hd__decap_3
Xclkbuf_leaf_86_CLK clkbuf_leaf_88_CLK/A VGND VGND VPWR VPWR _8679_/CLK sky130_fd_sc_hd__clkbuf_8
XFILLER_10_631 VGND VGND VPWR VPWR sky130_fd_sc_hd__decap_3
XFILLER_10_675 VGND VGND VPWR VPWR sky130_fd_sc_hd__decap_3
XFILLER_6_613 VGND VGND VPWR VPWR sky130_fd_sc_hd__decap_3
XFILLER_5_134 VGND VGND VPWR VPWR sky130_fd_sc_hd__decap_3
XFILLER_6_657 VGND VGND VPWR VPWR sky130_fd_sc_hd__decap_3
XFILLER_123_500 VGND VGND VPWR VPWR sky130_fd_sc_hd__decap_3
XFILLER_135_371 VGND VGND VPWR VPWR sky130_fd_sc_hd__decap_3
XFILLER_5_189 VGND VGND VPWR VPWR sky130_fd_sc_hd__decap_3
XTAP_TAPCELL_ROW_75_1344 VGND VPWR sky130_fd_sc_hd__tapvpwrvgnd_1
XFILLER_135_393 VGND VGND VPWR VPWR sky130_fd_sc_hd__decap_3
XFILLER_111_717 VGND VGND VPWR VPWR sky130_fd_sc_hd__fill_2
XFILLER_123_588 VGND VGND VPWR VPWR sky130_fd_sc_hd__decap_3
XFILLER_78_85 VGND VGND VPWR VPWR sky130_fd_sc_hd__fill_1
XFILLER_49_300 VGND VGND VPWR VPWR sky130_fd_sc_hd__fill_1
XFILLER_77_620 VGND VGND VPWR VPWR sky130_fd_sc_hd__fill_2
XFILLER_77_631 VGND VGND VPWR VPWR sky130_fd_sc_hd__decap_3
Xclkbuf_leaf_10_CLK clkload0/A VGND VGND VPWR VPWR _8645_/CLK sky130_fd_sc_hd__clkbuf_8
XFILLER_134_80 VGND VGND VPWR VPWR sky130_fd_sc_hd__decap_3
XFILLER_134_91 VGND VGND VPWR VPWR sky130_fd_sc_hd__decap_3
XFILLER_91_100 VGND VGND VPWR VPWR sky130_fd_sc_hd__decap_3
XFILLER_92_623 VGND VGND VPWR VPWR sky130_fd_sc_hd__decap_3
XFILLER_64_347 VGND VGND VPWR VPWR sky130_fd_sc_hd__decap_3
XFILLER_64_358 VGND VGND VPWR VPWR sky130_fd_sc_hd__fill_2
XFILLER_91_133 VGND VGND VPWR VPWR sky130_fd_sc_hd__decap_3
XFILLER_92_645 VGND VGND VPWR VPWR sky130_fd_sc_hd__decap_3
XFILLER_17_241 VGND VGND VPWR VPWR sky130_fd_sc_hd__fill_1
XFILLER_45_561 VGND VGND VPWR VPWR sky130_fd_sc_hd__decap_3
XFILLER_91_166 VGND VGND VPWR VPWR sky130_fd_sc_hd__fill_2
XFILLER_32_200 VGND VGND VPWR VPWR sky130_fd_sc_hd__fill_2
XFILLER_91_199 VGND VGND VPWR VPWR sky130_fd_sc_hd__decap_3
XTAP_TAPCELL_ROW_86_1495 VGND VPWR sky130_fd_sc_hd__tapvpwrvgnd_1
XFILLER_32_244 VGND VGND VPWR VPWR sky130_fd_sc_hd__fill_1
XFILLER_60_542 VGND VGND VPWR VPWR sky130_fd_sc_hd__fill_2
X_3820_ _4335_/A VGND VGND VPWR VPWR _3820_/X sky130_fd_sc_hd__clkbuf_2
Xclkbuf_leaf_77_CLK clkload10/A VGND VGND VPWR VPWR _8695_/CLK sky130_fd_sc_hd__clkbuf_8
XFILLER_20_439 VGND VGND VPWR VPWR sky130_fd_sc_hd__decap_3
XFILLER_60_586 VGND VGND VPWR VPWR sky130_fd_sc_hd__fill_2
X_3751_ _3751_/A VGND VGND VPWR VPWR _3763_/A sky130_fd_sc_hd__clkbuf_1
XTAP_TAPCELL_ROW_15_497 VGND VPWR sky130_fd_sc_hd__tapvpwrvgnd_1
XFILLER_9_473 VGND VGND VPWR VPWR sky130_fd_sc_hd__decap_3
X_6470_ _4913_/X _8289_/Q _6482_/S VGND VGND VPWR VPWR _6471_/A sky130_fd_sc_hd__mux2_2
XFILLER_133_308 VGND VGND VPWR VPWR sky130_fd_sc_hd__decap_3
X_5421_ _5505_/S VGND VGND VPWR VPWR _5440_/S sky130_fd_sc_hd__buf_2
XFILLER_114_500 VGND VGND VPWR VPWR sky130_fd_sc_hd__decap_3
XFILLER_126_360 VGND VGND VPWR VPWR sky130_fd_sc_hd__decap_3
XFILLER_126_371 VGND VGND VPWR VPWR sky130_fd_sc_hd__decap_3
X_8140_ _8710_/CLK _8140_/D fanout665/X VGND VGND VPWR VPWR _8140_/Q sky130_fd_sc_hd__dfrtp_2
X_5352_ _7727_/Q _4976_/A _5356_/S VGND VGND VPWR VPWR _5353_/A sky130_fd_sc_hd__mux2_2
XFILLER_114_533 VGND VGND VPWR VPWR sky130_fd_sc_hd__fill_1
XFILLER_99_222 VGND VGND VPWR VPWR sky130_fd_sc_hd__fill_2
X_8071_ _8719_/CLK _8071_/D load_slew591/X VGND VGND VPWR VPWR _8071_/Q sky130_fd_sc_hd__dfrtp_2
X_4303_ _8010_/Q _4350_/A2 _4436_/B1 _7929_/Q _4336_/C1 VGND VGND VPWR VPWR _4303_/X
+ sky130_fd_sc_hd__o221a_2
XFILLER_87_417 VGND VGND VPWR VPWR sky130_fd_sc_hd__decap_3
XFILLER_99_277 VGND VGND VPWR VPWR sky130_fd_sc_hd__decap_3
X_7022_ _7022_/A VGND VGND VPWR VPWR _8547_/D sky130_fd_sc_hd__buf_2
X_5283_ _7695_/Q _4841_/X _5289_/S VGND VGND VPWR VPWR _5284_/A sky130_fd_sc_hd__mux2_2
XFILLER_4_71 VGND VGND VPWR VPWR sky130_fd_sc_hd__decap_3
XFILLER_68_620 VGND VGND VPWR VPWR sky130_fd_sc_hd__decap_3
X_4234_ _4241_/S _4229_/X _4231_/X _4233_/X VGND VGND VPWR VPWR _4234_/X sky130_fd_sc_hd__a22o_2
XFILLER_110_750 VGND VGND VPWR VPWR sky130_fd_sc_hd__decap_3
XFILLER_68_653 VGND VGND VPWR VPWR sky130_fd_sc_hd__fill_1
X_4165_ _4165_/A _4165_/B VGND VGND VPWR VPWR _4165_/X sky130_fd_sc_hd__or2_2
XFILLER_110_772 VGND VGND VPWR VPWR sky130_fd_sc_hd__fill_1
XFILLER_95_461 VGND VGND VPWR VPWR sky130_fd_sc_hd__decap_3
XTAP_TAPCELL_ROW_128_2090 VGND VPWR sky130_fd_sc_hd__tapvpwrvgnd_1
X_4096_ _4096_/A _4096_/B VGND VGND VPWR VPWR _4096_/X sky130_fd_sc_hd__or2_2
XFILLER_130_27 VGND VGND VPWR VPWR sky130_fd_sc_hd__fill_1
XFILLER_70_306 VGND VGND VPWR VPWR sky130_fd_sc_hd__fill_2
XFILLER_70_317 VGND VGND VPWR VPWR sky130_fd_sc_hd__decap_3
XFILLER_82_177 VGND VGND VPWR VPWR sky130_fd_sc_hd__decap_3
X_7924_ _8744_/CLK _7924_/D load_slew626/X VGND VGND VPWR VPWR _7924_/Q sky130_fd_sc_hd__dfrtp_2
XFILLER_130_38 VGND VGND VPWR VPWR sky130_fd_sc_hd__decap_3
XFILLER_23_222 VGND VGND VPWR VPWR sky130_fd_sc_hd__fill_2
XFILLER_24_734 VGND VGND VPWR VPWR sky130_fd_sc_hd__decap_3
XFILLER_36_583 VGND VGND VPWR VPWR sky130_fd_sc_hd__decap_3
XFILLER_63_380 VGND VGND VPWR VPWR sky130_fd_sc_hd__decap_3
X_7855_ _8679_/CLK _7855_/D wire701/X VGND VGND VPWR VPWR _7855_/Q sky130_fd_sc_hd__dfrtp_2
XTAP_TAPCELL_ROW_34_762 VGND VPWR sky130_fd_sc_hd__tapvpwrvgnd_1
Xclkbuf_leaf_68_CLK clkbuf_leaf_75_CLK/A VGND VGND VPWR VPWR _8693_/CLK sky130_fd_sc_hd__clkbuf_8
X_6806_ _6806_/A VGND VGND VPWR VPWR _8446_/D sky130_fd_sc_hd__buf_2
XFILLER_23_14 VGND VGND VPWR VPWR sky130_fd_sc_hd__decap_3
XFILLER_23_277 VGND VGND VPWR VPWR sky130_fd_sc_hd__decap_3
XFILLER_51_597 VGND VGND VPWR VPWR sky130_fd_sc_hd__fill_1
XTAP_TAPCELL_ROW_34_773 VGND VPWR sky130_fd_sc_hd__tapvpwrvgnd_1
X_7786_ _8768_/CLK _7786_/D fanout567/X VGND VGND VPWR VPWR _7786_/Q sky130_fd_sc_hd__dfrtp_2
X_4998_ input6/X _5026_/B VGND VGND VPWR VPWR _4999_/A sky130_fd_sc_hd__and2_2
XFILLER_23_47 VGND VGND VPWR VPWR sky130_fd_sc_hd__decap_3
XFILLER_23_69 VGND VGND VPWR VPWR sky130_fd_sc_hd__decap_3
X_3949_ _8068_/Q _8149_/Q _4367_/S VGND VGND VPWR VPWR _3950_/B sky130_fd_sc_hd__mux2_2
X_6737_ _6737_/A VGND VGND VPWR VPWR _8413_/D sky130_fd_sc_hd__buf_2
X_6668_ _6668_/A VGND VGND VPWR VPWR _8380_/D sky130_fd_sc_hd__buf_2
XTAP_TAPCELL_ROW_115_1901 VGND VPWR sky130_fd_sc_hd__tapvpwrvgnd_1
X_8407_ _8569_/CLK _8407_/D fanout497/X VGND VGND VPWR VPWR _8407_/Q sky130_fd_sc_hd__dfrtp_2
X_6599_ _6599_/A VGND VGND VPWR VPWR _8349_/D sky130_fd_sc_hd__buf_2
X_5619_ hold980/X _4824_/A _5633_/S VGND VGND VPWR VPWR _5620_/A sky130_fd_sc_hd__mux2_2
X_8338_ _8742_/CLK _8338_/D fanout522/X VGND VGND VPWR VPWR _8338_/Q sky130_fd_sc_hd__dfrtp_2
XFILLER_2_115 VGND VGND VPWR VPWR sky130_fd_sc_hd__decap_3
XFILLER_3_6 VGND VGND VPWR VPWR sky130_fd_sc_hd__decap_3
XFILLER_3_638 VGND VGND VPWR VPWR sky130_fd_sc_hd__decap_3
XFILLER_132_352 VGND VGND VPWR VPWR sky130_fd_sc_hd__decap_3
XFILLER_78_406 VGND VGND VPWR VPWR sky130_fd_sc_hd__decap_3
XTAP_TAPCELL_ROW_57_1085 VGND VPWR sky130_fd_sc_hd__tapvpwrvgnd_1
XTAP_TAPCELL_ROW_57_1096 VGND VPWR sky130_fd_sc_hd__tapvpwrvgnd_1
X_8269_ _8593_/CLK _8269_/D wire701/X VGND VGND VPWR VPWR _8269_/Q sky130_fd_sc_hd__dfrtp_2
XFILLER_120_525 VGND VGND VPWR VPWR sky130_fd_sc_hd__decap_3
XFILLER_132_385 VGND VGND VPWR VPWR sky130_fd_sc_hd__decap_3
XFILLER_78_428 VGND VGND VPWR VPWR sky130_fd_sc_hd__decap_3
Xfanout441 fanout443/X VGND VGND VPWR VPWR _4675_/S sky130_fd_sc_hd__clkdlybuf4s25_1
XFILLER_48_66 VGND VGND VPWR VPWR sky130_fd_sc_hd__decap_3
XFILLER_58_130 VGND VGND VPWR VPWR sky130_fd_sc_hd__decap_3
XTAP_TAPCELL_ROW_70_1274 VGND VPWR sky130_fd_sc_hd__tapvpwrvgnd_1
Xfanout463 fanout474/X VGND VGND VPWR VPWR _4449_/S sky130_fd_sc_hd__clkdlybuf4s25_1
Xfanout474 _8044_/Q VGND VGND VPWR VPWR fanout474/X sky130_fd_sc_hd__clkdlybuf4s25_1
XFILLER_48_88 VGND VGND VPWR VPWR sky130_fd_sc_hd__decap_3
XFILLER_58_174 VGND VGND VPWR VPWR sky130_fd_sc_hd__decap_3
XFILLER_74_623 VGND VGND VPWR VPWR sky130_fd_sc_hd__fill_1
Xfanout485 fanout487/X VGND VGND VPWR VPWR fanout485/X sky130_fd_sc_hd__clkdlybuf4s25_1
XFILLER_0_18 VGND VGND VPWR VPWR sky130_fd_sc_hd__decap_3
XFILLER_0_29 VGND VGND VPWR VPWR sky130_fd_sc_hd__decap_3
XFILLER_73_111 VGND VGND VPWR VPWR sky130_fd_sc_hd__fill_1
XFILLER_104_83 VGND VGND VPWR VPWR sky130_fd_sc_hd__fill_1
XFILLER_27_561 VGND VGND VPWR VPWR sky130_fd_sc_hd__fill_2
XFILLER_61_317 VGND VGND VPWR VPWR sky130_fd_sc_hd__decap_3
XFILLER_64_32 VGND VGND VPWR VPWR sky130_fd_sc_hd__decap_3
XFILLER_74_678 VGND VGND VPWR VPWR sky130_fd_sc_hd__fill_2
XFILLER_54_380 VGND VGND VPWR VPWR sky130_fd_sc_hd__decap_3
XFILLER_15_778 VGND VGND VPWR VPWR sky130_fd_sc_hd__decap_3
XFILLER_30_704 VGND VGND VPWR VPWR sky130_fd_sc_hd__fill_2
XFILLER_9_27 VGND VGND VPWR VPWR sky130_fd_sc_hd__decap_3
Xclkbuf_leaf_59_CLK clkload9/A VGND VGND VPWR VPWR _8593_/CLK sky130_fd_sc_hd__clkbuf_8
XFILLER_14_277 VGND VGND VPWR VPWR sky130_fd_sc_hd__decap_3
XFILLER_30_737 VGND VGND VPWR VPWR sky130_fd_sc_hd__decap_3
XFILLER_42_575 VGND VGND VPWR VPWR sky130_fd_sc_hd__decap_3
XFILLER_14_299 VGND VGND VPWR VPWR sky130_fd_sc_hd__decap_3
XFILLER_10_461 VGND VGND VPWR VPWR sky130_fd_sc_hd__decap_3
XFILLER_127_102 VGND VGND VPWR VPWR sky130_fd_sc_hd__decap_3
XFILLER_127_113 VGND VGND VPWR VPWR sky130_fd_sc_hd__decap_3
XFILLER_128_625 VGND VGND VPWR VPWR sky130_fd_sc_hd__decap_3
XFILLER_80_97 VGND VGND VPWR VPWR sky130_fd_sc_hd__fill_2
XTAP_TAPCELL_ROW_12_456 VGND VPWR sky130_fd_sc_hd__tapvpwrvgnd_1
XTAP_TAPCELL_ROW_12_467 VGND VPWR sky130_fd_sc_hd__tapvpwrvgnd_1
XFILLER_128_669 VGND VGND VPWR VPWR sky130_fd_sc_hd__decap_3
XFILLER_6_421 VGND VGND VPWR VPWR sky130_fd_sc_hd__fill_1
XPHY_EDGE_ROW_108_Right_108 VGND VGND VPWR VPWR sky130_fd_sc_hd__decap_3
XFILLER_135_190 VGND VGND VPWR VPWR sky130_fd_sc_hd__decap_3
XFILLER_2_660 VGND VGND VPWR VPWR sky130_fd_sc_hd__decap_3
XFILLER_97_715 VGND VGND VPWR VPWR sky130_fd_sc_hd__decap_3
XFILLER_123_396 VGND VGND VPWR VPWR sky130_fd_sc_hd__fill_2
XFILLER_2_693 VGND VGND VPWR VPWR sky130_fd_sc_hd__decap_3
XTAP_TAPCELL_ROW_88_1524 VGND VPWR sky130_fd_sc_hd__tapvpwrvgnd_1
XFILLER_37_347 VGND VGND VPWR VPWR sky130_fd_sc_hd__decap_3
XFILLER_64_133 VGND VGND VPWR VPWR sky130_fd_sc_hd__decap_3
XFILLER_65_667 VGND VGND VPWR VPWR sky130_fd_sc_hd__decap_3
XFILLER_80_604 VGND VGND VPWR VPWR sky130_fd_sc_hd__decap_3
XFILLER_92_453 VGND VGND VPWR VPWR sky130_fd_sc_hd__fill_2
X_5970_ _7177_/A _5970_/B VGND VGND VPWR VPWR _6097_/A sky130_fd_sc_hd__nor2_2
XFILLER_45_380 VGND VGND VPWR VPWR sky130_fd_sc_hd__decap_3
XFILLER_64_188 VGND VGND VPWR VPWR sky130_fd_sc_hd__fill_1
X_4921_ _4921_/A VGND VGND VPWR VPWR _4921_/X sky130_fd_sc_hd__buf_1
XFILLER_33_542 VGND VGND VPWR VPWR sky130_fd_sc_hd__fill_1
X_7640_ _8622_/CLK _7640_/D wire657/X VGND VGND VPWR VPWR _7640_/Q sky130_fd_sc_hd__dfrtp_2
X_4852_ _4852_/A _4852_/B VGND VGND VPWR VPWR _4853_/A sky130_fd_sc_hd__and2_2
XFILLER_21_737 VGND VGND VPWR VPWR sky130_fd_sc_hd__decap_3
XFILLER_33_586 VGND VGND VPWR VPWR sky130_fd_sc_hd__decap_3
XFILLER_60_383 VGND VGND VPWR VPWR sky130_fd_sc_hd__fill_1
X_3803_ _3889_/A VGND VGND VPWR VPWR _3817_/A sky130_fd_sc_hd__clkbuf_2
XTAP_TAPCELL_ROW_31_721 VGND VPWR sky130_fd_sc_hd__tapvpwrvgnd_1
XTAP_TAPCELL_ROW_31_732 VGND VPWR sky130_fd_sc_hd__tapvpwrvgnd_1
X_7571_ _8634_/CLK _7571_/D load_slew605/X VGND VGND VPWR VPWR _7571_/Q sky130_fd_sc_hd__dfrtp_2
X_4783_ _7455_/A VGND VGND VPWR VPWR _4820_/S sky130_fd_sc_hd__buf_2
XFILLER_119_614 VGND VGND VPWR VPWR sky130_fd_sc_hd__fill_2
X_3734_ _3758_/A VGND VGND VPWR VPWR _4460_/A sky130_fd_sc_hd__clkbuf_2
X_6522_ _5015_/X _8313_/Q _6528_/S VGND VGND VPWR VPWR _6523_/A sky130_fd_sc_hd__mux2_2
XFILLER_109_28 VGND VGND VPWR VPWR sky130_fd_sc_hd__decap_3
XFILLER_119_658 VGND VGND VPWR VPWR sky130_fd_sc_hd__decap_3
XTAP_TAPCELL_ROW_99_1675 VGND VPWR sky130_fd_sc_hd__tapvpwrvgnd_1
X_6453_ _4879_/X _8281_/Q _6461_/S VGND VGND VPWR VPWR _6454_/A sky130_fd_sc_hd__mux2_2
XFILLER_133_105 VGND VGND VPWR VPWR sky130_fd_sc_hd__decap_3
XFILLER_133_116 VGND VGND VPWR VPWR sky130_fd_sc_hd__decap_3
Xclkload40 _8801_/CLK VGND VGND VPWR VPWR clkload40/X sky130_fd_sc_hd__clkbuf_8
Xclkload51 _8786_/CLK VGND VGND VPWR VPWR clkload51/X sky130_fd_sc_hd__clkbuf_4
Xclkload62 _8672_/CLK VGND VGND VPWR VPWR clkload62/X sky130_fd_sc_hd__clkbuf_8
X_5404_ _5404_/A VGND VGND VPWR VPWR _7751_/D sky130_fd_sc_hd__buf_1
XFILLER_127_691 VGND VGND VPWR VPWR sky130_fd_sc_hd__decap_3
XFILLER_133_149 VGND VGND VPWR VPWR sky130_fd_sc_hd__decap_3
Xclkload73 _8758_/CLK VGND VGND VPWR VPWR clkload73/X sky130_fd_sc_hd__clkbuf_8
X_8123_ _8771_/CLK _8123_/D load_slew570/X VGND VGND VPWR VPWR _8123_/Q sky130_fd_sc_hd__dfrtp_2
X_6384_ _4740_/X _8248_/Q _6398_/S VGND VGND VPWR VPWR _6385_/A sky130_fd_sc_hd__mux2_2
XFILLER_88_704 VGND VGND VPWR VPWR sky130_fd_sc_hd__decap_3
X_5335_ _6314_/A _7004_/B _6314_/C _5679_/D VGND VGND VPWR VPWR _5336_/A sky130_fd_sc_hd__and4b_2
XFILLER_102_525 VGND VGND VPWR VPWR sky130_fd_sc_hd__decap_3
XFILLER_102_536 VGND VGND VPWR VPWR sky130_fd_sc_hd__fill_1
XFILLER_125_27 VGND VGND VPWR VPWR sky130_fd_sc_hd__decap_3
XFILLER_87_214 VGND VGND VPWR VPWR sky130_fd_sc_hd__decap_3
XTAP_TAPCELL_ROW_110_1831 VGND VPWR sky130_fd_sc_hd__tapvpwrvgnd_1
X_8054_ _8783_/CLK _8054_/D load_slew682/X VGND VGND VPWR VPWR _8054_/Q sky130_fd_sc_hd__dfrtp_2
X_5266_ _7687_/Q _4807_/X _5268_/S VGND VGND VPWR VPWR _5267_/A sky130_fd_sc_hd__mux2_2
X_7005_ _7005_/A VGND VGND VPWR VPWR _7174_/S sky130_fd_sc_hd__buf_2
X_4217_ _8002_/Q _4286_/A2 _3785_/X _7921_/Q _4231_/A VGND VGND VPWR VPWR _4217_/X
+ sky130_fd_sc_hd__o221a_2
XFILLER_68_483 VGND VGND VPWR VPWR sky130_fd_sc_hd__decap_3
X_5197_ _7654_/Q _5011_/X _5205_/S VGND VGND VPWR VPWR _5198_/A sky130_fd_sc_hd__mux2_2
XFILLER_110_580 VGND VGND VPWR VPWR sky130_fd_sc_hd__decap_3
XFILLER_18_47 VGND VGND VPWR VPWR sky130_fd_sc_hd__decap_3
XTAP_TAPCELL_ROW_39_832 VGND VPWR sky130_fd_sc_hd__tapvpwrvgnd_1
XTAP_TAPCELL_ROW_39_843 VGND VPWR sky130_fd_sc_hd__tapvpwrvgnd_1
X_4148_ _8735_/Q _7510_/Q _7591_/Q _7672_/Q _4150_/S _4146_/A VGND VGND VPWR VPWR
+ _4148_/X sky130_fd_sc_hd__mux4_2
X_4079_ _8647_/Q _4195_/A2 _3744_/X _8566_/Q _3955_/A VGND VGND VPWR VPWR _4079_/X
+ sky130_fd_sc_hd__o221a_2
XFILLER_71_637 VGND VGND VPWR VPWR sky130_fd_sc_hd__decap_3
X_7907_ _8483_/CLK _7907_/D fanout502/A VGND VGND VPWR VPWR _7907_/Q sky130_fd_sc_hd__dfrtp_2
XFILLER_24_542 VGND VGND VPWR VPWR sky130_fd_sc_hd__decap_3
XFILLER_12_715 VGND VGND VPWR VPWR sky130_fd_sc_hd__decap_3
XFILLER_34_79 VGND VGND VPWR VPWR sky130_fd_sc_hd__fill_2
X_7838_ _8495_/CLK _7838_/D load_slew509/X VGND VGND VPWR VPWR _7838_/Q sky130_fd_sc_hd__dfrtp_2
XFILLER_11_225 VGND VGND VPWR VPWR sky130_fd_sc_hd__decap_3
XFILLER_8_719 VGND VGND VPWR VPWR sky130_fd_sc_hd__decap_3
XTAP_TAPCELL_ROW_121_1982 VGND VPWR sky130_fd_sc_hd__tapvpwrvgnd_1
XTAP_TAPCELL_ROW_121_1993 VGND VPWR sky130_fd_sc_hd__tapvpwrvgnd_1
X_7769_ _8744_/CLK _7769_/D load_slew626/X VGND VGND VPWR VPWR _7769_/Q sky130_fd_sc_hd__dfrtp_2
XFILLER_7_207 VGND VGND VPWR VPWR sky130_fd_sc_hd__decap_3
Xclkload1 clkload1/A VGND VGND VPWR VPWR clkload1/X sky130_fd_sc_hd__clkbuf_8
XTAP_TAPCELL_ROW_59_1114 VGND VPWR sky130_fd_sc_hd__tapvpwrvgnd_1
XFILLER_119_3 VGND VGND VPWR VPWR sky130_fd_sc_hd__decap_3
XTAP_TAPCELL_ROW_59_1125 VGND VPWR sky130_fd_sc_hd__tapvpwrvgnd_1
XFILLER_118_691 VGND VGND VPWR VPWR sky130_fd_sc_hd__fill_1
XFILLER_105_363 VGND VGND VPWR VPWR sky130_fd_sc_hd__decap_3
XFILLER_133_650 VGND VGND VPWR VPWR sky130_fd_sc_hd__decap_3
XFILLER_1_3 VGND VGND VPWR VPWR sky130_fd_sc_hd__decap_3
XFILLER_59_43 VGND VGND VPWR VPWR sky130_fd_sc_hd__decap_3
XTAP_TAPCELL_ROW_72_1303 VGND VPWR sky130_fd_sc_hd__tapvpwrvgnd_1
XFILLER_105_396 VGND VGND VPWR VPWR sky130_fd_sc_hd__fill_1
XFILLER_132_171 VGND VGND VPWR VPWR sky130_fd_sc_hd__decap_3
XFILLER_133_694 VGND VGND VPWR VPWR sky130_fd_sc_hd__decap_3
XFILLER_78_236 VGND VGND VPWR VPWR sky130_fd_sc_hd__decap_3
XFILLER_120_333 VGND VGND VPWR VPWR sky130_fd_sc_hd__decap_3
XFILLER_115_60 VGND VGND VPWR VPWR sky130_fd_sc_hd__decap_3
XFILLER_46_100 VGND VGND VPWR VPWR sky130_fd_sc_hd__fill_2
XFILLER_120_399 VGND VGND VPWR VPWR sky130_fd_sc_hd__decap_3
XFILLER_75_42 VGND VGND VPWR VPWR sky130_fd_sc_hd__fill_2
Xfanout293 _3853_/C1 VGND VGND VPWR VPWR _4684_/C1 sky130_fd_sc_hd__clkdlybuf4s25_1
XFILLER_34_306 VGND VGND VPWR VPWR sky130_fd_sc_hd__fill_2
XFILLER_46_144 VGND VGND VPWR VPWR sky130_fd_sc_hd__fill_2
XFILLER_47_667 VGND VGND VPWR VPWR sky130_fd_sc_hd__decap_3
XFILLER_47_678 VGND VGND VPWR VPWR sky130_fd_sc_hd__fill_2
XFILLER_34_317 VGND VGND VPWR VPWR sky130_fd_sc_hd__decap_3
XFILLER_61_103 VGND VGND VPWR VPWR sky130_fd_sc_hd__decap_3
XFILLER_62_648 VGND VGND VPWR VPWR sky130_fd_sc_hd__decap_3
XTAP_TAPCELL_ROW_17_526 VGND VPWR sky130_fd_sc_hd__tapvpwrvgnd_1
XTAP_TAPCELL_ROW_17_537 VGND VPWR sky130_fd_sc_hd__tapvpwrvgnd_1
XFILLER_131_81 VGND VGND VPWR VPWR sky130_fd_sc_hd__decap_3
XTAP_TAPCELL_ROW_83_1454 VGND VPWR sky130_fd_sc_hd__tapvpwrvgnd_1
XFILLER_42_361 VGND VGND VPWR VPWR sky130_fd_sc_hd__decap_3
XFILLER_91_63 VGND VGND VPWR VPWR sky130_fd_sc_hd__decap_3
XFILLER_91_85 VGND VGND VPWR VPWR sky130_fd_sc_hd__decap_3
XFILLER_42_383 VGND VGND VPWR VPWR sky130_fd_sc_hd__decap_3
XFILLER_30_578 VGND VGND VPWR VPWR sky130_fd_sc_hd__decap_3
XFILLER_10_280 VGND VGND VPWR VPWR sky130_fd_sc_hd__decap_3
XFILLER_128_433 VGND VGND VPWR VPWR sky130_fd_sc_hd__decap_3
XFILLER_7_741 VGND VGND VPWR VPWR sky130_fd_sc_hd__decap_3
XFILLER_116_639 VGND VGND VPWR VPWR sky130_fd_sc_hd__fill_2
XFILLER_128_466 VGND VGND VPWR VPWR sky130_fd_sc_hd__decap_3
XFILLER_128_477 VGND VGND VPWR VPWR sky130_fd_sc_hd__decap_3
XFILLER_6_262 VGND VGND VPWR VPWR sky130_fd_sc_hd__fill_2
XFILLER_7_774 VGND VGND VPWR VPWR sky130_fd_sc_hd__decap_3
XFILLER_7_785 VGND VGND VPWR VPWR sky130_fd_sc_hd__decap_3
XFILLER_109_691 VGND VGND VPWR VPWR sky130_fd_sc_hd__decap_3
XFILLER_131_609 VGND VGND VPWR VPWR sky130_fd_sc_hd__decap_3
XFILLER_124_672 VGND VGND VPWR VPWR sky130_fd_sc_hd__fill_2
XFILLER_34_3 VGND VGND VPWR VPWR sky130_fd_sc_hd__decap_3
XFILLER_97_523 VGND VGND VPWR VPWR sky130_fd_sc_hd__decap_3
X_5120_ _5120_/A VGND VGND VPWR VPWR _7618_/D sky130_fd_sc_hd__buf_1
XFILLER_97_567 VGND VGND VPWR VPWR sky130_fd_sc_hd__fill_1
Xload_slew655 fanout654/X VGND VGND VPWR VPWR load_slew655/X sky130_fd_sc_hd__buf_2
Xload_slew633 fanout632/X VGND VGND VPWR VPWR load_slew633/X sky130_fd_sc_hd__clkbuf_4
X_5051_ _4723_/X _7586_/Q _5053_/S VGND VGND VPWR VPWR _5052_/A sky130_fd_sc_hd__mux2_2
XFILLER_38_601 VGND VGND VPWR VPWR sky130_fd_sc_hd__decap_3
XFILLER_85_729 VGND VGND VPWR VPWR sky130_fd_sc_hd__fill_2
X_4002_ _4510_/A1 _4001_/X _3848_/X VGND VGND VPWR VPWR _4002_/X sky130_fd_sc_hd__o21a_2
Xload_slew699 fanout698/X VGND VGND VPWR VPWR load_slew699/X sky130_fd_sc_hd__buf_4
XFILLER_111_399 VGND VGND VPWR VPWR sky130_fd_sc_hd__fill_2
XFILLER_38_634 VGND VGND VPWR VPWR sky130_fd_sc_hd__decap_3
XFILLER_93_751 VGND VGND VPWR VPWR sky130_fd_sc_hd__decap_3
XFILLER_1_72 VGND VGND VPWR VPWR sky130_fd_sc_hd__decap_3
XFILLER_25_306 VGND VGND VPWR VPWR sky130_fd_sc_hd__decap_3
XTAP_TAPCELL_ROW_36_802 VGND VPWR sky130_fd_sc_hd__tapvpwrvgnd_1
XFILLER_52_125 VGND VGND VPWR VPWR sky130_fd_sc_hd__decap_3
XFILLER_53_648 VGND VGND VPWR VPWR sky130_fd_sc_hd__decap_3
X_8741_ _8743_/CLK _8741_/D wire519/A VGND VGND VPWR VPWR _8741_/Q sky130_fd_sc_hd__dfrtp_2
X_5953_ _5958_/A1 _5947_/X _4917_/X _5948_/X hold870/X VGND VGND VPWR VPWR _8037_/D
+ sky130_fd_sc_hd__a32o_2
X_8672_ _8672_/CLK _8672_/D fanout694/X VGND VGND VPWR VPWR _8672_/Q sky130_fd_sc_hd__dfrtp_2
X_5884_ _5893_/A1 _5893_/A2 _5031_/X _5893_/B1 hold808/X VGND VGND VPWR VPWR _7983_/D
+ sky130_fd_sc_hd__a32o_2
X_4904_ _4903_/X _7548_/Q _4904_/S VGND VGND VPWR VPWR _4905_/A sky130_fd_sc_hd__mux2_2
XFILLER_61_692 VGND VGND VPWR VPWR sky130_fd_sc_hd__fill_2
X_7623_ _8770_/CLK _7623_/D load_slew550/X VGND VGND VPWR VPWR _7623_/Q sky130_fd_sc_hd__dfrtp_2
X_4835_ _4835_/A VGND VGND VPWR VPWR _7531_/D sky130_fd_sc_hd__buf_1
XFILLER_119_400 VGND VGND VPWR VPWR sky130_fd_sc_hd__fill_1
X_7554_ _8779_/CLK _7554_/D wire746/X VGND VGND VPWR VPWR _7554_/Q sky130_fd_sc_hd__dfrtp_2
X_4766_ _4765_/X _4766_/A1 _4778_/S VGND VGND VPWR VPWR _4767_/A sky130_fd_sc_hd__mux2_2
XFILLER_119_455 VGND VGND VPWR VPWR sky130_fd_sc_hd__decap_3
X_3717_ _8052_/Q _3723_/B VGND VGND VPWR VPWR _7177_/A sky130_fd_sc_hd__nand2b_2
X_6505_ _4981_/X _8305_/Q _6507_/S VGND VGND VPWR VPWR _6506_/A sky130_fd_sc_hd__mux2_2
XFILLER_20_15 VGND VGND VPWR VPWR sky130_fd_sc_hd__decap_3
X_7485_ _5011_/X _8798_/Q _7495_/S VGND VGND VPWR VPWR _7486_/A sky130_fd_sc_hd__mux2_2
X_4697_ _5679_/D VGND VGND VPWR VPWR _5947_/A sky130_fd_sc_hd__clkbuf_2
XFILLER_134_436 VGND VGND VPWR VPWR sky130_fd_sc_hd__decap_3
XFILLER_20_59 VGND VGND VPWR VPWR sky130_fd_sc_hd__decap_3
X_6436_ _4845_/X _8273_/Q _6440_/S VGND VGND VPWR VPWR _6437_/A sky130_fd_sc_hd__mux2_2
X_6367_ _4707_/X _8240_/Q _6377_/S VGND VGND VPWR VPWR _6368_/A sky130_fd_sc_hd__mux2_2
XFILLER_114_160 VGND VGND VPWR VPWR sky130_fd_sc_hd__decap_3
XTAP_TAPCELL_ROW_54_1044 VGND VPWR sky130_fd_sc_hd__tapvpwrvgnd_1
X_8106_ _8754_/CLK _8106_/D load_slew691/X VGND VGND VPWR VPWR _8106_/Q sky130_fd_sc_hd__dfrtp_2
X_5318_ _5318_/A VGND VGND VPWR VPWR _7711_/D sky130_fd_sc_hd__buf_1
XFILLER_0_449 VGND VGND VPWR VPWR sky130_fd_sc_hd__fill_1
XFILLER_130_631 VGND VGND VPWR VPWR sky130_fd_sc_hd__decap_3
XTAP_TAPCELL_ROW_54_1055 VGND VPWR sky130_fd_sc_hd__tapvpwrvgnd_1
X_6298_ _4913_/X _8208_/Q _6310_/S VGND VGND VPWR VPWR _6299_/A sky130_fd_sc_hd__mux2_4
XFILLER_130_675 VGND VGND VPWR VPWR sky130_fd_sc_hd__decap_3
XFILLER_29_57 VGND VGND VPWR VPWR sky130_fd_sc_hd__fill_1
XFILLER_69_781 VGND VGND VPWR VPWR sky130_fd_sc_hd__decap_3
X_8037_ _8695_/CLK _8037_/D load_slew733/X VGND VGND VPWR VPWR _8037_/Q sky130_fd_sc_hd__dfrtp_2
X_5249_ _5333_/S VGND VGND VPWR VPWR _5268_/S sky130_fd_sc_hd__buf_2
XFILLER_28_122 VGND VGND VPWR VPWR sky130_fd_sc_hd__fill_1
XFILLER_75_228 VGND VGND VPWR VPWR sky130_fd_sc_hd__decap_3
XFILLER_29_667 VGND VGND VPWR VPWR sky130_fd_sc_hd__decap_3
XFILLER_44_648 VGND VGND VPWR VPWR sky130_fd_sc_hd__fill_2
XFILLER_43_169 VGND VGND VPWR VPWR sky130_fd_sc_hd__decap_3
XFILLER_129_208 VGND VGND VPWR VPWR sky130_fd_sc_hd__decap_3
XFILLER_12_545 VGND VGND VPWR VPWR sky130_fd_sc_hd__decap_3
XFILLER_51_191 VGND VGND VPWR VPWR sky130_fd_sc_hd__decap_3
XFILLER_12_589 VGND VGND VPWR VPWR sky130_fd_sc_hd__decap_3
XFILLER_61_66 VGND VGND VPWR VPWR sky130_fd_sc_hd__fill_1
XFILLER_61_88 VGND VGND VPWR VPWR sky130_fd_sc_hd__decap_3
XTAP_TAPCELL_ROW_22_595 VGND VPWR sky130_fd_sc_hd__tapvpwrvgnd_1
XFILLER_125_447 VGND VGND VPWR VPWR sky130_fd_sc_hd__fill_1
XFILLER_4_722 VGND VGND VPWR VPWR sky130_fd_sc_hd__decap_3
XFILLER_3_221 VGND VGND VPWR VPWR sky130_fd_sc_hd__decap_3
XFILLER_4_755 VGND VGND VPWR VPWR sky130_fd_sc_hd__fill_1
XFILLER_4_766 VGND VGND VPWR VPWR sky130_fd_sc_hd__decap_3
XFILLER_106_683 VGND VGND VPWR VPWR sky130_fd_sc_hd__fill_2
XFILLER_106_694 VGND VGND VPWR VPWR sky130_fd_sc_hd__decap_3
XFILLER_112_108 VGND VGND VPWR VPWR sky130_fd_sc_hd__decap_3
XFILLER_3_276 VGND VGND VPWR VPWR sky130_fd_sc_hd__fill_1
XFILLER_4_799 VGND VGND VPWR VPWR sky130_fd_sc_hd__decap_3
XPHY_EDGE_ROW_5_Left_141 VGND VGND VPWR VPWR sky130_fd_sc_hd__decap_3
XFILLER_121_631 VGND VGND VPWR VPWR sky130_fd_sc_hd__fill_2
XFILLER_133_491 VGND VGND VPWR VPWR sky130_fd_sc_hd__decap_3
XFILLER_120_141 VGND VGND VPWR VPWR sky130_fd_sc_hd__decap_3
XFILLER_20_9 VGND VGND VPWR VPWR sky130_fd_sc_hd__decap_3
XFILLER_86_41 VGND VGND VPWR VPWR sky130_fd_sc_hd__decap_3
XFILLER_59_291 VGND VGND VPWR VPWR sky130_fd_sc_hd__decap_3
XFILLER_66_239 VGND VGND VPWR VPWR sky130_fd_sc_hd__decap_3
XFILLER_86_85 VGND VGND VPWR VPWR sky130_fd_sc_hd__fill_1
XFILLER_19_133 VGND VGND VPWR VPWR sky130_fd_sc_hd__decap_3
XFILLER_34_147 VGND VGND VPWR VPWR sky130_fd_sc_hd__fill_1
XFILLER_90_754 VGND VGND VPWR VPWR sky130_fd_sc_hd__fill_2
XFILLER_62_489 VGND VGND VPWR VPWR sky130_fd_sc_hd__decap_3
XTAP_TAPCELL_ROW_41_860 VGND VPWR sky130_fd_sc_hd__tapvpwrvgnd_1
X_4620_ _8453_/Q _8534_/Q _4620_/S VGND VGND VPWR VPWR _4621_/B sky130_fd_sc_hd__mux2_2
XFILLER_128_230 VGND VGND VPWR VPWR sky130_fd_sc_hd__decap_3
XFILLER_129_753 VGND VGND VPWR VPWR sky130_fd_sc_hd__decap_3
XTAP_TAPCELL_ROW_41_871 VGND VPWR sky130_fd_sc_hd__tapvpwrvgnd_1
XFILLER_116_403 VGND VGND VPWR VPWR sky130_fd_sc_hd__decap_3
XFILLER_129_797 VGND VGND VPWR VPWR sky130_fd_sc_hd__decap_3
XTAP_TAPCELL_ROW_96_1634 VGND VPWR sky130_fd_sc_hd__tapvpwrvgnd_1
Xmax_cap202 _7257_/X VGND VGND VPWR VPWR _7266_/B1 sky130_fd_sc_hd__buf_4
X_4551_ _7708_/Q _3816_/X _4551_/B1 _7627_/Q _3732_/A VGND VGND VPWR VPWR _4551_/X
+ sky130_fd_sc_hd__o221a_2
XFILLER_116_436 VGND VGND VPWR VPWR sky130_fd_sc_hd__fill_2
XFILLER_7_593 VGND VGND VPWR VPWR sky130_fd_sc_hd__decap_3
Xmax_cap235 _7202_/X VGND VGND VPWR VPWR _7213_/A1 sky130_fd_sc_hd__buf_2
Xmax_cap224 _4734_/B VGND VGND VPWR VPWR _4726_/B sky130_fd_sc_hd__clkbuf_2
Xmax_cap213 _5907_/X VGND VGND VPWR VPWR _5919_/A1 sky130_fd_sc_hd__buf_2
X_7270_ _7270_/A VGND VGND VPWR VPWR _7270_/X sky130_fd_sc_hd__clkbuf_1
X_4482_ _4480_/X _4481_/X _4534_/A VGND VGND VPWR VPWR _4482_/X sky130_fd_sc_hd__mux2_2
Xmax_cap268 _3839_/S VGND VGND VPWR VPWR _4514_/S sky130_fd_sc_hd__buf_6
Xmax_cap257 _3769_/X VGND VGND VPWR VPWR _4652_/B1 sky130_fd_sc_hd__buf_6
Xmax_cap246 _3870_/X VGND VGND VPWR VPWR _4622_/B1 sky130_fd_sc_hd__clkbuf_8
X_6221_ _6221_/A VGND VGND VPWR VPWR _8171_/D sky130_fd_sc_hd__buf_6
XFILLER_124_480 VGND VGND VPWR VPWR sky130_fd_sc_hd__decap_3
XFILLER_131_439 VGND VGND VPWR VPWR sky130_fd_sc_hd__decap_3
X_6152_ _6152_/A VGND VGND VPWR VPWR _8138_/D sky130_fd_sc_hd__buf_6
XFILLER_106_29 VGND VGND VPWR VPWR sky130_fd_sc_hd__decap_3
Xload_slew430 _4550_/S VGND VGND VPWR VPWR _3957_/S sky130_fd_sc_hd__buf_4
X_5103_ _5103_/A VGND VGND VPWR VPWR _7610_/D sky130_fd_sc_hd__buf_1
XFILLER_85_526 VGND VGND VPWR VPWR sky130_fd_sc_hd__decap_3
Xload_slew452 _3861_/S VGND VGND VPWR VPWR _3814_/S sky130_fd_sc_hd__buf_2
X_6083_ _8107_/Q _4828_/A _6095_/S VGND VGND VPWR VPWR _6084_/A sky130_fd_sc_hd__mux2_2
XFILLER_66_740 VGND VGND VPWR VPWR sky130_fd_sc_hd__decap_3
Xload_slew496 fanout495/X VGND VGND VPWR VPWR load_slew496/X sky130_fd_sc_hd__clkbuf_2
X_5034_ _5034_/A VGND VGND VPWR VPWR _7578_/D sky130_fd_sc_hd__buf_1
XFILLER_122_17 VGND VGND VPWR VPWR sky130_fd_sc_hd__decap_3
XTAP_TAPCELL_ROW_123_2008 VGND VPWR sky130_fd_sc_hd__tapvpwrvgnd_1
XTAP_TAPCELL_ROW_123_2019 VGND VPWR sky130_fd_sc_hd__tapvpwrvgnd_1
XFILLER_26_648 VGND VGND VPWR VPWR sky130_fd_sc_hd__decap_3
XFILLER_38_486 VGND VGND VPWR VPWR sky130_fd_sc_hd__fill_2
XTAP_TAPCELL_ROW_49_982 VGND VPWR sky130_fd_sc_hd__tapvpwrvgnd_1
XFILLER_41_607 VGND VGND VPWR VPWR sky130_fd_sc_hd__fill_1
XFILLER_53_456 VGND VGND VPWR VPWR sky130_fd_sc_hd__decap_3
XTAP_TAPCELL_ROW_0_279 VGND VPWR sky130_fd_sc_hd__tapvpwrvgnd_1
X_6985_ _6985_/A VGND VGND VPWR VPWR _8530_/D sky130_fd_sc_hd__buf_6
XFILLER_15_15 VGND VGND VPWR VPWR sky130_fd_sc_hd__decap_3
XFILLER_15_48 VGND VGND VPWR VPWR sky130_fd_sc_hd__decap_3
XFILLER_80_253 VGND VGND VPWR VPWR sky130_fd_sc_hd__decap_3
XFILLER_80_275 VGND VGND VPWR VPWR sky130_fd_sc_hd__decap_3
XTAP_TAPCELL_ROW_105_1763 VGND VPWR sky130_fd_sc_hd__tapvpwrvgnd_1
X_8724_ _8724_/CLK _8724_/D fanout502/A VGND VGND VPWR VPWR _8724_/Q sky130_fd_sc_hd__dfrtp_2
X_5936_ _5944_/A1 _5934_/X _4857_/X _5935_/X hold865/X VGND VGND VPWR VPWR _8023_/D
+ sky130_fd_sc_hd__a32o_2
XFILLER_21_320 VGND VGND VPWR VPWR sky130_fd_sc_hd__decap_3
XFILLER_33_180 VGND VGND VPWR VPWR sky130_fd_sc_hd__decap_3
X_8655_ _8655_/CLK _8655_/D load_slew484/X VGND VGND VPWR VPWR _8655_/Q sky130_fd_sc_hd__dfrtp_2
X_7606_ _8750_/CLK _7606_/D load_slew636/X VGND VGND VPWR VPWR _7606_/Q sky130_fd_sc_hd__dfrtp_2
X_5867_ _5867_/A1 _5867_/A2 _4985_/X _5857_/X hold869/X VGND VGND VPWR VPWR _7972_/D
+ sky130_fd_sc_hd__a32o_2
XFILLER_21_375 VGND VGND VPWR VPWR sky130_fd_sc_hd__decap_3
X_8586_ _8586_/CLK _8586_/D fanout539/X VGND VGND VPWR VPWR _8586_/Q sky130_fd_sc_hd__dfrtp_2
X_5798_ _5798_/A VGND VGND VPWR VPWR _7937_/D sky130_fd_sc_hd__buf_1
X_4818_ _4818_/A _4818_/B VGND VGND VPWR VPWR _4819_/A sky130_fd_sc_hd__and2_2
XFILLER_135_701 VGND VGND VPWR VPWR sky130_fd_sc_hd__decap_3
X_7537_ _8799_/CLK _7537_/D wire600/X VGND VGND VPWR VPWR _7537_/Q sky130_fd_sc_hd__dfrtp_2
X_4749_ _4749_/A VGND VGND VPWR VPWR _4749_/X sky130_fd_sc_hd__buf_1
XFILLER_107_414 VGND VGND VPWR VPWR sky130_fd_sc_hd__decap_3
XFILLER_134_200 VGND VGND VPWR VPWR sky130_fd_sc_hd__decap_3
X_7468_ _4977_/X hold955/X _7474_/S VGND VGND VPWR VPWR _7469_/A sky130_fd_sc_hd__mux2_2
XFILLER_103_6 VGND VGND VPWR VPWR sky130_fd_sc_hd__decap_3
XFILLER_107_458 VGND VGND VPWR VPWR sky130_fd_sc_hd__decap_3
XFILLER_134_244 VGND VGND VPWR VPWR sky130_fd_sc_hd__decap_3
XFILLER_135_778 VGND VGND VPWR VPWR sky130_fd_sc_hd__decap_3
X_6419_ _4811_/X _8265_/Q _6419_/S VGND VGND VPWR VPWR _6420_/A sky130_fd_sc_hd__mux2_2
XFILLER_134_277 VGND VGND VPWR VPWR sky130_fd_sc_hd__decap_3
XFILLER_1_703 VGND VGND VPWR VPWR sky130_fd_sc_hd__decap_3
X_7399_ _8757_/Q _4836_/A _7407_/S VGND VGND VPWR VPWR _7400_/A sky130_fd_sc_hd__mux2_2
XFILLER_1_747 VGND VGND VPWR VPWR sky130_fd_sc_hd__decap_3
XFILLER_102_141 VGND VGND VPWR VPWR sky130_fd_sc_hd__decap_3
XFILLER_130_472 VGND VGND VPWR VPWR sky130_fd_sc_hd__decap_3
XFILLER_49_729 VGND VGND VPWR VPWR sky130_fd_sc_hd__decap_3
XFILLER_76_526 VGND VGND VPWR VPWR sky130_fd_sc_hd__decap_3
XFILLER_130_483 VGND VGND VPWR VPWR sky130_fd_sc_hd__decap_3
XFILLER_76_548 VGND VGND VPWR VPWR sky130_fd_sc_hd__decap_3
XFILLER_56_44 VGND VGND VPWR VPWR sky130_fd_sc_hd__decap_3
XFILLER_57_762 VGND VGND VPWR VPWR sky130_fd_sc_hd__decap_3
XFILLER_63_209 VGND VGND VPWR VPWR sky130_fd_sc_hd__decap_3
XTAP_TAPCELL_ROW_67_1224 VGND VPWR sky130_fd_sc_hd__tapvpwrvgnd_1
XFILLER_16_136 VGND VGND VPWR VPWR sky130_fd_sc_hd__decap_3
XFILLER_17_648 VGND VGND VPWR VPWR sky130_fd_sc_hd__decap_3
XFILLER_71_242 VGND VGND VPWR VPWR sky130_fd_sc_hd__decap_3
XTAP_TAPCELL_ROW_67_1235 VGND VPWR sky130_fd_sc_hd__tapvpwrvgnd_1
XFILLER_71_264 VGND VGND VPWR VPWR sky130_fd_sc_hd__decap_3
XTAP_TAPCELL_ROW_27_665 VGND VPWR sky130_fd_sc_hd__tapvpwrvgnd_1
XTAP_TAPCELL_ROW_27_676 VGND VPWR sky130_fd_sc_hd__tapvpwrvgnd_1
XFILLER_25_692 VGND VGND VPWR VPWR sky130_fd_sc_hd__decap_3
XTAP_TAPCELL_ROW_80_1413 VGND VPWR sky130_fd_sc_hd__tapvpwrvgnd_1
XFILLER_9_803 VGND VGND VPWR VPWR sky130_fd_sc_hd__fill_1
XFILLER_40_684 VGND VGND VPWR VPWR sky130_fd_sc_hd__decap_3
XFILLER_126_701 VGND VGND VPWR VPWR sky130_fd_sc_hd__fill_1
XFILLER_8_357 VGND VGND VPWR VPWR sky130_fd_sc_hd__decap_3
XFILLER_8_368 VGND VGND VPWR VPWR sky130_fd_sc_hd__decap_3
XFILLER_8_379 VGND VGND VPWR VPWR sky130_fd_sc_hd__decap_3
XFILLER_126_723 VGND VGND VPWR VPWR sky130_fd_sc_hd__decap_3
XFILLER_126_778 VGND VGND VPWR VPWR sky130_fd_sc_hd__decap_3
XFILLER_4_530 VGND VGND VPWR VPWR sky130_fd_sc_hd__fill_2
XTAP_TAPCELL_ROW_78_1386 VGND VPWR sky130_fd_sc_hd__tapvpwrvgnd_1
XFILLER_113_439 VGND VGND VPWR VPWR sky130_fd_sc_hd__fill_2
XFILLER_125_299 VGND VGND VPWR VPWR sky130_fd_sc_hd__fill_2
XFILLER_99_629 VGND VGND VPWR VPWR sky130_fd_sc_hd__decap_3
XFILLER_106_480 VGND VGND VPWR VPWR sky130_fd_sc_hd__decap_3
XFILLER_79_331 VGND VGND VPWR VPWR sky130_fd_sc_hd__decap_3
XTAP_TAPCELL_ROW_91_1564 VGND VPWR sky130_fd_sc_hd__tapvpwrvgnd_1
XFILLER_79_364 VGND VGND VPWR VPWR sky130_fd_sc_hd__decap_3
XFILLER_0_791 VGND VGND VPWR VPWR sky130_fd_sc_hd__decap_3
XFILLER_121_472 VGND VGND VPWR VPWR sky130_fd_sc_hd__decap_3
XFILLER_67_537 VGND VGND VPWR VPWR sky130_fd_sc_hd__fill_1
XTAP_TAPCELL_ROW_7_390 VGND VPWR sky130_fd_sc_hd__tapvpwrvgnd_1
XFILLER_47_272 VGND VGND VPWR VPWR sky130_fd_sc_hd__decap_3
XTAP_TAPCELL_ROW_46_930 VGND VPWR sky130_fd_sc_hd__tapvpwrvgnd_1
XTAP_TAPCELL_ROW_46_941 VGND VPWR sky130_fd_sc_hd__tapvpwrvgnd_1
XFILLER_23_629 VGND VGND VPWR VPWR sky130_fd_sc_hd__fill_1
XFILLER_90_562 VGND VGND VPWR VPWR sky130_fd_sc_hd__decap_3
X_3982_ _7899_/Q _4631_/A2 _3981_/X _3984_/A _4467_/A1 VGND VGND VPWR VPWR _3982_/X
+ sky130_fd_sc_hd__o221a_2
X_6770_ _8429_/Q _4818_/A _6786_/S VGND VGND VPWR VPWR _6771_/A sky130_fd_sc_hd__mux2_2
XFILLER_15_180 VGND VGND VPWR VPWR sky130_fd_sc_hd__decap_3
X_5721_ _7901_/Q _5027_/A _5721_/S VGND VGND VPWR VPWR _5722_/A sky130_fd_sc_hd__mux2_2
XFILLER_30_172 VGND VGND VPWR VPWR sky130_fd_sc_hd__decap_3
XFILLER_31_673 VGND VGND VPWR VPWR sky130_fd_sc_hd__decap_3
X_8440_ _8683_/CLK _8440_/D fanout566/X VGND VGND VPWR VPWR _8440_/Q sky130_fd_sc_hd__dfrtp_2
X_5652_ _7869_/Q _4891_/A _5654_/S VGND VGND VPWR VPWR _5653_/A sky130_fd_sc_hd__mux2_2
XFILLER_129_550 VGND VGND VPWR VPWR sky130_fd_sc_hd__decap_3
XFILLER_129_561 VGND VGND VPWR VPWR sky130_fd_sc_hd__decap_3
XTAP_TAPCELL_ROW_100_1693 VGND VPWR sky130_fd_sc_hd__tapvpwrvgnd_1
X_8371_ _8695_/CLK _8371_/D load_slew733/X VGND VGND VPWR VPWR _8371_/Q sky130_fd_sc_hd__dfrtp_2
X_5583_ _7836_/Q _4753_/A _5591_/S VGND VGND VPWR VPWR _5584_/A sky130_fd_sc_hd__mux2_2
X_4603_ _4633_/A _4603_/B VGND VGND VPWR VPWR _4603_/X sky130_fd_sc_hd__or2_2
XFILLER_129_594 VGND VGND VPWR VPWR sky130_fd_sc_hd__decap_3
XFILLER_7_60 VGND VGND VPWR VPWR sky130_fd_sc_hd__decap_3
XPHY_EDGE_ROW_68_Left_204 VGND VGND VPWR VPWR sky130_fd_sc_hd__decap_3
X_7322_ _7322_/A VGND VGND VPWR VPWR _8720_/D sky130_fd_sc_hd__buf_1
X_4534_ _4534_/A _4534_/B VGND VGND VPWR VPWR _4534_/X sky130_fd_sc_hd__or2_2
XFILLER_116_233 VGND VGND VPWR VPWR sky130_fd_sc_hd__decap_3
XFILLER_132_704 VGND VGND VPWR VPWR sky130_fd_sc_hd__decap_3
XFILLER_131_214 VGND VGND VPWR VPWR sky130_fd_sc_hd__decap_3
XFILLER_132_737 VGND VGND VPWR VPWR sky130_fd_sc_hd__decap_3
X_7253_ _7253_/A1 _4849_/X _7243_/X _7244_/X hold896/X VGND VGND VPWR VPWR _8679_/D
+ sky130_fd_sc_hd__a32o_2
X_4465_ _4465_/A _4465_/B VGND VGND VPWR VPWR _4465_/X sky130_fd_sc_hd__or2_2
XFILLER_131_225 VGND VGND VPWR VPWR sky130_fd_sc_hd__decap_3
XFILLER_98_651 VGND VGND VPWR VPWR sky130_fd_sc_hd__decap_3
X_7184_ _7188_/A1 _4965_/X _7187_/A3 _7187_/B1 hold765/X VGND VGND VPWR VPWR _8625_/D
+ sky130_fd_sc_hd__a32o_2
X_6204_ _6204_/A VGND VGND VPWR VPWR _8163_/D sky130_fd_sc_hd__buf_6
X_4396_ _4458_/B2 _4391_/X _4393_/X _4395_/X VGND VGND VPWR VPWR _4396_/X sky130_fd_sc_hd__a22o_2
XFILLER_131_258 VGND VGND VPWR VPWR sky130_fd_sc_hd__decap_3
XFILLER_86_802 VGND VGND VPWR VPWR sky130_fd_sc_hd__fill_2
XTAP_TAPCELL_ROW_51_1003 VGND VPWR sky130_fd_sc_hd__tapvpwrvgnd_1
X_6135_ _8132_/Q _4932_/A _6137_/S VGND VGND VPWR VPWR _6136_/A sky130_fd_sc_hd__mux2_2
XFILLER_100_645 VGND VGND VPWR VPWR sky130_fd_sc_hd__fill_2
XFILLER_133_27 VGND VGND VPWR VPWR sky130_fd_sc_hd__decap_3
XFILLER_97_172 VGND VGND VPWR VPWR sky130_fd_sc_hd__decap_3
Xhold1002 _7912_/Q VGND VGND VPWR VPWR _5745_/A0 sky130_fd_sc_hd__dlygate4sd3_1
Xhold1013 _7553_/Q VGND VGND VPWR VPWR _4926_/A1 sky130_fd_sc_hd__dlygate4sd3_1
Xhold1024 _8261_/Q VGND VGND VPWR VPWR _6411_/A1 sky130_fd_sc_hd__dlygate4sd3_1
Xload_slew282 _3733_/A VGND VGND VPWR VPWR _4241_/S sky130_fd_sc_hd__clkbuf_2
X_6066_ _8099_/Q _4794_/A _6074_/S VGND VGND VPWR VPWR _6067_/A sky130_fd_sc_hd__mux2_2
XPHY_EDGE_ROW_77_Left_213 VGND VGND VPWR VPWR sky130_fd_sc_hd__decap_3
Xhold1035 _7536_/Q VGND VGND VPWR VPWR _4854_/A1 sky130_fd_sc_hd__dlygate4sd3_1
Xhold1046 _8073_/Q VGND VGND VPWR VPWR _6011_/A0 sky130_fd_sc_hd__dlygate4sd3_1
Xhold1057 _7530_/Q VGND VGND VPWR VPWR _4830_/A1 sky130_fd_sc_hd__dlygate4sd3_1
X_5017_ _5017_/A VGND VGND VPWR VPWR _7574_/D sky130_fd_sc_hd__buf_1
XFILLER_73_529 VGND VGND VPWR VPWR sky130_fd_sc_hd__decap_3
Xhold1068 _7643_/Q VGND VGND VPWR VPWR _5174_/A0 sky130_fd_sc_hd__dlygate4sd3_1
XFILLER_26_47 VGND VGND VPWR VPWR sky130_fd_sc_hd__decap_3
XFILLER_53_220 VGND VGND VPWR VPWR sky130_fd_sc_hd__decap_3
XFILLER_54_732 VGND VGND VPWR VPWR sky130_fd_sc_hd__decap_3
XFILLER_66_592 VGND VGND VPWR VPWR sky130_fd_sc_hd__decap_3
XFILLER_41_437 VGND VGND VPWR VPWR sky130_fd_sc_hd__decap_3
XTAP_TAPCELL_ROW_24_624 VGND VPWR sky130_fd_sc_hd__tapvpwrvgnd_1
XTAP_TAPCELL_ROW_24_635 VGND VPWR sky130_fd_sc_hd__tapvpwrvgnd_1
X_8707_ _8710_/CLK _8707_/D load_slew663/X VGND VGND VPWR VPWR _8707_/Q sky130_fd_sc_hd__dfrtp_2
X_6968_ _6968_/A VGND VGND VPWR VPWR _8522_/D sky130_fd_sc_hd__buf_6
XFILLER_10_802 VGND VGND VPWR VPWR sky130_fd_sc_hd__fill_2
XFILLER_22_651 VGND VGND VPWR VPWR sky130_fd_sc_hd__fill_2
XFILLER_22_662 VGND VGND VPWR VPWR sky130_fd_sc_hd__fill_1
XTAP_TAPCELL_ROW_62_1154 VGND VPWR sky130_fd_sc_hd__tapvpwrvgnd_1
X_6899_ _6899_/A VGND VGND VPWR VPWR _8489_/D sky130_fd_sc_hd__buf_6
X_5919_ _5919_/A1 _5919_/A2 _4811_/X _5919_/B1 hold784/X VGND VGND VPWR VPWR _8012_/D
+ sky130_fd_sc_hd__a32o_2
XFILLER_22_695 VGND VGND VPWR VPWR sky130_fd_sc_hd__decap_3
XFILLER_42_46 VGND VGND VPWR VPWR sky130_fd_sc_hd__decap_3
XTAP_TAPCELL_ROW_62_1165 VGND VPWR sky130_fd_sc_hd__tapvpwrvgnd_1
X_8638_ _8638_/CLK _8638_/D fanout585/X VGND VGND VPWR VPWR _8638_/Q sky130_fd_sc_hd__dfrtp_2
XFILLER_108_701 VGND VGND VPWR VPWR sky130_fd_sc_hd__fill_2
XPHY_EDGE_ROW_86_Left_222 VGND VGND VPWR VPWR sky130_fd_sc_hd__decap_3
X_8569_ _8569_/CLK _8569_/D load_slew494/X VGND VGND VPWR VPWR _8569_/Q sky130_fd_sc_hd__dfrtp_2
XFILLER_135_520 VGND VGND VPWR VPWR sky130_fd_sc_hd__decap_3
XTAP_TAPCELL_ROW_118_1943 VGND VPWR sky130_fd_sc_hd__tapvpwrvgnd_1
XFILLER_135_564 VGND VGND VPWR VPWR sky130_fd_sc_hd__decap_3
XFILLER_101_3 VGND VGND VPWR VPWR sky130_fd_sc_hd__fill_1
XFILLER_122_214 VGND VGND VPWR VPWR sky130_fd_sc_hd__decap_3
XFILLER_135_586 VGND VGND VPWR VPWR sky130_fd_sc_hd__fill_2
XFILLER_123_759 VGND VGND VPWR VPWR sky130_fd_sc_hd__decap_3
XFILLER_3_18 VGND VGND VPWR VPWR sky130_fd_sc_hd__decap_3
Xhold880 _8031_/Q VGND VGND VPWR VPWR hold880/X sky130_fd_sc_hd__dlygate4sd3_1
Xhold891 _8007_/Q VGND VGND VPWR VPWR hold891/X sky130_fd_sc_hd__dlygate4sd3_1
XFILLER_88_150 VGND VGND VPWR VPWR sky130_fd_sc_hd__fill_1
XFILLER_89_662 VGND VGND VPWR VPWR sky130_fd_sc_hd__fill_1
XFILLER_89_673 VGND VGND VPWR VPWR sky130_fd_sc_hd__decap_3
XFILLER_103_494 VGND VGND VPWR VPWR sky130_fd_sc_hd__decap_3
XFILLER_49_537 VGND VGND VPWR VPWR sky130_fd_sc_hd__decap_3
XFILLER_67_54 VGND VGND VPWR VPWR sky130_fd_sc_hd__fill_2
XPHY_EDGE_ROW_95_Left_231 VGND VGND VPWR VPWR sky130_fd_sc_hd__decap_3
XFILLER_29_272 VGND VGND VPWR VPWR sky130_fd_sc_hd__decap_3
XFILLER_64_518 VGND VGND VPWR VPWR sky130_fd_sc_hd__fill_2
XFILLER_64_529 VGND VGND VPWR VPWR sky130_fd_sc_hd__decap_3
XFILLER_123_93 VGND VGND VPWR VPWR sky130_fd_sc_hd__decap_3
XFILLER_17_445 VGND VGND VPWR VPWR sky130_fd_sc_hd__decap_3
XFILLER_45_732 VGND VGND VPWR VPWR sky130_fd_sc_hd__fill_2
XFILLER_91_337 VGND VGND VPWR VPWR sky130_fd_sc_hd__decap_3
XFILLER_44_253 VGND VGND VPWR VPWR sky130_fd_sc_hd__decap_3
XTAP_TAPCELL_ROW_43_900 VGND VPWR sky130_fd_sc_hd__tapvpwrvgnd_1
XFILLER_16_80 VGND VGND VPWR VPWR sky130_fd_sc_hd__decap_3
XFILLER_60_757 VGND VGND VPWR VPWR sky130_fd_sc_hd__decap_3
XFILLER_9_600 VGND VGND VPWR VPWR sky130_fd_sc_hd__decap_3
XFILLER_13_673 VGND VGND VPWR VPWR sky130_fd_sc_hd__decap_3
XFILLER_40_470 VGND VGND VPWR VPWR sky130_fd_sc_hd__decap_3
XFILLER_9_644 VGND VGND VPWR VPWR sky130_fd_sc_hd__decap_3
Xclkbuf_4_1_0_CLK clkbuf_0_CLK/X VGND VGND VPWR VPWR clkbuf_4_1_0_CLK/X sky130_fd_sc_hd__clkbuf_8
XFILLER_126_520 VGND VGND VPWR VPWR sky130_fd_sc_hd__decap_3
XFILLER_9_688 VGND VGND VPWR VPWR sky130_fd_sc_hd__decap_3
XFILLER_126_586 VGND VGND VPWR VPWR sky130_fd_sc_hd__fill_2
XFILLER_4_360 VGND VGND VPWR VPWR sky130_fd_sc_hd__decap_3
XFILLER_99_426 VGND VGND VPWR VPWR sky130_fd_sc_hd__decap_3
XFILLER_113_225 VGND VGND VPWR VPWR sky130_fd_sc_hd__decap_3
XFILLER_114_748 VGND VGND VPWR VPWR sky130_fd_sc_hd__decap_3
XFILLER_4_371 VGND VGND VPWR VPWR sky130_fd_sc_hd__decap_3
X_4250_ _7762_/Q _7843_/Q _7924_/Q _8005_/Q _4247_/S _4330_/A VGND VGND VPWR VPWR
+ _4250_/X sky130_fd_sc_hd__mux4_2
XFILLER_101_409 VGND VGND VPWR VPWR sky130_fd_sc_hd__decap_3
XFILLER_68_802 VGND VGND VPWR VPWR sky130_fd_sc_hd__fill_2
X_4181_ _4313_/A1 _4175_/X _4180_/X VGND VGND VPWR VPWR _4181_/X sky130_fd_sc_hd__o21a_2
XFILLER_67_334 VGND VGND VPWR VPWR sky130_fd_sc_hd__fill_2
XFILLER_121_291 VGND VGND VPWR VPWR sky130_fd_sc_hd__fill_2
XFILLER_95_654 VGND VGND VPWR VPWR sky130_fd_sc_hd__decap_3
XTAP_TAPCELL_ROW_2_319 VGND VPWR sky130_fd_sc_hd__tapvpwrvgnd_1
XFILLER_36_710 VGND VGND VPWR VPWR sky130_fd_sc_hd__fill_2
XFILLER_36_721 VGND VGND VPWR VPWR sky130_fd_sc_hd__decap_3
XFILLER_95_687 VGND VGND VPWR VPWR sky130_fd_sc_hd__decap_3
X_7940_ _8671_/CLK _7940_/D load_slew696/X VGND VGND VPWR VPWR _7940_/Q sky130_fd_sc_hd__dfrtp_2
XFILLER_94_197 VGND VGND VPWR VPWR sky130_fd_sc_hd__decap_3
X_7871_ _8694_/CLK _7871_/D load_slew720/X VGND VGND VPWR VPWR _7871_/Q sky130_fd_sc_hd__dfrtp_2
XFILLER_35_253 VGND VGND VPWR VPWR sky130_fd_sc_hd__decap_3
X_6822_ _8454_/Q _4924_/A _6828_/S VGND VGND VPWR VPWR _6823_/A sky130_fd_sc_hd__mux2_2
XFILLER_50_201 VGND VGND VPWR VPWR sky130_fd_sc_hd__decap_3
XFILLER_51_724 VGND VGND VPWR VPWR sky130_fd_sc_hd__decap_3
XTAP_TAPCELL_ROW_102_1722 VGND VPWR sky130_fd_sc_hd__tapvpwrvgnd_1
X_3965_ _4467_/A1 _3960_/X _3962_/X _3964_/X VGND VGND VPWR VPWR _3965_/X sky130_fd_sc_hd__a22o_2
X_6753_ _8421_/Q _4786_/A _6765_/S VGND VGND VPWR VPWR _6754_/A sky130_fd_sc_hd__mux2_2
X_3896_ _8712_/Q _8793_/Q _7568_/Q _7649_/Q _4007_/S _3984_/A VGND VGND VPWR VPWR
+ _3896_/X sky130_fd_sc_hd__mux4_2
X_6684_ _8388_/Q input4/X _6702_/S VGND VGND VPWR VPWR _6685_/A sky130_fd_sc_hd__mux2_2
X_5704_ _5704_/A VGND VGND VPWR VPWR _7892_/D sky130_fd_sc_hd__buf_1
XFILLER_12_27 VGND VGND VPWR VPWR sky130_fd_sc_hd__fill_1
XFILLER_31_481 VGND VGND VPWR VPWR sky130_fd_sc_hd__fill_1
XFILLER_31_492 VGND VGND VPWR VPWR sky130_fd_sc_hd__decap_3
X_8423_ _8747_/CLK _8423_/D fanout646/X VGND VGND VPWR VPWR _8423_/Q sky130_fd_sc_hd__dfrtp_2
X_5635_ _5677_/S VGND VGND VPWR VPWR _5654_/S sky130_fd_sc_hd__buf_2
XFILLER_128_27 VGND VGND VPWR VPWR sky130_fd_sc_hd__fill_1
XFILLER_12_38 VGND VGND VPWR VPWR sky130_fd_sc_hd__decap_3
XFILLER_128_38 VGND VGND VPWR VPWR sky130_fd_sc_hd__decap_3
XTAP_TAPCELL_ROW_131_2129 VGND VPWR sky130_fd_sc_hd__tapvpwrvgnd_1
X_8354_ _8680_/CLK _8354_/D fanout690/X VGND VGND VPWR VPWR _8354_/Q sky130_fd_sc_hd__dfrtp_2
X_5566_ _7828_/Q _4719_/A _5570_/S VGND VGND VPWR VPWR _5567_/A sky130_fd_sc_hd__mux2_2
XFILLER_105_726 VGND VGND VPWR VPWR sky130_fd_sc_hd__fill_2
XFILLER_132_501 VGND VGND VPWR VPWR sky130_fd_sc_hd__decap_3
X_8285_ _8688_/CLK _8285_/D fanout569/X VGND VGND VPWR VPWR _8285_/Q sky130_fd_sc_hd__dfrtp_2
X_7305_ _8712_/Q input4/X _7323_/S VGND VGND VPWR VPWR _7306_/A sky130_fd_sc_hd__mux2_2
X_5497_ _7796_/Q _4924_/A _5503_/S VGND VGND VPWR VPWR _5498_/A sky130_fd_sc_hd__mux2_2
X_4517_ _4515_/X _4516_/X _4534_/A VGND VGND VPWR VPWR _4517_/X sky130_fd_sc_hd__mux2_2
XFILLER_132_545 VGND VGND VPWR VPWR sky130_fd_sc_hd__decap_3
X_7236_ _7239_/A1 _4791_/X _7230_/X _7231_/X hold846/X VGND VGND VPWR VPWR _8665_/D
+ sky130_fd_sc_hd__a32o_2
X_4448_ _4450_/A _4446_/X _4447_/X VGND VGND VPWR VPWR _4448_/X sky130_fd_sc_hd__o21a_2
XFILLER_120_707 VGND VGND VPWR VPWR sky130_fd_sc_hd__decap_3
XFILLER_132_578 VGND VGND VPWR VPWR sky130_fd_sc_hd__decap_3
XFILLER_132_589 VGND VGND VPWR VPWR sky130_fd_sc_hd__decap_3
XFILLER_59_802 VGND VGND VPWR VPWR sky130_fd_sc_hd__fill_2
XTAP_TAPCELL_ROW_113_1873 VGND VPWR sky130_fd_sc_hd__tapvpwrvgnd_1
Xfanout601 fanout609/A VGND VGND VPWR VPWR fanout601/X sky130_fd_sc_hd__clkdlybuf4s25_1
XFILLER_58_312 VGND VGND VPWR VPWR sky130_fd_sc_hd__fill_1
Xfanout634 fanout653/X VGND VGND VPWR VPWR fanout634/X sky130_fd_sc_hd__clkdlybuf4s25_1
Xfanout656 fanout656/A VGND VGND VPWR VPWR wire657/A sky130_fd_sc_hd__clkdlybuf4s25_1
X_7167_ _7167_/A VGND VGND VPWR VPWR _8616_/D sky130_fd_sc_hd__buf_2
X_4379_ _8431_/Q _8512_/Q _8593_/Q _8674_/Q _4402_/S _4415_/A VGND VGND VPWR VPWR
+ _4379_/X sky130_fd_sc_hd__mux4_2
XFILLER_112_291 VGND VGND VPWR VPWR sky130_fd_sc_hd__decap_3
X_7098_ _7098_/A VGND VGND VPWR VPWR _8583_/D sky130_fd_sc_hd__buf_2
X_6118_ _6139_/S VGND VGND VPWR VPWR _6137_/S sky130_fd_sc_hd__buf_2
XFILLER_100_475 VGND VGND VPWR VPWR sky130_fd_sc_hd__fill_1
XFILLER_37_57 VGND VGND VPWR VPWR sky130_fd_sc_hd__decap_3
XFILLER_39_570 VGND VGND VPWR VPWR sky130_fd_sc_hd__decap_3
XFILLER_58_378 VGND VGND VPWR VPWR sky130_fd_sc_hd__fill_1
XFILLER_85_164 VGND VGND VPWR VPWR sky130_fd_sc_hd__decap_3
XTAP_TAPCELL_ROW_29_705 VGND VPWR sky130_fd_sc_hd__tapvpwrvgnd_1
X_6049_ _6049_/A0 _4760_/A _6053_/S VGND VGND VPWR VPWR _6050_/A sky130_fd_sc_hd__mux2_2
XFILLER_37_79 VGND VGND VPWR VPWR sky130_fd_sc_hd__decap_3
XFILLER_73_337 VGND VGND VPWR VPWR sky130_fd_sc_hd__decap_3
XFILLER_41_212 VGND VGND VPWR VPWR sky130_fd_sc_hd__decap_3
XFILLER_42_757 VGND VGND VPWR VPWR sky130_fd_sc_hd__fill_1
XFILLER_53_67 VGND VGND VPWR VPWR sky130_fd_sc_hd__decap_3
XFILLER_10_610 VGND VGND VPWR VPWR sky130_fd_sc_hd__decap_3
XFILLER_10_643 VGND VGND VPWR VPWR sky130_fd_sc_hd__fill_1
XFILLER_10_654 VGND VGND VPWR VPWR sky130_fd_sc_hd__decap_3
XFILLER_22_492 VGND VGND VPWR VPWR sky130_fd_sc_hd__fill_2
XFILLER_108_520 VGND VGND VPWR VPWR sky130_fd_sc_hd__decap_3
XFILLER_10_687 VGND VGND VPWR VPWR sky130_fd_sc_hd__decap_3
XFILLER_6_625 VGND VGND VPWR VPWR sky130_fd_sc_hd__decap_3
XFILLER_5_146 VGND VGND VPWR VPWR sky130_fd_sc_hd__decap_3
XFILLER_6_669 VGND VGND VPWR VPWR sky130_fd_sc_hd__decap_3
XFILLER_5_157 VGND VGND VPWR VPWR sky130_fd_sc_hd__fill_2
XTAP_TAPCELL_ROW_75_1345 VGND VPWR sky130_fd_sc_hd__tapvpwrvgnd_1
XFILLER_118_82 VGND VGND VPWR VPWR sky130_fd_sc_hd__fill_2
XFILLER_110_206 VGND VGND VPWR VPWR sky130_fd_sc_hd__fill_2
XFILLER_111_729 VGND VGND VPWR VPWR sky130_fd_sc_hd__fill_2
XFILLER_123_556 VGND VGND VPWR VPWR sky130_fd_sc_hd__decap_3
XFILLER_78_75 VGND VGND VPWR VPWR sky130_fd_sc_hd__fill_1
XFILLER_49_323 VGND VGND VPWR VPWR sky130_fd_sc_hd__decap_3
XFILLER_89_470 VGND VGND VPWR VPWR sky130_fd_sc_hd__decap_3
XFILLER_77_654 VGND VGND VPWR VPWR sky130_fd_sc_hd__decap_3
XFILLER_77_687 VGND VGND VPWR VPWR sky130_fd_sc_hd__decap_3
XFILLER_17_220 VGND VGND VPWR VPWR sky130_fd_sc_hd__decap_3
XFILLER_18_754 VGND VGND VPWR VPWR sky130_fd_sc_hd__fill_2
XFILLER_76_197 VGND VGND VPWR VPWR sky130_fd_sc_hd__decap_3
XFILLER_91_145 VGND VGND VPWR VPWR sky130_fd_sc_hd__decap_3
XFILLER_17_231 VGND VGND VPWR VPWR sky130_fd_sc_hd__decap_3
XFILLER_18_765 VGND VGND VPWR VPWR sky130_fd_sc_hd__fill_2
XFILLER_18_776 VGND VGND VPWR VPWR sky130_fd_sc_hd__decap_3
XFILLER_27_90 VGND VGND VPWR VPWR sky130_fd_sc_hd__decap_3
XFILLER_33_702 VGND VGND VPWR VPWR sky130_fd_sc_hd__decap_3
XFILLER_91_178 VGND VGND VPWR VPWR sky130_fd_sc_hd__decap_3
XFILLER_17_275 VGND VGND VPWR VPWR sky130_fd_sc_hd__decap_3
XFILLER_45_595 VGND VGND VPWR VPWR sky130_fd_sc_hd__decap_3
XFILLER_60_521 VGND VGND VPWR VPWR sky130_fd_sc_hd__fill_2
XFILLER_72_381 VGND VGND VPWR VPWR sky130_fd_sc_hd__fill_1
XTAP_TAPCELL_ROW_86_1496 VGND VPWR sky130_fd_sc_hd__tapvpwrvgnd_1
X_3750_ _3921_/A VGND VGND VPWR VPWR _3750_/X sky130_fd_sc_hd__clkbuf_2
XFILLER_118_306 VGND VGND VPWR VPWR sky130_fd_sc_hd__fill_2
XFILLER_9_441 VGND VGND VPWR VPWR sky130_fd_sc_hd__decap_3
XTAP_TAPCELL_ROW_15_498 VGND VPWR sky130_fd_sc_hd__tapvpwrvgnd_1
XFILLER_9_485 VGND VGND VPWR VPWR sky130_fd_sc_hd__decap_3
X_5420_ _5420_/A VGND VGND VPWR VPWR _7759_/D sky130_fd_sc_hd__buf_1
X_5351_ _5351_/A VGND VGND VPWR VPWR _7726_/D sky130_fd_sc_hd__buf_1
XFILLER_5_691 VGND VGND VPWR VPWR sky130_fd_sc_hd__decap_3
X_8070_ _8637_/CLK _8070_/D fanout595/A VGND VGND VPWR VPWR _8070_/Q sky130_fd_sc_hd__dfrtp_2
X_5282_ _5282_/A VGND VGND VPWR VPWR _7694_/D sky130_fd_sc_hd__buf_1
X_4302_ _7767_/Q _7848_/Q _4302_/S VGND VGND VPWR VPWR _4302_/X sky130_fd_sc_hd__mux2_2
XFILLER_4_50 VGND VGND VPWR VPWR sky130_fd_sc_hd__decap_3
X_7021_ _4977_/X _8547_/Q _7025_/S VGND VGND VPWR VPWR _7022_/A sky130_fd_sc_hd__mux2_2
X_4233_ _4639_/A1 _4232_/X _4545_/B1 VGND VGND VPWR VPWR _4233_/X sky130_fd_sc_hd__o21a_2
XFILLER_101_228 VGND VGND VPWR VPWR sky130_fd_sc_hd__fill_2
XFILLER_101_239 VGND VGND VPWR VPWR sky130_fd_sc_hd__decap_3
XFILLER_114_589 VGND VGND VPWR VPWR sky130_fd_sc_hd__decap_3
XFILLER_4_83 VGND VGND VPWR VPWR sky130_fd_sc_hd__fill_1
XFILLER_4_94 VGND VGND VPWR VPWR sky130_fd_sc_hd__decap_3
XFILLER_87_429 VGND VGND VPWR VPWR sky130_fd_sc_hd__decap_3
XFILLER_114_18 VGND VGND VPWR VPWR sky130_fd_sc_hd__decap_3
XFILLER_114_29 VGND VGND VPWR VPWR sky130_fd_sc_hd__fill_1
XFILLER_67_131 VGND VGND VPWR VPWR sky130_fd_sc_hd__decap_3
X_4164_ _8736_/Q _7511_/Q _7592_/Q _7673_/Q _4193_/S _4158_/A VGND VGND VPWR VPWR
+ _4165_/B sky130_fd_sc_hd__mux4_2
XFILLER_28_518 VGND VGND VPWR VPWR sky130_fd_sc_hd__fill_2
XFILLER_28_529 VGND VGND VPWR VPWR sky130_fd_sc_hd__decap_3
XFILLER_82_101 VGND VGND VPWR VPWR sky130_fd_sc_hd__decap_3
XFILLER_83_613 VGND VGND VPWR VPWR sky130_fd_sc_hd__decap_3
XFILLER_95_473 VGND VGND VPWR VPWR sky130_fd_sc_hd__decap_3
XTAP_TAPCELL_ROW_128_2080 VGND VPWR sky130_fd_sc_hd__tapvpwrvgnd_1
X_4095_ _8730_/Q _7505_/Q _4272_/S VGND VGND VPWR VPWR _4096_/B sky130_fd_sc_hd__mux2_2
XFILLER_55_337 VGND VGND VPWR VPWR sky130_fd_sc_hd__decap_3
XTAP_TAPCELL_ROW_128_2091 VGND VPWR sky130_fd_sc_hd__tapvpwrvgnd_1
X_7923_ _7923_/CLK _7923_/D fanout615/X VGND VGND VPWR VPWR _7923_/Q sky130_fd_sc_hd__dfrtp_2
XFILLER_36_551 VGND VGND VPWR VPWR sky130_fd_sc_hd__decap_3
XFILLER_70_329 VGND VGND VPWR VPWR sky130_fd_sc_hd__fill_1
XFILLER_82_189 VGND VGND VPWR VPWR sky130_fd_sc_hd__fill_1
X_7854_ _8019_/CLK _7854_/D load_slew714/X VGND VGND VPWR VPWR _7854_/Q sky130_fd_sc_hd__dfrtp_2
XFILLER_23_234 VGND VGND VPWR VPWR sky130_fd_sc_hd__decap_3
XFILLER_24_757 VGND VGND VPWR VPWR sky130_fd_sc_hd__decap_3
X_7785_ _8769_/CLK _7785_/D wire552/X VGND VGND VPWR VPWR _7785_/Q sky130_fd_sc_hd__dfrtp_2
X_6805_ _8446_/Q _4890_/A _6807_/S VGND VGND VPWR VPWR _6806_/A sky130_fd_sc_hd__mux2_2
XFILLER_23_26 VGND VGND VPWR VPWR sky130_fd_sc_hd__decap_3
XTAP_TAPCELL_ROW_34_763 VGND VPWR sky130_fd_sc_hd__tapvpwrvgnd_1
XTAP_TAPCELL_ROW_34_774 VGND VPWR sky130_fd_sc_hd__tapvpwrvgnd_1
X_6736_ _8413_/Q _4752_/A _6744_/S VGND VGND VPWR VPWR _6737_/A sky130_fd_sc_hd__mux2_2
X_4997_ _4997_/A VGND VGND VPWR VPWR _7569_/D sky130_fd_sc_hd__buf_1
XFILLER_135_9 VGND VGND VPWR VPWR sky130_fd_sc_hd__decap_3
X_3948_ _8716_/Q _8797_/Q _7572_/Q _7653_/Q _3983_/S _3984_/A VGND VGND VPWR VPWR
+ _3948_/X sky130_fd_sc_hd__mux4_2
X_3879_ _3840_/S _3873_/X _3875_/X _3878_/X VGND VGND VPWR VPWR _3879_/X sky130_fd_sc_hd__a22o_2
X_6667_ _8380_/Q _4956_/A _6681_/S VGND VGND VPWR VPWR _6668_/A sky130_fd_sc_hd__mux2_2
XTAP_TAPCELL_ROW_115_1902 VGND VPWR sky130_fd_sc_hd__tapvpwrvgnd_1
X_8406_ _8649_/CLK _8406_/D wire531/X VGND VGND VPWR VPWR _8406_/Q sky130_fd_sc_hd__dfrtp_2
X_6598_ _4824_/X _8349_/Q _6612_/S VGND VGND VPWR VPWR _6599_/A sky130_fd_sc_hd__mux2_2
X_5618_ _5618_/A VGND VGND VPWR VPWR _7852_/D sky130_fd_sc_hd__buf_1
XFILLER_105_501 VGND VGND VPWR VPWR sky130_fd_sc_hd__decap_3
XFILLER_124_309 VGND VGND VPWR VPWR sky130_fd_sc_hd__decap_3
XFILLER_3_617 VGND VGND VPWR VPWR sky130_fd_sc_hd__decap_3
X_8337_ _8734_/CLK _8337_/D fanout527/X VGND VGND VPWR VPWR _8337_/Q sky130_fd_sc_hd__dfrtp_2
X_5549_ _7820_/Q _5027_/A _5549_/S VGND VGND VPWR VPWR _5550_/A sky130_fd_sc_hd__mux2_2
XFILLER_132_331 VGND VGND VPWR VPWR sky130_fd_sc_hd__decap_3
XFILLER_2_127 VGND VGND VPWR VPWR sky130_fd_sc_hd__fill_1
XFILLER_105_556 VGND VGND VPWR VPWR sky130_fd_sc_hd__decap_3
XFILLER_105_567 VGND VGND VPWR VPWR sky130_fd_sc_hd__decap_3
XTAP_TAPCELL_ROW_57_1086 VGND VPWR sky130_fd_sc_hd__tapvpwrvgnd_1
XTAP_TAPCELL_ROW_57_1097 VGND VPWR sky130_fd_sc_hd__tapvpwrvgnd_1
X_8268_ _8754_/CLK _8268_/D wire693/X VGND VGND VPWR VPWR _8268_/Q sky130_fd_sc_hd__dfrtp_2
XFILLER_132_397 VGND VGND VPWR VPWR sky130_fd_sc_hd__decap_3
XFILLER_59_610 VGND VGND VPWR VPWR sky130_fd_sc_hd__fill_1
Xfanout420 _4524_/S0 VGND VGND VPWR VPWR _4528_/S sky130_fd_sc_hd__clkdlybuf4s25_1
Xfanout431 fanout433/X VGND VGND VPWR VPWR _3973_/S sky130_fd_sc_hd__clkdlybuf4s25_1
X_8199_ _8766_/CLK _8199_/D fanout575/X VGND VGND VPWR VPWR _8199_/Q sky130_fd_sc_hd__dfrtp_2
X_7219_ wire234/X _4731_/X wire175/X wire205/X hold788/X VGND VGND VPWR VPWR _8651_/D
+ sky130_fd_sc_hd__a32o_2
XTAP_TAPCELL_ROW_70_1275 VGND VPWR sky130_fd_sc_hd__tapvpwrvgnd_1
Xfanout453 fanout474/X VGND VGND VPWR VPWR wire454/A sky130_fd_sc_hd__clkdlybuf4s25_1
Xfanout464 _4568_/S VGND VGND VPWR VPWR _4559_/S sky130_fd_sc_hd__clkdlybuf4s25_1
Xfanout475 fanout475/A VGND VGND VPWR VPWR wire476/A sky130_fd_sc_hd__clkdlybuf4s25_1
XFILLER_46_304 VGND VGND VPWR VPWR sky130_fd_sc_hd__decap_3
XFILLER_58_153 VGND VGND VPWR VPWR sky130_fd_sc_hd__decap_3
XFILLER_59_676 VGND VGND VPWR VPWR sky130_fd_sc_hd__fill_2
Xfanout497 fanout507/X VGND VGND VPWR VPWR fanout497/X sky130_fd_sc_hd__clkdlybuf4s25_1
XFILLER_58_197 VGND VGND VPWR VPWR sky130_fd_sc_hd__decap_3
XFILLER_64_11 VGND VGND VPWR VPWR sky130_fd_sc_hd__decap_3
XFILLER_104_73 VGND VGND VPWR VPWR sky130_fd_sc_hd__fill_1
XFILLER_27_540 VGND VGND VPWR VPWR sky130_fd_sc_hd__decap_3
XFILLER_27_551 VGND VGND VPWR VPWR sky130_fd_sc_hd__decap_3
XFILLER_73_156 VGND VGND VPWR VPWR sky130_fd_sc_hd__decap_3
XFILLER_74_668 VGND VGND VPWR VPWR sky130_fd_sc_hd__fill_1
XFILLER_42_521 VGND VGND VPWR VPWR sky130_fd_sc_hd__decap_3
XFILLER_61_329 VGND VGND VPWR VPWR sky130_fd_sc_hd__decap_3
XFILLER_42_554 VGND VGND VPWR VPWR sky130_fd_sc_hd__decap_3
XFILLER_30_727 VGND VGND VPWR VPWR sky130_fd_sc_hd__fill_2
XFILLER_42_587 VGND VGND VPWR VPWR sky130_fd_sc_hd__fill_1
XFILLER_9_39 VGND VGND VPWR VPWR sky130_fd_sc_hd__decap_3
XFILLER_120_94 VGND VGND VPWR VPWR sky130_fd_sc_hd__decap_3
XFILLER_128_604 VGND VGND VPWR VPWR sky130_fd_sc_hd__decap_3
XFILLER_80_43 VGND VGND VPWR VPWR sky130_fd_sc_hd__decap_3
XFILLER_128_637 VGND VGND VPWR VPWR sky130_fd_sc_hd__decap_3
XTAP_TAPCELL_ROW_12_457 VGND VPWR sky130_fd_sc_hd__tapvpwrvgnd_1
XFILLER_127_125 VGND VGND VPWR VPWR sky130_fd_sc_hd__fill_1
XFILLER_127_147 VGND VGND VPWR VPWR sky130_fd_sc_hd__decap_3
XFILLER_128_648 VGND VGND VPWR VPWR sky130_fd_sc_hd__decap_3
XFILLER_13_81 VGND VGND VPWR VPWR sky130_fd_sc_hd__decap_3
XFILLER_115_309 VGND VGND VPWR VPWR sky130_fd_sc_hd__decap_3
XFILLER_127_169 VGND VGND VPWR VPWR sky130_fd_sc_hd__decap_3
XFILLER_129_81 VGND VGND VPWR VPWR sky130_fd_sc_hd__decap_3
XFILLER_89_52 VGND VGND VPWR VPWR sky130_fd_sc_hd__decap_3
XPHY_EDGE_ROW_23_Left_159 VGND VGND VPWR VPWR sky130_fd_sc_hd__decap_3
XFILLER_97_727 VGND VGND VPWR VPWR sky130_fd_sc_hd__fill_1
XFILLER_111_537 VGND VGND VPWR VPWR sky130_fd_sc_hd__decap_3
XFILLER_2_672 VGND VGND VPWR VPWR sky130_fd_sc_hd__decap_3
XFILLER_111_559 VGND VGND VPWR VPWR sky130_fd_sc_hd__fill_1
XFILLER_29_6 VGND VGND VPWR VPWR sky130_fd_sc_hd__decap_3
XFILLER_49_131 VGND VGND VPWR VPWR sky130_fd_sc_hd__decap_3
XFILLER_96_248 VGND VGND VPWR VPWR sky130_fd_sc_hd__decap_3
XFILLER_49_153 VGND VGND VPWR VPWR sky130_fd_sc_hd__fill_1
XTAP_TAPCELL_ROW_88_1525 VGND VPWR sky130_fd_sc_hd__tapvpwrvgnd_1
XFILLER_37_337 VGND VGND VPWR VPWR sky130_fd_sc_hd__fill_1
XFILLER_49_186 VGND VGND VPWR VPWR sky130_fd_sc_hd__decap_3
XFILLER_92_421 VGND VGND VPWR VPWR sky130_fd_sc_hd__decap_3
XFILLER_52_307 VGND VGND VPWR VPWR sky130_fd_sc_hd__fill_1
XPHY_EDGE_ROW_32_Left_168 VGND VGND VPWR VPWR sky130_fd_sc_hd__decap_3
X_4920_ _4920_/A _4936_/B VGND VGND VPWR VPWR _4921_/A sky130_fd_sc_hd__and2_2
XFILLER_21_705 VGND VGND VPWR VPWR sky130_fd_sc_hd__fill_2
X_4851_ _4851_/A VGND VGND VPWR VPWR _7535_/D sky130_fd_sc_hd__buf_1
X_3802_ _3862_/A _3798_/X _3801_/X VGND VGND VPWR VPWR _3802_/X sky130_fd_sc_hd__o21a_2
XTAP_TAPCELL_ROW_31_722 VGND VPWR sky130_fd_sc_hd__tapvpwrvgnd_1
XTAP_TAPCELL_ROW_31_733 VGND VPWR sky130_fd_sc_hd__tapvpwrvgnd_1
X_7570_ _8795_/CLK _7570_/D wire600/A VGND VGND VPWR VPWR _7570_/Q sky130_fd_sc_hd__dfrtp_2
X_4782_ _4782_/A VGND VGND VPWR VPWR _4782_/X sky130_fd_sc_hd__buf_1
XFILLER_118_103 VGND VGND VPWR VPWR sky130_fd_sc_hd__decap_3
X_3733_ _3733_/A VGND VGND VPWR VPWR _3758_/A sky130_fd_sc_hd__inv_2
X_6521_ _6521_/A VGND VGND VPWR VPWR _8312_/D sky130_fd_sc_hd__buf_2
XFILLER_9_271 VGND VGND VPWR VPWR sky130_fd_sc_hd__decap_3
XTAP_TAPCELL_ROW_99_1676 VGND VPWR sky130_fd_sc_hd__tapvpwrvgnd_1
X_6452_ _6452_/A VGND VGND VPWR VPWR _8280_/D sky130_fd_sc_hd__buf_2
XFILLER_106_309 VGND VGND VPWR VPWR sky130_fd_sc_hd__decap_3
XFILLER_118_169 VGND VGND VPWR VPWR sky130_fd_sc_hd__decap_3
XFILLER_134_607 VGND VGND VPWR VPWR sky130_fd_sc_hd__decap_3
XFILLER_134_629 VGND VGND VPWR VPWR sky130_fd_sc_hd__decap_3
XPHY_EDGE_ROW_41_Left_177 VGND VGND VPWR VPWR sky130_fd_sc_hd__decap_3
Xclkload30 _8769_/CLK VGND VGND VPWR VPWR clkload30/X sky130_fd_sc_hd__clkbuf_8
Xclkload41 _8796_/CLK VGND VGND VPWR VPWR clkload41/X sky130_fd_sc_hd__clkbuf_8
Xclkload52 _8792_/CLK VGND VGND VPWR VPWR clkload52/X sky130_fd_sc_hd__clkbuf_4
X_5403_ _7751_/Q _4734_/A _5419_/S VGND VGND VPWR VPWR _5404_/A sky130_fd_sc_hd__mux2_2
XFILLER_133_128 VGND VGND VPWR VPWR sky130_fd_sc_hd__decap_3
Xclkload63 _8754_/CLK VGND VGND VPWR VPWR clkload63/X sky130_fd_sc_hd__clkbuf_8
Xclkload74 _8699_/CLK VGND VGND VPWR VPWR clkload74/X sky130_fd_sc_hd__clkbuf_8
X_8122_ _8608_/CLK _8122_/D wire547/X VGND VGND VPWR VPWR _8122_/Q sky130_fd_sc_hd__dfrtp_2
X_6383_ _6383_/A VGND VGND VPWR VPWR _8247_/D sky130_fd_sc_hd__buf_2
XFILLER_130_802 VGND VGND VPWR VPWR sky130_fd_sc_hd__fill_2
X_5334_ _5334_/A VGND VGND VPWR VPWR _7719_/D sky130_fd_sc_hd__buf_1
XFILLER_125_39 VGND VGND VPWR VPWR sky130_fd_sc_hd__decap_3
XTAP_TAPCELL_ROW_110_1832 VGND VPWR sky130_fd_sc_hd__tapvpwrvgnd_1
X_8053_ _8560_/CLK _8053_/D _8053_/SET_B VGND VGND VPWR VPWR _8053_/Q sky130_fd_sc_hd__dfstp_2
X_5265_ _5265_/A VGND VGND VPWR VPWR _7686_/D sky130_fd_sc_hd__buf_1
XFILLER_87_237 VGND VGND VPWR VPWR sky130_fd_sc_hd__decap_3
X_7004_ _7004_/A _7004_/B _7004_/C _7004_/D VGND VGND VPWR VPWR _7005_/A sky130_fd_sc_hd__or4_4
X_5196_ _5196_/A VGND VGND VPWR VPWR _7653_/D sky130_fd_sc_hd__buf_1
X_4216_ _4227_/A _4216_/B VGND VGND VPWR VPWR _4216_/X sky130_fd_sc_hd__or2_2
XFILLER_110_570 VGND VGND VPWR VPWR sky130_fd_sc_hd__fill_1
XFILLER_18_15 VGND VGND VPWR VPWR sky130_fd_sc_hd__decap_3
XFILLER_56_602 VGND VGND VPWR VPWR sky130_fd_sc_hd__decap_3
XFILLER_96_760 VGND VGND VPWR VPWR sky130_fd_sc_hd__decap_3
X_4147_ _7996_/Q _3921_/A _3889_/A _7915_/Q _3726_/A VGND VGND VPWR VPWR _4147_/X
+ sky130_fd_sc_hd__o221a_2
XFILLER_110_592 VGND VGND VPWR VPWR sky130_fd_sc_hd__fill_1
XFILLER_18_59 VGND VGND VPWR VPWR sky130_fd_sc_hd__decap_3
XFILLER_28_326 VGND VGND VPWR VPWR sky130_fd_sc_hd__fill_2
XFILLER_55_134 VGND VGND VPWR VPWR sky130_fd_sc_hd__decap_3
XFILLER_83_432 VGND VGND VPWR VPWR sky130_fd_sc_hd__decap_3
XPHY_EDGE_ROW_50_Left_186 VGND VGND VPWR VPWR sky130_fd_sc_hd__decap_3
XTAP_TAPCELL_ROW_39_833 VGND VPWR sky130_fd_sc_hd__tapvpwrvgnd_1
XTAP_TAPCELL_ROW_39_844 VGND VPWR sky130_fd_sc_hd__tapvpwrvgnd_1
XFILLER_55_167 VGND VGND VPWR VPWR sky130_fd_sc_hd__fill_1
X_4078_ _4146_/A _4078_/B VGND VGND VPWR VPWR _4078_/X sky130_fd_sc_hd__or2_2
XFILLER_55_178 VGND VGND VPWR VPWR sky130_fd_sc_hd__fill_2
X_7906_ _8804_/CLK _7906_/D load_slew499/X VGND VGND VPWR VPWR _7906_/Q sky130_fd_sc_hd__dfrtp_2
XFILLER_51_340 VGND VGND VPWR VPWR sky130_fd_sc_hd__decap_3
XFILLER_70_137 VGND VGND VPWR VPWR sky130_fd_sc_hd__decap_3
X_7837_ _8495_/CLK _7837_/D load_slew509/X VGND VGND VPWR VPWR _7837_/Q sky130_fd_sc_hd__dfrtp_2
XFILLER_11_204 VGND VGND VPWR VPWR sky130_fd_sc_hd__decap_3
XFILLER_24_576 VGND VGND VPWR VPWR sky130_fd_sc_hd__decap_3
XFILLER_24_587 VGND VGND VPWR VPWR sky130_fd_sc_hd__fill_1
XFILLER_11_237 VGND VGND VPWR VPWR sky130_fd_sc_hd__fill_1
XFILLER_11_248 VGND VGND VPWR VPWR sky130_fd_sc_hd__decap_3
XFILLER_24_598 VGND VGND VPWR VPWR sky130_fd_sc_hd__decap_3
XTAP_TAPCELL_ROW_121_1983 VGND VPWR sky130_fd_sc_hd__tapvpwrvgnd_1
X_7768_ _8782_/CLK _7768_/D load_slew649/X VGND VGND VPWR VPWR _7768_/Q sky130_fd_sc_hd__dfrtp_2
XFILLER_133_6 VGND VGND VPWR VPWR sky130_fd_sc_hd__decap_3
XFILLER_50_13 VGND VGND VPWR VPWR sky130_fd_sc_hd__decap_3
Xclkload2 clkload2/A VGND VGND VPWR VPWR clkload2/X sky130_fd_sc_hd__clkbuf_8
X_7699_ _8799_/CLK _7699_/D fanout595/X VGND VGND VPWR VPWR _7699_/Q sky130_fd_sc_hd__dfrtp_2
X_6719_ _8405_/Q _4718_/A _6723_/S VGND VGND VPWR VPWR _6720_/A sky130_fd_sc_hd__mux2_2
XTAP_TAPCELL_ROW_59_1115 VGND VPWR sky130_fd_sc_hd__tapvpwrvgnd_1
XFILLER_109_169 VGND VGND VPWR VPWR sky130_fd_sc_hd__fill_1
XFILLER_118_670 VGND VGND VPWR VPWR sky130_fd_sc_hd__decap_3
XFILLER_133_662 VGND VGND VPWR VPWR sky130_fd_sc_hd__decap_3
XTAP_TAPCELL_ROW_72_1304 VGND VPWR sky130_fd_sc_hd__tapvpwrvgnd_1
XFILLER_120_312 VGND VGND VPWR VPWR sky130_fd_sc_hd__decap_3
XFILLER_132_150 VGND VGND VPWR VPWR sky130_fd_sc_hd__decap_3
XFILLER_133_673 VGND VGND VPWR VPWR sky130_fd_sc_hd__decap_3
XFILLER_59_66 VGND VGND VPWR VPWR sky130_fd_sc_hd__fill_1
XFILLER_120_345 VGND VGND VPWR VPWR sky130_fd_sc_hd__decap_3
XFILLER_132_183 VGND VGND VPWR VPWR sky130_fd_sc_hd__decap_3
XFILLER_115_72 VGND VGND VPWR VPWR sky130_fd_sc_hd__fill_1
Xfanout283 _8047_/Q VGND VGND VPWR VPWR _4300_/A1 sky130_fd_sc_hd__clkdlybuf4s25_1
XFILLER_101_570 VGND VGND VPWR VPWR sky130_fd_sc_hd__decap_3
XFILLER_115_94 VGND VGND VPWR VPWR sky130_fd_sc_hd__fill_1
XFILLER_19_337 VGND VGND VPWR VPWR sky130_fd_sc_hd__decap_3
XFILLER_74_421 VGND VGND VPWR VPWR sky130_fd_sc_hd__decap_3
XFILLER_74_432 VGND VGND VPWR VPWR sky130_fd_sc_hd__fill_1
XFILLER_75_54 VGND VGND VPWR VPWR sky130_fd_sc_hd__fill_2
XFILLER_86_270 VGND VGND VPWR VPWR sky130_fd_sc_hd__decap_3
XFILLER_131_60 VGND VGND VPWR VPWR sky130_fd_sc_hd__decap_3
XTAP_TAPCELL_ROW_17_527 VGND VPWR sky130_fd_sc_hd__tapvpwrvgnd_1
XFILLER_131_93 VGND VGND VPWR VPWR sky130_fd_sc_hd__decap_3
XFILLER_61_137 VGND VGND VPWR VPWR sky130_fd_sc_hd__decap_3
XFILLER_61_159 VGND VGND VPWR VPWR sky130_fd_sc_hd__decap_3
XTAP_TAPCELL_ROW_83_1455 VGND VPWR sky130_fd_sc_hd__tapvpwrvgnd_1
Xclkbuf_5_27__f_CLK clkbuf_4_13_0_CLK/X VGND VGND VPWR VPWR clkload9/A sky130_fd_sc_hd__clkbuf_16
XFILLER_15_576 VGND VGND VPWR VPWR sky130_fd_sc_hd__decap_3
XFILLER_91_97 VGND VGND VPWR VPWR sky130_fd_sc_hd__decap_3
XFILLER_24_80 VGND VGND VPWR VPWR sky130_fd_sc_hd__decap_3
XFILLER_11_771 VGND VGND VPWR VPWR sky130_fd_sc_hd__decap_3
XFILLER_128_445 VGND VGND VPWR VPWR sky130_fd_sc_hd__decap_3
XFILLER_115_106 VGND VGND VPWR VPWR sky130_fd_sc_hd__decap_3
XFILLER_128_489 VGND VGND VPWR VPWR sky130_fd_sc_hd__decap_3
XFILLER_6_230 VGND VGND VPWR VPWR sky130_fd_sc_hd__decap_3
XFILLER_7_753 VGND VGND VPWR VPWR sky130_fd_sc_hd__decap_3
XFILLER_109_670 VGND VGND VPWR VPWR sky130_fd_sc_hd__fill_2
XFILLER_6_296 VGND VGND VPWR VPWR sky130_fd_sc_hd__decap_3
XFILLER_7_797 VGND VGND VPWR VPWR sky130_fd_sc_hd__decap_3
XFILLER_108_180 VGND VGND VPWR VPWR sky130_fd_sc_hd__fill_1
XFILLER_111_301 VGND VGND VPWR VPWR sky130_fd_sc_hd__decap_3
XFILLER_123_150 VGND VGND VPWR VPWR sky130_fd_sc_hd__decap_3
XFILLER_123_172 VGND VGND VPWR VPWR sky130_fd_sc_hd__decap_3
XFILLER_130_109 VGND VGND VPWR VPWR sky130_fd_sc_hd__decap_3
Xload_slew623 fanout622/X VGND VGND VPWR VPWR load_slew623/X sky130_fd_sc_hd__buf_4
Xload_slew612 fanout611/X VGND VGND VPWR VPWR fanout609/A sky130_fd_sc_hd__clkbuf_4
XFILLER_69_237 VGND VGND VPWR VPWR sky130_fd_sc_hd__decap_3
Xload_slew645 fanout644/X VGND VGND VPWR VPWR load_slew645/X sky130_fd_sc_hd__clkbuf_4
X_5050_ _5050_/A VGND VGND VPWR VPWR _7585_/D sky130_fd_sc_hd__buf_1
XFILLER_111_378 VGND VGND VPWR VPWR sky130_fd_sc_hd__decap_3
XFILLER_27_3 VGND VGND VPWR VPWR sky130_fd_sc_hd__decap_3
XFILLER_85_719 VGND VGND VPWR VPWR sky130_fd_sc_hd__decap_3
X_4001_ _8720_/Q _8801_/Q _7576_/Q _7657_/Q _3996_/S _3993_/A VGND VGND VPWR VPWR
+ _4001_/X sky130_fd_sc_hd__mux4_2
Xload_slew689 fanout688/X VGND VGND VPWR VPWR load_slew689/X sky130_fd_sc_hd__buf_4
Xload_slew678 fanout677/X VGND VGND VPWR VPWR load_slew678/X sky130_fd_sc_hd__buf_4
Xload_slew667 fanout666/X VGND VGND VPWR VPWR load_slew667/X sky130_fd_sc_hd__clkbuf_4
XFILLER_37_123 VGND VGND VPWR VPWR sky130_fd_sc_hd__decap_3
XFILLER_78_793 VGND VGND VPWR VPWR sky130_fd_sc_hd__decap_3
XFILLER_1_51 VGND VGND VPWR VPWR sky130_fd_sc_hd__decap_3
XFILLER_38_657 VGND VGND VPWR VPWR sky130_fd_sc_hd__decap_3
XFILLER_92_240 VGND VGND VPWR VPWR sky130_fd_sc_hd__decap_3
XFILLER_93_763 VGND VGND VPWR VPWR sky130_fd_sc_hd__decap_3
XTAP_TAPCELL_ROW_36_803 VGND VPWR sky130_fd_sc_hd__tapvpwrvgnd_1
XFILLER_1_84 VGND VGND VPWR VPWR sky130_fd_sc_hd__decap_3
XFILLER_65_487 VGND VGND VPWR VPWR sky130_fd_sc_hd__decap_3
XFILLER_80_424 VGND VGND VPWR VPWR sky130_fd_sc_hd__decap_3
XFILLER_92_262 VGND VGND VPWR VPWR sky130_fd_sc_hd__decap_3
XFILLER_93_785 VGND VGND VPWR VPWR sky130_fd_sc_hd__fill_1
X_8740_ _8740_/CLK _8740_/D load_slew538/X VGND VGND VPWR VPWR _8740_/Q sky130_fd_sc_hd__dfrtp_2
X_5952_ _5958_/A1 _5947_/X _4913_/X _5948_/X hold878/X VGND VGND VPWR VPWR _8036_/D
+ sky130_fd_sc_hd__a32o_2
XFILLER_92_295 VGND VGND VPWR VPWR sky130_fd_sc_hd__decap_3
X_4903_ _4903_/A VGND VGND VPWR VPWR _4903_/X sky130_fd_sc_hd__buf_1
XFILLER_21_513 VGND VGND VPWR VPWR sky130_fd_sc_hd__decap_3
XFILLER_33_340 VGND VGND VPWR VPWR sky130_fd_sc_hd__decap_3
X_8671_ _8671_/CLK _8671_/D fanout694/X VGND VGND VPWR VPWR _8671_/Q sky130_fd_sc_hd__dfrtp_2
X_5883_ _5948_/A VGND VGND VPWR VPWR _5883_/X sky130_fd_sc_hd__clkbuf_1
XFILLER_60_192 VGND VGND VPWR VPWR sky130_fd_sc_hd__fill_1
X_7622_ _8766_/CLK _7622_/D wire574/X VGND VGND VPWR VPWR _7622_/Q sky130_fd_sc_hd__dfrtp_2
X_4834_ _4833_/X _7531_/Q _4862_/S VGND VGND VPWR VPWR _4835_/A sky130_fd_sc_hd__mux2_2
X_7553_ _8778_/CLK _7553_/D fanout730/X VGND VGND VPWR VPWR _7553_/Q sky130_fd_sc_hd__dfrtp_2
X_4765_ _4765_/A VGND VGND VPWR VPWR _4765_/X sky130_fd_sc_hd__buf_1
XFILLER_119_434 VGND VGND VPWR VPWR sky130_fd_sc_hd__decap_3
X_3716_ _3716_/A _3716_/B VGND VGND VPWR VPWR _8044_/D sky130_fd_sc_hd__xnor2_2
X_6504_ _6504_/A VGND VGND VPWR VPWR _8304_/D sky130_fd_sc_hd__buf_2
XFILLER_107_629 VGND VGND VPWR VPWR sky130_fd_sc_hd__decap_3
XFILLER_134_404 VGND VGND VPWR VPWR sky130_fd_sc_hd__decap_3
X_7484_ _7484_/A VGND VGND VPWR VPWR _8797_/D sky130_fd_sc_hd__buf_1
X_4696_ _6141_/B _6141_/C _6658_/B VGND VGND VPWR VPWR _5679_/D sky130_fd_sc_hd__o21a_2
XFILLER_106_106 VGND VGND VPWR VPWR sky130_fd_sc_hd__decap_3
XFILLER_134_448 VGND VGND VPWR VPWR sky130_fd_sc_hd__decap_3
XFILLER_20_27 VGND VGND VPWR VPWR sky130_fd_sc_hd__fill_1
XFILLER_20_38 VGND VGND VPWR VPWR sky130_fd_sc_hd__decap_3
X_6435_ _6435_/A VGND VGND VPWR VPWR _8272_/D sky130_fd_sc_hd__buf_2
X_6366_ _6366_/A VGND VGND VPWR VPWR _8239_/D sky130_fd_sc_hd__buf_2
XFILLER_0_417 VGND VGND VPWR VPWR sky130_fd_sc_hd__decap_3
XFILLER_114_172 VGND VGND VPWR VPWR sky130_fd_sc_hd__decap_3
XFILLER_130_610 VGND VGND VPWR VPWR sky130_fd_sc_hd__decap_3
XFILLER_88_524 VGND VGND VPWR VPWR sky130_fd_sc_hd__decap_3
XTAP_TAPCELL_ROW_54_1045 VGND VPWR sky130_fd_sc_hd__tapvpwrvgnd_1
X_8105_ _8274_/CLK _8105_/D fanout695/X VGND VGND VPWR VPWR _8105_/Q sky130_fd_sc_hd__dfrtp_2
X_5317_ _7711_/Q _4908_/X _5331_/S VGND VGND VPWR VPWR _5318_/A sky130_fd_sc_hd__mux2_2
XFILLER_114_194 VGND VGND VPWR VPWR sky130_fd_sc_hd__fill_2
XFILLER_130_643 VGND VGND VPWR VPWR sky130_fd_sc_hd__fill_1
XFILLER_130_654 VGND VGND VPWR VPWR sky130_fd_sc_hd__decap_3
XFILLER_88_568 VGND VGND VPWR VPWR sky130_fd_sc_hd__fill_2
X_8036_ _8778_/CLK _8036_/D load_slew729/X VGND VGND VPWR VPWR _8036_/Q sky130_fd_sc_hd__dfrtp_2
X_6297_ _6297_/A VGND VGND VPWR VPWR _8207_/D sky130_fd_sc_hd__buf_6
XFILLER_130_687 VGND VGND VPWR VPWR sky130_fd_sc_hd__decap_3
XFILLER_29_36 VGND VGND VPWR VPWR sky130_fd_sc_hd__decap_3
XFILLER_29_602 VGND VGND VPWR VPWR sky130_fd_sc_hd__decap_3
XFILLER_69_760 VGND VGND VPWR VPWR sky130_fd_sc_hd__decap_3
XFILLER_75_207 VGND VGND VPWR VPWR sky130_fd_sc_hd__decap_3
XFILLER_76_719 VGND VGND VPWR VPWR sky130_fd_sc_hd__decap_3
XFILLER_88_579 VGND VGND VPWR VPWR sky130_fd_sc_hd__decap_3
X_5248_ _5248_/A VGND VGND VPWR VPWR _7678_/D sky130_fd_sc_hd__buf_1
XFILLER_29_635 VGND VGND VPWR VPWR sky130_fd_sc_hd__decap_3
XFILLER_56_421 VGND VGND VPWR VPWR sky130_fd_sc_hd__decap_3
X_5179_ _5179_/A VGND VGND VPWR VPWR _7645_/D sky130_fd_sc_hd__buf_1
XFILLER_29_657 VGND VGND VPWR VPWR sky130_fd_sc_hd__decap_3
XFILLER_83_240 VGND VGND VPWR VPWR sky130_fd_sc_hd__fill_1
XFILLER_84_752 VGND VGND VPWR VPWR sky130_fd_sc_hd__decap_3
XFILLER_84_763 VGND VGND VPWR VPWR sky130_fd_sc_hd__fill_1
XFILLER_45_24 VGND VGND VPWR VPWR sky130_fd_sc_hd__fill_2
XFILLER_71_402 VGND VGND VPWR VPWR sky130_fd_sc_hd__decap_3
XFILLER_83_284 VGND VGND VPWR VPWR sky130_fd_sc_hd__decap_3
XFILLER_45_57 VGND VGND VPWR VPWR sky130_fd_sc_hd__fill_2
XFILLER_45_79 VGND VGND VPWR VPWR sky130_fd_sc_hd__decap_3
XFILLER_71_446 VGND VGND VPWR VPWR sky130_fd_sc_hd__fill_2
XFILLER_12_502 VGND VGND VPWR VPWR sky130_fd_sc_hd__decap_3
XFILLER_40_800 VGND VGND VPWR VPWR sky130_fd_sc_hd__decap_3
XFILLER_52_682 VGND VGND VPWR VPWR sky130_fd_sc_hd__decap_3
XFILLER_61_34 VGND VGND VPWR VPWR sky130_fd_sc_hd__decap_3
XTAP_TAPCELL_ROW_65_1196 VGND VPWR sky130_fd_sc_hd__tapvpwrvgnd_1
XFILLER_12_557 VGND VGND VPWR VPWR sky130_fd_sc_hd__decap_3
XFILLER_131_3 VGND VGND VPWR VPWR sky130_fd_sc_hd__decap_3
XFILLER_8_539 VGND VGND VPWR VPWR sky130_fd_sc_hd__decap_3
XFILLER_4_701 VGND VGND VPWR VPWR sky130_fd_sc_hd__decap_3
XFILLER_6_18 VGND VGND VPWR VPWR sky130_fd_sc_hd__decap_3
XFILLER_6_29 VGND VGND VPWR VPWR sky130_fd_sc_hd__decap_3
XTAP_TAPCELL_ROW_22_596 VGND VPWR sky130_fd_sc_hd__tapvpwrvgnd_1
XFILLER_125_426 VGND VGND VPWR VPWR sky130_fd_sc_hd__decap_3
XFILLER_4_734 VGND VGND VPWR VPWR sky130_fd_sc_hd__decap_3
XFILLER_106_651 VGND VGND VPWR VPWR sky130_fd_sc_hd__decap_3
XFILLER_10_71 VGND VGND VPWR VPWR sky130_fd_sc_hd__decap_3
XFILLER_121_610 VGND VGND VPWR VPWR sky130_fd_sc_hd__decap_3
XFILLER_133_470 VGND VGND VPWR VPWR sky130_fd_sc_hd__decap_3
XFILLER_4_778 VGND VGND VPWR VPWR sky130_fd_sc_hd__decap_3
XFILLER_79_502 VGND VGND VPWR VPWR sky130_fd_sc_hd__fill_2
XFILLER_126_71 VGND VGND VPWR VPWR sky130_fd_sc_hd__decap_3
XFILLER_79_568 VGND VGND VPWR VPWR sky130_fd_sc_hd__fill_1
XFILLER_120_153 VGND VGND VPWR VPWR sky130_fd_sc_hd__decap_3
XFILLER_13_9 VGND VGND VPWR VPWR sky130_fd_sc_hd__decap_3
XFILLER_47_410 VGND VGND VPWR VPWR sky130_fd_sc_hd__decap_3
XFILLER_59_281 VGND VGND VPWR VPWR sky130_fd_sc_hd__decap_3
XFILLER_75_741 VGND VGND VPWR VPWR sky130_fd_sc_hd__decap_3
XFILLER_94_549 VGND VGND VPWR VPWR sky130_fd_sc_hd__decap_3
XFILLER_47_487 VGND VGND VPWR VPWR sky130_fd_sc_hd__decap_3
XFILLER_74_273 VGND VGND VPWR VPWR sky130_fd_sc_hd__fill_1
XFILLER_75_785 VGND VGND VPWR VPWR sky130_fd_sc_hd__decap_3
XFILLER_34_137 VGND VGND VPWR VPWR sky130_fd_sc_hd__decap_3
XFILLER_62_457 VGND VGND VPWR VPWR sky130_fd_sc_hd__decap_3
XFILLER_74_295 VGND VGND VPWR VPWR sky130_fd_sc_hd__fill_1
XPHY_EDGE_ROW_106_Left_242 VGND VGND VPWR VPWR sky130_fd_sc_hd__decap_3
XFILLER_30_321 VGND VGND VPWR VPWR sky130_fd_sc_hd__decap_3
XFILLER_35_90 VGND VGND VPWR VPWR sky130_fd_sc_hd__decap_3
XFILLER_42_181 VGND VGND VPWR VPWR sky130_fd_sc_hd__decap_3
XFILLER_129_721 VGND VGND VPWR VPWR sky130_fd_sc_hd__decap_3
XTAP_TAPCELL_ROW_41_861 VGND VPWR sky130_fd_sc_hd__tapvpwrvgnd_1
XFILLER_129_732 VGND VGND VPWR VPWR sky130_fd_sc_hd__decap_3
XFILLER_30_365 VGND VGND VPWR VPWR sky130_fd_sc_hd__decap_3
XFILLER_30_398 VGND VGND VPWR VPWR sky130_fd_sc_hd__decap_3
XTAP_TAPCELL_ROW_41_872 VGND VPWR sky130_fd_sc_hd__tapvpwrvgnd_1
XFILLER_128_242 VGND VGND VPWR VPWR sky130_fd_sc_hd__decap_3
XFILLER_128_253 VGND VGND VPWR VPWR sky130_fd_sc_hd__decap_3
XFILLER_128_264 VGND VGND VPWR VPWR sky130_fd_sc_hd__decap_3
XFILLER_129_765 VGND VGND VPWR VPWR sky130_fd_sc_hd__decap_3
XTAP_TAPCELL_ROW_96_1635 VGND VPWR sky130_fd_sc_hd__tapvpwrvgnd_1
X_4550_ _8771_/Q _7546_/Q _4550_/S VGND VGND VPWR VPWR _4550_/X sky130_fd_sc_hd__mux2_2
XFILLER_7_561 VGND VGND VPWR VPWR sky130_fd_sc_hd__decap_3
Xmax_cap225 _3848_/X VGND VGND VPWR VPWR _4617_/A1 sky130_fd_sc_hd__buf_6
Xmax_cap214 _5894_/X VGND VGND VPWR VPWR _5906_/A1 sky130_fd_sc_hd__buf_2
Xmax_cap203 _7244_/X VGND VGND VPWR VPWR _7255_/B1 sky130_fd_sc_hd__buf_2
X_4481_ _7782_/Q _7863_/Q _7944_/Q _8025_/Q _4523_/S0 _4531_/S1 VGND VGND VPWR VPWR
+ _4481_/X sky130_fd_sc_hd__mux4_2
Xmax_cap269 _3776_/X VGND VGND VPWR VPWR _4677_/C1 sky130_fd_sc_hd__buf_6
Xmax_cap258 _4388_/B VGND VGND VPWR VPWR _4160_/B sky130_fd_sc_hd__buf_6
Xmax_cap247 _3819_/X VGND VGND VPWR VPWR _4335_/A sky130_fd_sc_hd__buf_6
Xmax_cap236 _5959_/X VGND VGND VPWR VPWR _7188_/A1 sky130_fd_sc_hd__buf_2
X_6220_ _4757_/X _8171_/Q _6226_/S VGND VGND VPWR VPWR _6221_/A sky130_fd_sc_hd__mux2_4
XPHY_EDGE_ROW_115_Left_251 VGND VGND VPWR VPWR sky130_fd_sc_hd__decap_3
X_6151_ _4961_/X _8138_/Q _6163_/S VGND VGND VPWR VPWR _6152_/A sky130_fd_sc_hd__mux2_4
XFILLER_97_343 VGND VGND VPWR VPWR sky130_fd_sc_hd__decap_3
X_5102_ _4824_/X _7610_/Q _5116_/S VGND VGND VPWR VPWR _5103_/A sky130_fd_sc_hd__mux2_2
XFILLER_111_131 VGND VGND VPWR VPWR sky130_fd_sc_hd__decap_3
Xload_slew442 _4675_/S VGND VGND VPWR VPWR _4320_/S sky130_fd_sc_hd__buf_2
X_6082_ _6082_/A VGND VGND VPWR VPWR _8106_/D sky130_fd_sc_hd__buf_1
XFILLER_111_175 VGND VGND VPWR VPWR sky130_fd_sc_hd__decap_3
XFILLER_38_421 VGND VGND VPWR VPWR sky130_fd_sc_hd__decap_3
Xload_slew486 fanout485/X VGND VGND VPWR VPWR load_slew486/X sky130_fd_sc_hd__clkbuf_2
X_5033_ _5031_/X hold985/X _5053_/S VGND VGND VPWR VPWR _5034_/A sky130_fd_sc_hd__mux2_2
XFILLER_122_29 VGND VGND VPWR VPWR sky130_fd_sc_hd__fill_2
XFILLER_66_752 VGND VGND VPWR VPWR sky130_fd_sc_hd__decap_3
XFILLER_66_763 VGND VGND VPWR VPWR sky130_fd_sc_hd__fill_1
XTAP_TAPCELL_ROW_123_2009 VGND VPWR sky130_fd_sc_hd__tapvpwrvgnd_1
XTAP_TAPCELL_ROW_49_972 VGND VPWR sky130_fd_sc_hd__tapvpwrvgnd_1
XTAP_TAPCELL_ROW_49_983 VGND VPWR sky130_fd_sc_hd__tapvpwrvgnd_1
XFILLER_53_435 VGND VGND VPWR VPWR sky130_fd_sc_hd__decap_3
XFILLER_81_755 VGND VGND VPWR VPWR sky130_fd_sc_hd__fill_1
XPHY_EDGE_ROW_124_Left_260 VGND VGND VPWR VPWR sky130_fd_sc_hd__decap_3
X_6984_ _4903_/X _8530_/Q _7000_/S VGND VGND VPWR VPWR _6985_/A sky130_fd_sc_hd__mux2_4
XFILLER_15_27 VGND VGND VPWR VPWR sky130_fd_sc_hd__decap_3
XFILLER_53_468 VGND VGND VPWR VPWR sky130_fd_sc_hd__fill_2
XFILLER_80_265 VGND VGND VPWR VPWR sky130_fd_sc_hd__fill_2
XTAP_TAPCELL_ROW_105_1764 VGND VPWR sky130_fd_sc_hd__tapvpwrvgnd_1
X_8723_ _8730_/CLK _8723_/D fanout498/X VGND VGND VPWR VPWR _8723_/Q sky130_fd_sc_hd__dfrtp_2
X_5935_ _5948_/A VGND VGND VPWR VPWR _5935_/X sky130_fd_sc_hd__clkbuf_1
XFILLER_34_682 VGND VGND VPWR VPWR sky130_fd_sc_hd__decap_3
XFILLER_40_129 VGND VGND VPWR VPWR sky130_fd_sc_hd__decap_3
XFILLER_80_287 VGND VGND VPWR VPWR sky130_fd_sc_hd__fill_2
X_8654_ _8735_/CLK _8654_/D load_slew529/X VGND VGND VPWR VPWR _8654_/Q sky130_fd_sc_hd__dfrtp_2
Xclkbuf_5_10__f_CLK clkbuf_4_5_0_CLK/X VGND VGND VPWR VPWR clkbuf_leaf_35_CLK/A sky130_fd_sc_hd__clkbuf_16
X_5866_ _5867_/A1 _5867_/A2 _4981_/X _5857_/X hold778/X VGND VGND VPWR VPWR _7971_/D
+ sky130_fd_sc_hd__a32o_2
XFILLER_21_332 VGND VGND VPWR VPWR sky130_fd_sc_hd__decap_3
XFILLER_21_343 VGND VGND VPWR VPWR sky130_fd_sc_hd__decap_3
XFILLER_33_192 VGND VGND VPWR VPWR sky130_fd_sc_hd__decap_3
X_7605_ _8669_/CLK _7605_/D fanout635/X VGND VGND VPWR VPWR _7605_/Q sky130_fd_sc_hd__dfrtp_2
X_4817_ _4817_/A VGND VGND VPWR VPWR _7527_/D sky130_fd_sc_hd__buf_1
XFILLER_21_387 VGND VGND VPWR VPWR sky130_fd_sc_hd__decap_3
XFILLER_31_15 VGND VGND VPWR VPWR sky130_fd_sc_hd__decap_3
X_8585_ _8669_/CLK _8585_/D load_slew645/X VGND VGND VPWR VPWR _8585_/Q sky130_fd_sc_hd__dfrtp_2
X_5797_ _7937_/Q _4837_/A _5805_/S VGND VGND VPWR VPWR _5798_/A sky130_fd_sc_hd__mux2_2
XFILLER_135_713 VGND VGND VPWR VPWR sky130_fd_sc_hd__decap_3
X_7536_ _8759_/CLK _7536_/D wire707/X VGND VGND VPWR VPWR _7536_/Q sky130_fd_sc_hd__dfrtp_2
X_4748_ _4748_/A _4776_/B VGND VGND VPWR VPWR _4749_/A sky130_fd_sc_hd__and2_2
XFILLER_134_212 VGND VGND VPWR VPWR sky130_fd_sc_hd__decap_3
XFILLER_135_735 VGND VGND VPWR VPWR sky130_fd_sc_hd__decap_3
X_7467_ _7467_/A VGND VGND VPWR VPWR _8789_/D sky130_fd_sc_hd__buf_1
X_4679_ _4676_/X _4677_/X _4678_/X _4684_/B2 VGND VGND VPWR VPWR _4679_/X sky130_fd_sc_hd__a22o_2
XFILLER_134_256 VGND VGND VPWR VPWR sky130_fd_sc_hd__decap_3
XFILLER_135_757 VGND VGND VPWR VPWR sky130_fd_sc_hd__decap_3
XPHY_EDGE_ROW_1_Right_1 VGND VGND VPWR VPWR sky130_fd_sc_hd__decap_3
X_6418_ _6418_/A VGND VGND VPWR VPWR _8264_/D sky130_fd_sc_hd__buf_2
XFILLER_122_418 VGND VGND VPWR VPWR sky130_fd_sc_hd__fill_2
XFILLER_122_429 VGND VGND VPWR VPWR sky130_fd_sc_hd__decap_3
XFILLER_134_289 VGND VGND VPWR VPWR sky130_fd_sc_hd__decap_3
XFILLER_1_715 VGND VGND VPWR VPWR sky130_fd_sc_hd__decap_3
X_7398_ _7398_/A VGND VGND VPWR VPWR _8756_/D sky130_fd_sc_hd__buf_1
XFILLER_0_236 VGND VGND VPWR VPWR sky130_fd_sc_hd__decap_3
XFILLER_115_481 VGND VGND VPWR VPWR sky130_fd_sc_hd__fill_2
XFILLER_1_759 VGND VGND VPWR VPWR sky130_fd_sc_hd__decap_3
X_6349_ _6349_/A VGND VGND VPWR VPWR _8231_/D sky130_fd_sc_hd__buf_2
XFILLER_130_451 VGND VGND VPWR VPWR sky130_fd_sc_hd__decap_3
XFILLER_76_516 VGND VGND VPWR VPWR sky130_fd_sc_hd__fill_1
XFILLER_102_186 VGND VGND VPWR VPWR sky130_fd_sc_hd__fill_1
XFILLER_102_197 VGND VGND VPWR VPWR sky130_fd_sc_hd__decap_3
XFILLER_130_495 VGND VGND VPWR VPWR sky130_fd_sc_hd__decap_3
XFILLER_29_421 VGND VGND VPWR VPWR sky130_fd_sc_hd__decap_3
XFILLER_88_398 VGND VGND VPWR VPWR sky130_fd_sc_hd__fill_1
X_8019_ _8019_/CLK _8019_/D load_slew714/X VGND VGND VPWR VPWR _8019_/Q sky130_fd_sc_hd__dfrtp_2
XFILLER_29_443 VGND VGND VPWR VPWR sky130_fd_sc_hd__decap_3
XFILLER_17_605 VGND VGND VPWR VPWR sky130_fd_sc_hd__fill_2
XFILLER_56_251 VGND VGND VPWR VPWR sky130_fd_sc_hd__fill_1
XFILLER_56_262 VGND VGND VPWR VPWR sky130_fd_sc_hd__decap_3
XTAP_TAPCELL_ROW_67_1225 VGND VPWR sky130_fd_sc_hd__tapvpwrvgnd_1
XFILLER_44_446 VGND VGND VPWR VPWR sky130_fd_sc_hd__decap_3
XTAP_TAPCELL_ROW_67_1236 VGND VPWR sky130_fd_sc_hd__tapvpwrvgnd_1
XFILLER_112_62 VGND VGND VPWR VPWR sky130_fd_sc_hd__fill_1
XFILLER_31_107 VGND VGND VPWR VPWR sky130_fd_sc_hd__decap_3
XFILLER_44_468 VGND VGND VPWR VPWR sky130_fd_sc_hd__decap_3
XFILLER_71_276 VGND VGND VPWR VPWR sky130_fd_sc_hd__decap_3
XFILLER_72_799 VGND VGND VPWR VPWR sky130_fd_sc_hd__decap_3
XTAP_TAPCELL_ROW_27_666 VGND VPWR sky130_fd_sc_hd__tapvpwrvgnd_1
XTAP_TAPCELL_ROW_27_677 VGND VPWR sky130_fd_sc_hd__tapvpwrvgnd_1
XFILLER_52_490 VGND VGND VPWR VPWR sky130_fd_sc_hd__decap_3
XFILLER_71_287 VGND VGND VPWR VPWR sky130_fd_sc_hd__decap_3
XTAP_TAPCELL_ROW_80_1414 VGND VPWR sky130_fd_sc_hd__tapvpwrvgnd_1
XFILLER_72_88 VGND VGND VPWR VPWR sky130_fd_sc_hd__decap_3
XFILLER_12_398 VGND VGND VPWR VPWR sky130_fd_sc_hd__decap_3
XFILLER_8_347 VGND VGND VPWR VPWR sky130_fd_sc_hd__fill_1
XFILLER_21_81 VGND VGND VPWR VPWR sky130_fd_sc_hd__decap_3
XFILLER_4_520 VGND VGND VPWR VPWR sky130_fd_sc_hd__decap_3
XFILLER_4_542 VGND VGND VPWR VPWR sky130_fd_sc_hd__decap_3
XTAP_TAPCELL_ROW_78_1387 VGND VPWR sky130_fd_sc_hd__tapvpwrvgnd_1
XFILLER_125_267 VGND VGND VPWR VPWR sky130_fd_sc_hd__decap_3
XFILLER_97_41 VGND VGND VPWR VPWR sky130_fd_sc_hd__decap_3
XFILLER_98_118 VGND VGND VPWR VPWR sky130_fd_sc_hd__decap_3
XFILLER_134_790 VGND VGND VPWR VPWR sky130_fd_sc_hd__decap_3
XTAP_TAPCELL_ROW_91_1565 VGND VPWR sky130_fd_sc_hd__tapvpwrvgnd_1
XFILLER_67_505 VGND VGND VPWR VPWR sky130_fd_sc_hd__decap_3
XFILLER_0_781 VGND VGND VPWR VPWR sky130_fd_sc_hd__decap_3
XFILLER_39_218 VGND VGND VPWR VPWR sky130_fd_sc_hd__fill_2
XFILLER_79_387 VGND VGND VPWR VPWR sky130_fd_sc_hd__decap_3
XTAP_TAPCELL_ROW_7_391 VGND VPWR sky130_fd_sc_hd__tapvpwrvgnd_1
XFILLER_11_6 VGND VGND VPWR VPWR sky130_fd_sc_hd__decap_3
XFILLER_48_763 VGND VGND VPWR VPWR sky130_fd_sc_hd__fill_2
XFILLER_94_368 VGND VGND VPWR VPWR sky130_fd_sc_hd__decap_3
XFILLER_35_402 VGND VGND VPWR VPWR sky130_fd_sc_hd__decap_3
XFILLER_63_722 VGND VGND VPWR VPWR sky130_fd_sc_hd__decap_3
XFILLER_47_284 VGND VGND VPWR VPWR sky130_fd_sc_hd__decap_3
XTAP_TAPCELL_ROW_46_931 VGND VPWR sky130_fd_sc_hd__tapvpwrvgnd_1
XTAP_TAPCELL_ROW_46_942 VGND VPWR sky130_fd_sc_hd__tapvpwrvgnd_1
XFILLER_16_660 VGND VGND VPWR VPWR sky130_fd_sc_hd__decap_3
XFILLER_62_243 VGND VGND VPWR VPWR sky130_fd_sc_hd__fill_1
X_3981_ _7737_/Q _7818_/Q _3983_/S VGND VGND VPWR VPWR _3981_/X sky130_fd_sc_hd__mux2_2
X_5720_ _5720_/A VGND VGND VPWR VPWR _7900_/D sky130_fd_sc_hd__buf_1
X_5651_ _5651_/A VGND VGND VPWR VPWR _7868_/D sky130_fd_sc_hd__buf_1
XFILLER_30_195 VGND VGND VPWR VPWR sky130_fd_sc_hd__fill_1
XTAP_TAPCELL_ROW_100_1694 VGND VPWR sky130_fd_sc_hd__tapvpwrvgnd_1
X_8370_ _8694_/CLK _8370_/D load_slew729/X VGND VGND VPWR VPWR _8370_/Q sky130_fd_sc_hd__dfrtp_2
X_5582_ _5582_/A VGND VGND VPWR VPWR _7835_/D sky130_fd_sc_hd__buf_1
X_4602_ _8127_/Q _8208_/Q _4630_/S VGND VGND VPWR VPWR _4603_/B sky130_fd_sc_hd__mux2_2
XFILLER_129_573 VGND VGND VPWR VPWR sky130_fd_sc_hd__decap_3
XFILLER_7_72 VGND VGND VPWR VPWR sky130_fd_sc_hd__decap_3
X_7321_ _8720_/Q _5022_/A _7323_/S VGND VGND VPWR VPWR _7322_/A sky130_fd_sc_hd__mux2_2
X_4533_ _8121_/Q _8202_/Q _8283_/Q _8364_/Q _4528_/S _4529_/A VGND VGND VPWR VPWR
+ _4534_/B sky130_fd_sc_hd__mux4_2
XFILLER_117_779 VGND VGND VPWR VPWR sky130_fd_sc_hd__decap_3
XTAP_TAPCELL_ROW_133_2160 VGND VPWR sky130_fd_sc_hd__tapvpwrvgnd_1
X_7252_ _7253_/A1 _4845_/X _7255_/A3 _7255_/B1 hold882/X VGND VGND VPWR VPWR _8678_/D
+ sky130_fd_sc_hd__a32o_2
XFILLER_116_267 VGND VGND VPWR VPWR sky130_fd_sc_hd__decap_3
XFILLER_132_716 VGND VGND VPWR VPWR sky130_fd_sc_hd__decap_3
X_6203_ _4723_/X _8163_/Q _6205_/S VGND VGND VPWR VPWR _6204_/A sky130_fd_sc_hd__mux2_4
X_4464_ _8762_/Q _7537_/Q _7618_/Q _7699_/Q _4550_/S _4552_/A1 VGND VGND VPWR VPWR
+ _4465_/B sky130_fd_sc_hd__mux4_2
XFILLER_131_237 VGND VGND VPWR VPWR sky130_fd_sc_hd__decap_3
XFILLER_132_749 VGND VGND VPWR VPWR sky130_fd_sc_hd__decap_3
XFILLER_98_641 VGND VGND VPWR VPWR sky130_fd_sc_hd__decap_3
X_7183_ _5959_/X _4961_/X _7187_/A3 _7187_/B1 hold836/X VGND VGND VPWR VPWR _8624_/D
+ sky130_fd_sc_hd__a32o_2
X_4395_ wire326/X _4394_/X _3877_/X VGND VGND VPWR VPWR _4395_/X sky130_fd_sc_hd__o21a_2
XFILLER_112_462 VGND VGND VPWR VPWR sky130_fd_sc_hd__decap_3
XFILLER_98_685 VGND VGND VPWR VPWR sky130_fd_sc_hd__decap_3
XTAP_TAPCELL_ROW_51_1004 VGND VPWR sky130_fd_sc_hd__tapvpwrvgnd_1
X_6134_ _6134_/A VGND VGND VPWR VPWR _8131_/D sky130_fd_sc_hd__buf_1
XFILLER_133_39 VGND VGND VPWR VPWR sky130_fd_sc_hd__decap_3
XFILLER_85_313 VGND VGND VPWR VPWR sky130_fd_sc_hd__fill_1
XFILLER_85_335 VGND VGND VPWR VPWR sky130_fd_sc_hd__fill_1
XFILLER_97_162 VGND VGND VPWR VPWR sky130_fd_sc_hd__decap_3
Xhold1003 _7499_/Q VGND VGND VPWR VPWR _4700_/A1 sky130_fd_sc_hd__dlygate4sd3_1
Xhold1014 _8215_/Q VGND VGND VPWR VPWR _6312_/A1 sky130_fd_sc_hd__dlygate4sd3_1
X_6065_ _6065_/A VGND VGND VPWR VPWR _8098_/D sky130_fd_sc_hd__buf_1
XFILLER_85_346 VGND VGND VPWR VPWR sky130_fd_sc_hd__fill_2
Xhold1025 _7916_/Q VGND VGND VPWR VPWR _5753_/A0 sky130_fd_sc_hd__dlygate4sd3_1
Xhold1036 _7848_/Q VGND VGND VPWR VPWR _5608_/A0 sky130_fd_sc_hd__dlygate4sd3_1
Xhold1047 _7827_/Q VGND VGND VPWR VPWR _5564_/A0 sky130_fd_sc_hd__dlygate4sd3_1
Xhold1058 _8749_/Q VGND VGND VPWR VPWR _7382_/A0 sky130_fd_sc_hd__dlygate4sd3_1
Xload_slew294 _4684_/C1 VGND VGND VPWR VPWR _4336_/C1 sky130_fd_sc_hd__buf_4
X_5016_ _5015_/X _7574_/Q _5028_/S VGND VGND VPWR VPWR _5017_/A sky130_fd_sc_hd__mux2_2
XFILLER_26_15 VGND VGND VPWR VPWR sky130_fd_sc_hd__decap_3
XFILLER_38_240 VGND VGND VPWR VPWR sky130_fd_sc_hd__decap_3
XFILLER_39_785 VGND VGND VPWR VPWR sky130_fd_sc_hd__decap_3
XFILLER_66_582 VGND VGND VPWR VPWR sky130_fd_sc_hd__decap_3
Xhold1069 _7544_/Q VGND VGND VPWR VPWR _4888_/A1 sky130_fd_sc_hd__dlygate4sd3_1
XFILLER_38_284 VGND VGND VPWR VPWR sky130_fd_sc_hd__decap_3
XFILLER_54_744 VGND VGND VPWR VPWR sky130_fd_sc_hd__decap_3
XFILLER_26_59 VGND VGND VPWR VPWR sky130_fd_sc_hd__decap_3
XFILLER_53_254 VGND VGND VPWR VPWR sky130_fd_sc_hd__fill_1
X_6967_ _4871_/X _8522_/Q _6979_/S VGND VGND VPWR VPWR _6968_/A sky130_fd_sc_hd__mux2_4
XFILLER_81_585 VGND VGND VPWR VPWR sky130_fd_sc_hd__decap_3
XTAP_TAPCELL_ROW_24_625 VGND VPWR sky130_fd_sc_hd__tapvpwrvgnd_1
X_8706_ _8788_/CLK _8706_/D fanout664/X VGND VGND VPWR VPWR _8706_/Q sky130_fd_sc_hd__dfrtp_2
X_5918_ _5907_/X _5908_/X _4807_/X _5909_/X hold883/X VGND VGND VPWR VPWR _8011_/D
+ sky130_fd_sc_hd__a32o_2
XTAP_TAPCELL_ROW_62_1155 VGND VPWR sky130_fd_sc_hd__tapvpwrvgnd_1
X_6898_ _4731_/X _8489_/Q _6916_/S VGND VGND VPWR VPWR _6899_/A sky130_fd_sc_hd__mux2_4
XTAP_TAPCELL_ROW_62_1166 VGND VPWR sky130_fd_sc_hd__tapvpwrvgnd_1
X_8637_ _8637_/CLK _8637_/D fanout597/X VGND VGND VPWR VPWR _8637_/Q sky130_fd_sc_hd__dfrtp_2
X_5849_ hold999/X _4941_/A _5849_/S VGND VGND VPWR VPWR _5850_/A sky130_fd_sc_hd__mux2_2
X_8568_ _8649_/CLK _8568_/D wire531/X VGND VGND VPWR VPWR _8568_/Q sky130_fd_sc_hd__dfrtp_2
XFILLER_107_201 VGND VGND VPWR VPWR sky130_fd_sc_hd__decap_3
XFILLER_5_328 VGND VGND VPWR VPWR sky130_fd_sc_hd__decap_3
XTAP_TAPCELL_ROW_118_1944 VGND VPWR sky130_fd_sc_hd__tapvpwrvgnd_1
X_7519_ _8744_/CLK _7519_/D load_slew628/X VGND VGND VPWR VPWR _7519_/Q sky130_fd_sc_hd__dfrtp_2
X_8499_ _8583_/CLK _8499_/D load_slew623/X VGND VGND VPWR VPWR _8499_/Q sky130_fd_sc_hd__dfrtp_2
XFILLER_123_738 VGND VGND VPWR VPWR sky130_fd_sc_hd__decap_3
XFILLER_116_790 VGND VGND VPWR VPWR sky130_fd_sc_hd__decap_3
Xhold870 _8037_/Q VGND VGND VPWR VPWR hold870/X sky130_fd_sc_hd__dlygate4sd3_1
Xhold881 _8015_/Q VGND VGND VPWR VPWR hold881/X sky130_fd_sc_hd__dlygate4sd3_1
XFILLER_107_51 VGND VGND VPWR VPWR sky130_fd_sc_hd__decap_3
XFILLER_107_84 VGND VGND VPWR VPWR sky130_fd_sc_hd__decap_3
Xhold892 _8029_/Q VGND VGND VPWR VPWR hold892/X sky130_fd_sc_hd__dlygate4sd3_1
XFILLER_131_771 VGND VGND VPWR VPWR sky130_fd_sc_hd__decap_3
XFILLER_67_44 VGND VGND VPWR VPWR sky130_fd_sc_hd__fill_1
XFILLER_67_66 VGND VGND VPWR VPWR sky130_fd_sc_hd__decap_3
XTAP_TAPCELL_ROW_4_350 VGND VPWR sky130_fd_sc_hd__tapvpwrvgnd_1
XFILLER_45_711 VGND VGND VPWR VPWR sky130_fd_sc_hd__decap_3
XFILLER_45_722 VGND VGND VPWR VPWR sky130_fd_sc_hd__decap_3
XFILLER_91_305 VGND VGND VPWR VPWR sky130_fd_sc_hd__decap_3
XFILLER_123_72 VGND VGND VPWR VPWR sky130_fd_sc_hd__decap_3
XFILLER_17_435 VGND VGND VPWR VPWR sky130_fd_sc_hd__fill_2
XFILLER_72_530 VGND VGND VPWR VPWR sky130_fd_sc_hd__fill_2
XFILLER_17_479 VGND VGND VPWR VPWR sky130_fd_sc_hd__decap_3
XFILLER_45_777 VGND VGND VPWR VPWR sky130_fd_sc_hd__fill_2
XFILLER_72_563 VGND VGND VPWR VPWR sky130_fd_sc_hd__fill_2
XFILLER_83_54 VGND VGND VPWR VPWR sky130_fd_sc_hd__fill_2
XTAP_TAPCELL_ROW_43_901 VGND VPWR sky130_fd_sc_hd__tapvpwrvgnd_1
XFILLER_60_725 VGND VGND VPWR VPWR sky130_fd_sc_hd__decap_3
XFILLER_13_641 VGND VGND VPWR VPWR sky130_fd_sc_hd__fill_2
XFILLER_12_162 VGND VGND VPWR VPWR sky130_fd_sc_hd__decap_3
XFILLER_13_685 VGND VGND VPWR VPWR sky130_fd_sc_hd__decap_3
XFILLER_9_612 VGND VGND VPWR VPWR sky130_fd_sc_hd__decap_3
XFILLER_9_623 VGND VGND VPWR VPWR sky130_fd_sc_hd__decap_3
XFILLER_8_144 VGND VGND VPWR VPWR sky130_fd_sc_hd__decap_3
XFILLER_9_656 VGND VGND VPWR VPWR sky130_fd_sc_hd__decap_3
XFILLER_8_166 VGND VGND VPWR VPWR sky130_fd_sc_hd__decap_3
XFILLER_126_554 VGND VGND VPWR VPWR sky130_fd_sc_hd__decap_3
XFILLER_126_598 VGND VGND VPWR VPWR sky130_fd_sc_hd__decap_3
XFILLER_99_438 VGND VGND VPWR VPWR sky130_fd_sc_hd__fill_1
XFILLER_99_449 VGND VGND VPWR VPWR sky130_fd_sc_hd__decap_3
XFILLER_122_760 VGND VGND VPWR VPWR sky130_fd_sc_hd__decap_3
XFILLER_79_151 VGND VGND VPWR VPWR sky130_fd_sc_hd__decap_3
XFILLER_95_600 VGND VGND VPWR VPWR sky130_fd_sc_hd__fill_1
X_4180_ _4177_/X _4178_/X _4179_/X _4165_/A _4231_/A VGND VGND VPWR VPWR _4180_/X
+ sky130_fd_sc_hd__a221o_2
XFILLER_122_782 VGND VGND VPWR VPWR sky130_fd_sc_hd__fill_1
XFILLER_95_611 VGND VGND VPWR VPWR sky130_fd_sc_hd__fill_2
XFILLER_95_633 VGND VGND VPWR VPWR sky130_fd_sc_hd__decap_3
XFILLER_36_733 VGND VGND VPWR VPWR sky130_fd_sc_hd__fill_2
XFILLER_48_582 VGND VGND VPWR VPWR sky130_fd_sc_hd__decap_3
X_7870_ _8771_/CLK _7870_/D load_slew570/X VGND VGND VPWR VPWR _7870_/Q sky130_fd_sc_hd__dfrtp_2
XFILLER_35_265 VGND VGND VPWR VPWR sky130_fd_sc_hd__fill_1
X_6821_ _6821_/A VGND VGND VPWR VPWR _8453_/D sky130_fd_sc_hd__buf_2
XFILLER_35_287 VGND VGND VPWR VPWR sky130_fd_sc_hd__decap_3
XFILLER_36_799 VGND VGND VPWR VPWR sky130_fd_sc_hd__decap_3
XTAP_TAPCELL_ROW_102_1723 VGND VPWR sky130_fd_sc_hd__tapvpwrvgnd_1
X_3964_ _4000_/A _3963_/X _3732_/X VGND VGND VPWR VPWR _3964_/X sky130_fd_sc_hd__o21a_2
X_6752_ _6752_/A VGND VGND VPWR VPWR _8420_/D sky130_fd_sc_hd__buf_2
X_3895_ _7730_/Q _7811_/Q _7892_/Q _7973_/Q _3906_/S _3984_/A VGND VGND VPWR VPWR
+ _3895_/X sky130_fd_sc_hd__mux4_2
X_6683_ _6830_/S VGND VGND VPWR VPWR _6702_/S sky130_fd_sc_hd__buf_2
X_5703_ _7892_/Q _4989_/A _5721_/S VGND VGND VPWR VPWR _5704_/A sky130_fd_sc_hd__mux2_2
XTAP_TAPCELL_ROW_135_2200 VGND VPWR sky130_fd_sc_hd__tapvpwrvgnd_1
X_8422_ _8668_/CLK _8422_/D wire638/X VGND VGND VPWR VPWR _8422_/Q sky130_fd_sc_hd__dfrtp_2
X_5634_ _5634_/A VGND VGND VPWR VPWR _7860_/D sky130_fd_sc_hd__buf_1
X_8353_ _8676_/CLK _8353_/D load_slew699/X VGND VGND VPWR VPWR _8353_/Q sky130_fd_sc_hd__dfrtp_2
X_7304_ _7451_/S VGND VGND VPWR VPWR _7323_/S sky130_fd_sc_hd__clkbuf_2
X_5565_ _5565_/A VGND VGND VPWR VPWR _7827_/D sky130_fd_sc_hd__buf_1
XFILLER_132_513 VGND VGND VPWR VPWR sky130_fd_sc_hd__decap_3
X_8284_ _8560_/CLK _8284_/D _8053_/SET_B VGND VGND VPWR VPWR _8284_/Q sky130_fd_sc_hd__dfrtp_2
X_5496_ _5496_/A VGND VGND VPWR VPWR _7795_/D sky130_fd_sc_hd__buf_1
X_4516_ _8443_/Q _8524_/Q _8605_/Q _8686_/Q _4544_/S0 _4498_/A VGND VGND VPWR VPWR
+ _4516_/X sky130_fd_sc_hd__mux4_2
XFILLER_104_215 VGND VGND VPWR VPWR sky130_fd_sc_hd__decap_3
XFILLER_117_598 VGND VGND VPWR VPWR sky130_fd_sc_hd__decap_3
X_7235_ _7239_/A1 _4787_/X _7242_/A3 _7242_/B1 hold845/X VGND VGND VPWR VPWR _8664_/D
+ sky130_fd_sc_hd__a32o_2
X_4447_ _8022_/Q _3816_/X _4551_/B1 _7941_/Q _4456_/C1 VGND VGND VPWR VPWR _4447_/X
+ sky130_fd_sc_hd__o221a_2
XFILLER_104_248 VGND VGND VPWR VPWR sky130_fd_sc_hd__decap_3
XFILLER_104_259 VGND VGND VPWR VPWR sky130_fd_sc_hd__decap_3
XFILLER_132_557 VGND VGND VPWR VPWR sky130_fd_sc_hd__decap_3
XTAP_TAPCELL_ROW_113_1874 VGND VPWR sky130_fd_sc_hd__tapvpwrvgnd_1
Xfanout602 fanout606/X VGND VGND VPWR VPWR wire603/A sky130_fd_sc_hd__clkdlybuf4s25_1
Xfanout613 fanout614/X VGND VGND VPWR VPWR fanout613/X sky130_fd_sc_hd__clkdlybuf4s25_1
Xfanout624 fanout653/X VGND VGND VPWR VPWR fanout624/X sky130_fd_sc_hd__clkdlybuf4s25_1
X_7166_ _4925_/X _8616_/Q _7172_/S VGND VGND VPWR VPWR _7167_/A sky130_fd_sc_hd__mux2_2
XFILLER_112_270 VGND VGND VPWR VPWR sky130_fd_sc_hd__decap_3
XFILLER_85_110 VGND VGND VPWR VPWR sky130_fd_sc_hd__fill_2
Xfanout635 wire638/A VGND VGND VPWR VPWR fanout635/X sky130_fd_sc_hd__clkdlybuf4s25_1
Xfanout646 fanout652/X VGND VGND VPWR VPWR fanout646/X sky130_fd_sc_hd__clkdlybuf4s25_1
X_6117_ _6117_/A VGND VGND VPWR VPWR _8123_/D sky130_fd_sc_hd__buf_1
X_4378_ _4415_/A _4376_/X _4377_/X VGND VGND VPWR VPWR _4378_/X sky130_fd_sc_hd__o21a_2
XFILLER_100_421 VGND VGND VPWR VPWR sky130_fd_sc_hd__decap_3
XFILLER_86_666 VGND VGND VPWR VPWR sky130_fd_sc_hd__decap_3
Xfanout668 fanout674/X VGND VGND VPWR VPWR wire669/A sky130_fd_sc_hd__clkdlybuf4s25_1
Xfanout679 fanout683/X VGND VGND VPWR VPWR wire680/A sky130_fd_sc_hd__clkdlybuf4s25_1
X_7097_ _4787_/X _7097_/A1 _7109_/S VGND VGND VPWR VPWR _7098_/A sky130_fd_sc_hd__mux2_1
XFILLER_100_454 VGND VGND VPWR VPWR sky130_fd_sc_hd__decap_3
X_6048_ _6048_/A VGND VGND VPWR VPWR _8090_/D sky130_fd_sc_hd__buf_1
XFILLER_26_221 VGND VGND VPWR VPWR sky130_fd_sc_hd__fill_1
XFILLER_73_349 VGND VGND VPWR VPWR sky130_fd_sc_hd__decap_3
Xclkbuf_5_8__f_CLK clkbuf_4_4_0_CLK/X VGND VGND VPWR VPWR clkbuf_5_8__f_CLK/X sky130_fd_sc_hd__clkbuf_16
XFILLER_26_243 VGND VGND VPWR VPWR sky130_fd_sc_hd__decap_3
XFILLER_14_416 VGND VGND VPWR VPWR sky130_fd_sc_hd__decap_3
XFILLER_26_265 VGND VGND VPWR VPWR sky130_fd_sc_hd__decap_3
XFILLER_54_585 VGND VGND VPWR VPWR sky130_fd_sc_hd__decap_3
XFILLER_81_360 VGND VGND VPWR VPWR sky130_fd_sc_hd__decap_3
X_7999_ _8657_/CLK _7999_/D fanout512/X VGND VGND VPWR VPWR _7999_/Q sky130_fd_sc_hd__dfrtp_2
XFILLER_42_769 VGND VGND VPWR VPWR sky130_fd_sc_hd__decap_3
XFILLER_53_57 VGND VGND VPWR VPWR sky130_fd_sc_hd__fill_1
XFILLER_22_460 VGND VGND VPWR VPWR sky130_fd_sc_hd__decap_3
XFILLER_41_268 VGND VGND VPWR VPWR sky130_fd_sc_hd__decap_3
XFILLER_10_622 VGND VGND VPWR VPWR sky130_fd_sc_hd__decap_3
XFILLER_10_666 VGND VGND VPWR VPWR sky130_fd_sc_hd__decap_3
XFILLER_6_604 VGND VGND VPWR VPWR sky130_fd_sc_hd__decap_3
XFILLER_108_543 VGND VGND VPWR VPWR sky130_fd_sc_hd__decap_3
XFILLER_10_699 VGND VGND VPWR VPWR sky130_fd_sc_hd__fill_1
XFILLER_5_125 VGND VGND VPWR VPWR sky130_fd_sc_hd__decap_3
XFILLER_6_637 VGND VGND VPWR VPWR sky130_fd_sc_hd__decap_3
XFILLER_6_648 VGND VGND VPWR VPWR sky130_fd_sc_hd__decap_3
XFILLER_108_576 VGND VGND VPWR VPWR sky130_fd_sc_hd__decap_3
XFILLER_135_351 VGND VGND VPWR VPWR sky130_fd_sc_hd__decap_3
XTAP_TAPCELL_ROW_75_1346 VGND VPWR sky130_fd_sc_hd__tapvpwrvgnd_1
XTAP_TAPCELL_ROW_9_420 VGND VPWR sky130_fd_sc_hd__tapvpwrvgnd_1
XFILLER_123_579 VGND VGND VPWR VPWR sky130_fd_sc_hd__decap_3
XFILLER_96_419 VGND VGND VPWR VPWR sky130_fd_sc_hd__fill_1
XFILLER_1_364 VGND VGND VPWR VPWR sky130_fd_sc_hd__decap_3
XFILLER_49_313 VGND VGND VPWR VPWR sky130_fd_sc_hd__fill_1
XFILLER_134_71 VGND VGND VPWR VPWR sky130_fd_sc_hd__decap_3
XFILLER_89_493 VGND VGND VPWR VPWR sky130_fd_sc_hd__decap_3
XFILLER_76_154 VGND VGND VPWR VPWR sky130_fd_sc_hd__decap_3
XFILLER_92_614 VGND VGND VPWR VPWR sky130_fd_sc_hd__decap_3
XFILLER_92_636 VGND VGND VPWR VPWR sky130_fd_sc_hd__fill_1
XFILLER_94_64 VGND VGND VPWR VPWR sky130_fd_sc_hd__decap_3
XFILLER_94_75 VGND VGND VPWR VPWR sky130_fd_sc_hd__decap_3
XFILLER_72_371 VGND VGND VPWR VPWR sky130_fd_sc_hd__fill_1
XTAP_TAPCELL_ROW_86_1497 VGND VPWR sky130_fd_sc_hd__tapvpwrvgnd_1
XFILLER_32_235 VGND VGND VPWR VPWR sky130_fd_sc_hd__fill_1
XFILLER_60_533 VGND VGND VPWR VPWR sky130_fd_sc_hd__decap_3
XFILLER_20_419 VGND VGND VPWR VPWR sky130_fd_sc_hd__fill_1
XFILLER_41_791 VGND VGND VPWR VPWR sky130_fd_sc_hd__decap_3
XTAP_TAPCELL_ROW_15_499 VGND VPWR sky130_fd_sc_hd__tapvpwrvgnd_1
XFILLER_9_497 VGND VGND VPWR VPWR sky130_fd_sc_hd__decap_3
X_5350_ _7726_/Q _4972_/A _5356_/S VGND VGND VPWR VPWR _5351_/A sky130_fd_sc_hd__mux2_2
XFILLER_114_546 VGND VGND VPWR VPWR sky130_fd_sc_hd__fill_2
X_5281_ _7694_/Q _4837_/X _5289_/S VGND VGND VPWR VPWR _5282_/A sky130_fd_sc_hd__mux2_2
X_4301_ _4313_/A1 _4292_/X _4295_/X _4300_/X VGND VGND VPWR VPWR _4301_/X sky130_fd_sc_hd__o31a_2
XFILLER_114_568 VGND VGND VPWR VPWR sky130_fd_sc_hd__decap_3
XFILLER_99_268 VGND VGND VPWR VPWR sky130_fd_sc_hd__decap_3
X_7020_ _7020_/A VGND VGND VPWR VPWR _8546_/D sky130_fd_sc_hd__buf_2
X_4232_ _8418_/Q _8499_/Q _8580_/Q _8661_/Q _4266_/S _4261_/A VGND VGND VPWR VPWR
+ _4232_/X sky130_fd_sc_hd__mux4_2
XFILLER_101_218 VGND VGND VPWR VPWR sky130_fd_sc_hd__decap_3
XFILLER_4_62 VGND VGND VPWR VPWR sky130_fd_sc_hd__decap_3
XFILLER_110_741 VGND VGND VPWR VPWR sky130_fd_sc_hd__decap_3
X_4163_ _4158_/X _4159_/X _4160_/X _4162_/X VGND VGND VPWR VPWR _4163_/X sky130_fd_sc_hd__a22o_2
XFILLER_68_699 VGND VGND VPWR VPWR sky130_fd_sc_hd__fill_1
XFILLER_95_452 VGND VGND VPWR VPWR sky130_fd_sc_hd__decap_3
XFILLER_95_485 VGND VGND VPWR VPWR sky130_fd_sc_hd__fill_1
X_4094_ _4094_/A VGND VGND VPWR VPWR _4094_/X sky130_fd_sc_hd__buf_1
XFILLER_55_349 VGND VGND VPWR VPWR sky130_fd_sc_hd__fill_2
XTAP_TAPCELL_ROW_128_2081 VGND VPWR sky130_fd_sc_hd__tapvpwrvgnd_1
X_7922_ _7923_/CLK _7922_/D load_slew616/X VGND VGND VPWR VPWR _7922_/Q sky130_fd_sc_hd__dfrtp_2
XFILLER_130_18 VGND VGND VPWR VPWR sky130_fd_sc_hd__decap_3
XFILLER_36_563 VGND VGND VPWR VPWR sky130_fd_sc_hd__decap_3
XFILLER_83_669 VGND VGND VPWR VPWR sky130_fd_sc_hd__decap_3
XFILLER_130_29 VGND VGND VPWR VPWR sky130_fd_sc_hd__decap_3
XFILLER_91_691 VGND VGND VPWR VPWR sky130_fd_sc_hd__decap_3
X_7853_ _8754_/CLK _7853_/D load_slew691/X VGND VGND VPWR VPWR _7853_/Q sky130_fd_sc_hd__dfrtp_2
XFILLER_23_246 VGND VGND VPWR VPWR sky130_fd_sc_hd__fill_1
XFILLER_63_393 VGND VGND VPWR VPWR sky130_fd_sc_hd__fill_2
X_7784_ _8029_/CLK _7784_/D wire574/X VGND VGND VPWR VPWR _7784_/Q sky130_fd_sc_hd__dfrtp_2
X_6804_ _6804_/A VGND VGND VPWR VPWR _8445_/D sky130_fd_sc_hd__buf_2
X_4996_ _4995_/X _7569_/Q _5028_/S VGND VGND VPWR VPWR _4997_/A sky130_fd_sc_hd__mux2_2
XTAP_TAPCELL_ROW_34_764 VGND VPWR sky130_fd_sc_hd__tapvpwrvgnd_1
XTAP_TAPCELL_ROW_34_775 VGND VPWR sky130_fd_sc_hd__tapvpwrvgnd_1
X_3947_ _3955_/A _3943_/X _3945_/X _3946_/X VGND VGND VPWR VPWR _3947_/X sky130_fd_sc_hd__a22o_2
X_6735_ _6735_/A VGND VGND VPWR VPWR _8412_/D sky130_fd_sc_hd__buf_2
XFILLER_23_38 VGND VGND VPWR VPWR sky130_fd_sc_hd__decap_3
XFILLER_128_9 VGND VGND VPWR VPWR sky130_fd_sc_hd__decap_3
XFILLER_31_290 VGND VGND VPWR VPWR sky130_fd_sc_hd__fill_1
X_3878_ _4639_/A1 _3876_/X _3877_/X VGND VGND VPWR VPWR _3878_/X sky130_fd_sc_hd__o21a_2
X_6666_ _6666_/A VGND VGND VPWR VPWR _8379_/D sky130_fd_sc_hd__buf_2
XTAP_TAPCELL_ROW_115_1903 VGND VPWR sky130_fd_sc_hd__tapvpwrvgnd_1
X_8405_ _8648_/CLK _8405_/D load_slew489/X VGND VGND VPWR VPWR _8405_/Q sky130_fd_sc_hd__dfrtp_2
X_6597_ _6597_/A VGND VGND VPWR VPWR _8348_/D sky130_fd_sc_hd__buf_2
X_5617_ _7852_/Q _4819_/A _5633_/S VGND VGND VPWR VPWR _5618_/A sky130_fd_sc_hd__mux2_2
XFILLER_117_351 VGND VGND VPWR VPWR sky130_fd_sc_hd__fill_1
XFILLER_133_800 VGND VGND VPWR VPWR sky130_fd_sc_hd__decap_3
XFILLER_3_607 VGND VGND VPWR VPWR sky130_fd_sc_hd__decap_3
Xclkbuf_leaf_145_CLK clkbuf_leaf_3_CLK/A VGND VGND VPWR VPWR _8493_/CLK sky130_fd_sc_hd__clkbuf_8
X_8336_ _8737_/CLK _8336_/D wire519/X VGND VGND VPWR VPWR _8336_/Q sky130_fd_sc_hd__dfrtp_2
X_5548_ _5548_/A VGND VGND VPWR VPWR _7819_/D sky130_fd_sc_hd__buf_1
XFILLER_117_373 VGND VGND VPWR VPWR sky130_fd_sc_hd__decap_3
XFILLER_132_321 VGND VGND VPWR VPWR sky130_fd_sc_hd__fill_1
XFILLER_2_106 VGND VGND VPWR VPWR sky130_fd_sc_hd__decap_3
XFILLER_3_629 VGND VGND VPWR VPWR sky130_fd_sc_hd__decap_3
X_8267_ _8753_/CLK _8267_/D fanout686/X VGND VGND VPWR VPWR _8267_/Q sky130_fd_sc_hd__dfrtp_2
XFILLER_132_343 VGND VGND VPWR VPWR sky130_fd_sc_hd__decap_3
XTAP_TAPCELL_ROW_57_1087 VGND VPWR sky130_fd_sc_hd__tapvpwrvgnd_1
X_7218_ _7270_/A VGND VGND VPWR VPWR _7218_/X sky130_fd_sc_hd__clkbuf_1
X_5479_ _5479_/A VGND VGND VPWR VPWR _7787_/D sky130_fd_sc_hd__buf_1
XFILLER_132_365 VGND VGND VPWR VPWR sky130_fd_sc_hd__decap_3
XFILLER_48_24 VGND VGND VPWR VPWR sky130_fd_sc_hd__decap_3
Xfanout410 fanout414/X VGND VGND VPWR VPWR _4077_/S sky130_fd_sc_hd__clkdlybuf4s25_1
X_8198_ _8684_/CLK _8198_/D load_slew560/X VGND VGND VPWR VPWR _8198_/Q sky130_fd_sc_hd__dfrtp_2
XFILLER_48_35 VGND VGND VPWR VPWR sky130_fd_sc_hd__fill_1
XFILLER_48_57 VGND VGND VPWR VPWR sky130_fd_sc_hd__decap_3
XFILLER_58_121 VGND VGND VPWR VPWR sky130_fd_sc_hd__decap_3
Xfanout443 fanout474/X VGND VGND VPWR VPWR fanout443/X sky130_fd_sc_hd__clkdlybuf4s25_1
X_7149_ _4891_/X _8608_/Q _7151_/S VGND VGND VPWR VPWR _7150_/A sky130_fd_sc_hd__mux2_2
XFILLER_101_785 VGND VGND VPWR VPWR sky130_fd_sc_hd__fill_2
XFILLER_19_508 VGND VGND VPWR VPWR sky130_fd_sc_hd__fill_2
XFILLER_58_165 VGND VGND VPWR VPWR sky130_fd_sc_hd__decap_3
XPHY_EDGE_ROW_122_Right_122 VGND VGND VPWR VPWR sky130_fd_sc_hd__decap_3
XTAP_TAPCELL_ROW_70_1276 VGND VPWR sky130_fd_sc_hd__tapvpwrvgnd_1
Xclkbuf_4_0_0_CLK clkbuf_0_CLK/X VGND VGND VPWR VPWR clkbuf_4_0_0_CLK/X sky130_fd_sc_hd__clkbuf_8
Xfanout487 fanout507/X VGND VGND VPWR VPWR fanout487/X sky130_fd_sc_hd__clkdlybuf4s25_1
Xfanout498 fanout500/X VGND VGND VPWR VPWR fanout498/X sky130_fd_sc_hd__clkdlybuf4s25_1
XFILLER_100_284 VGND VGND VPWR VPWR sky130_fd_sc_hd__decap_3
XFILLER_73_113 VGND VGND VPWR VPWR sky130_fd_sc_hd__decap_3
XFILLER_27_574 VGND VGND VPWR VPWR sky130_fd_sc_hd__decap_3
XFILLER_9_18 VGND VGND VPWR VPWR sky130_fd_sc_hd__decap_3
XFILLER_14_268 VGND VGND VPWR VPWR sky130_fd_sc_hd__decap_3
XFILLER_42_566 VGND VGND VPWR VPWR sky130_fd_sc_hd__decap_3
XFILLER_80_11 VGND VGND VPWR VPWR sky130_fd_sc_hd__fill_2
XFILLER_80_22 VGND VGND VPWR VPWR sky130_fd_sc_hd__decap_3
XFILLER_23_791 VGND VGND VPWR VPWR sky130_fd_sc_hd__decap_3
XFILLER_128_616 VGND VGND VPWR VPWR sky130_fd_sc_hd__decap_3
XFILLER_13_60 VGND VGND VPWR VPWR sky130_fd_sc_hd__decap_3
XTAP_TAPCELL_ROW_12_458 VGND VPWR sky130_fd_sc_hd__tapvpwrvgnd_1
XFILLER_129_60 VGND VGND VPWR VPWR sky130_fd_sc_hd__decap_3
XFILLER_13_93 VGND VGND VPWR VPWR sky130_fd_sc_hd__fill_2
XFILLER_124_800 VGND VGND VPWR VPWR sky130_fd_sc_hd__decap_3
XFILLER_127_159 VGND VGND VPWR VPWR sky130_fd_sc_hd__decap_3
XFILLER_129_93 VGND VGND VPWR VPWR sky130_fd_sc_hd__decap_3
XFILLER_6_467 VGND VGND VPWR VPWR sky130_fd_sc_hd__decap_3
Xclkbuf_leaf_136_CLK clkload1/A VGND VGND VPWR VPWR _8742_/CLK sky130_fd_sc_hd__clkbuf_8
XFILLER_135_181 VGND VGND VPWR VPWR sky130_fd_sc_hd__decap_3
XFILLER_2_640 VGND VGND VPWR VPWR sky130_fd_sc_hd__decap_3
XFILLER_2_651 VGND VGND VPWR VPWR sky130_fd_sc_hd__decap_3
XFILLER_111_505 VGND VGND VPWR VPWR sky130_fd_sc_hd__decap_3
XFILLER_2_684 VGND VGND VPWR VPWR sky130_fd_sc_hd__decap_3
XFILLER_69_419 VGND VGND VPWR VPWR sky130_fd_sc_hd__decap_3
XFILLER_49_110 VGND VGND VPWR VPWR sky130_fd_sc_hd__fill_2
XFILLER_77_430 VGND VGND VPWR VPWR sky130_fd_sc_hd__decap_3
XFILLER_89_290 VGND VGND VPWR VPWR sky130_fd_sc_hd__decap_3
XFILLER_49_143 VGND VGND VPWR VPWR sky130_fd_sc_hd__fill_1
XFILLER_49_165 VGND VGND VPWR VPWR sky130_fd_sc_hd__decap_3
XFILLER_65_603 VGND VGND VPWR VPWR sky130_fd_sc_hd__decap_3
XFILLER_65_658 VGND VGND VPWR VPWR sky130_fd_sc_hd__decap_3
XTAP_TAPCELL_ROW_88_1526 VGND VPWR sky130_fd_sc_hd__tapvpwrvgnd_1
XFILLER_80_617 VGND VGND VPWR VPWR sky130_fd_sc_hd__decap_3
XFILLER_92_477 VGND VGND VPWR VPWR sky130_fd_sc_hd__decap_3
XFILLER_33_533 VGND VGND VPWR VPWR sky130_fd_sc_hd__decap_3
XFILLER_45_393 VGND VGND VPWR VPWR sky130_fd_sc_hd__decap_3
X_4850_ _4849_/X _4850_/A1 _4862_/S VGND VGND VPWR VPWR _4851_/A sky130_fd_sc_hd__mux2_2
X_3801_ _8300_/Q _3799_/X _4424_/A2 _8219_/Q _4315_/C1 VGND VGND VPWR VPWR _3801_/X
+ sky130_fd_sc_hd__o221a_2
XTAP_TAPCELL_ROW_31_723 VGND VPWR sky130_fd_sc_hd__tapvpwrvgnd_1
X_6520_ _5011_/X _8312_/Q _6528_/S VGND VGND VPWR VPWR _6521_/A sky130_fd_sc_hd__mux2_2
X_4781_ _4781_/A _4810_/B VGND VGND VPWR VPWR _4782_/A sky130_fd_sc_hd__and2_2
X_3732_ _3732_/A VGND VGND VPWR VPWR _3732_/X sky130_fd_sc_hd__clkbuf_2
XFILLER_9_294 VGND VGND VPWR VPWR sky130_fd_sc_hd__decap_3
XTAP_TAPCELL_ROW_99_1677 VGND VPWR sky130_fd_sc_hd__tapvpwrvgnd_1
Xclkload20 _8727_/CLK VGND VGND VPWR VPWR clkload20/Y sky130_fd_sc_hd__clkinv_2
X_6451_ _4875_/X _8280_/Q _6461_/S VGND VGND VPWR VPWR _6452_/A sky130_fd_sc_hd__mux2_2
Xclkbuf_leaf_127_CLK clkload2/A VGND VGND VPWR VPWR _8748_/CLK sky130_fd_sc_hd__clkbuf_8
Xclkload31 _8683_/CLK VGND VGND VPWR VPWR clkload31/X sky130_fd_sc_hd__clkbuf_8
Xclkload42 _7923_/CLK VGND VGND VPWR VPWR clkload42/Y sky130_fd_sc_hd__bufinv_16
Xclkload53 _8382_/CLK VGND VGND VPWR VPWR clkload53/Y sky130_fd_sc_hd__bufinv_16
X_6382_ _4735_/X hold930/X _6398_/S VGND VGND VPWR VPWR _6383_/A sky130_fd_sc_hd__mux2_1
X_5402_ _5402_/A VGND VGND VPWR VPWR _7750_/D sky130_fd_sc_hd__buf_1
XFILLER_127_671 VGND VGND VPWR VPWR sky130_fd_sc_hd__fill_1
XFILLER_127_682 VGND VGND VPWR VPWR sky130_fd_sc_hd__decap_3
Xclkload64 _8671_/CLK VGND VGND VPWR VPWR clkload64/X sky130_fd_sc_hd__clkbuf_8
Xclkload75 _8772_/CLK VGND VGND VPWR VPWR clkload75/X sky130_fd_sc_hd__clkbuf_8
X_8121_ _8764_/CLK _8121_/D load_slew563/X VGND VGND VPWR VPWR _8121_/Q sky130_fd_sc_hd__dfrtp_2
X_5333_ _7719_/Q _4941_/X _5333_/S VGND VGND VPWR VPWR _5334_/A sky130_fd_sc_hd__mux2_2
XFILLER_102_505 VGND VGND VPWR VPWR sky130_fd_sc_hd__decap_3
XFILLER_102_516 VGND VGND VPWR VPWR sky130_fd_sc_hd__decap_3
XFILLER_114_365 VGND VGND VPWR VPWR sky130_fd_sc_hd__decap_3
XFILLER_114_387 VGND VGND VPWR VPWR sky130_fd_sc_hd__decap_3
XFILLER_125_18 VGND VGND VPWR VPWR sky130_fd_sc_hd__decap_3
XFILLER_88_728 VGND VGND VPWR VPWR sky130_fd_sc_hd__decap_3
XFILLER_88_739 VGND VGND VPWR VPWR sky130_fd_sc_hd__decap_3
XTAP_TAPCELL_ROW_110_1833 VGND VPWR sky130_fd_sc_hd__tapvpwrvgnd_1
X_8052_ _8608_/CLK _8052_/D wire547/X VGND VGND VPWR VPWR _8052_/Q sky130_fd_sc_hd__dfrtp_2
X_5264_ _7686_/Q _4803_/X _5268_/S VGND VGND VPWR VPWR _5265_/A sky130_fd_sc_hd__mux2_2
XFILLER_87_249 VGND VGND VPWR VPWR sky130_fd_sc_hd__decap_3
X_7003_ _7003_/A VGND VGND VPWR VPWR _8539_/D sky130_fd_sc_hd__buf_1
X_5195_ _7653_/Q _5007_/X _5205_/S VGND VGND VPWR VPWR _5196_/A sky130_fd_sc_hd__mux2_2
X_4215_ _7759_/Q _7840_/Q _4226_/S VGND VGND VPWR VPWR _4216_/B sky130_fd_sc_hd__mux2_2
XFILLER_28_305 VGND VGND VPWR VPWR sky130_fd_sc_hd__decap_3
X_4146_ _4146_/A _4146_/B VGND VGND VPWR VPWR _4146_/X sky130_fd_sc_hd__or2_2
XFILLER_18_27 VGND VGND VPWR VPWR sky130_fd_sc_hd__fill_1
XFILLER_18_38 VGND VGND VPWR VPWR sky130_fd_sc_hd__decap_3
XFILLER_95_293 VGND VGND VPWR VPWR sky130_fd_sc_hd__decap_3
XTAP_TAPCELL_ROW_39_834 VGND VPWR sky130_fd_sc_hd__tapvpwrvgnd_1
XTAP_TAPCELL_ROW_39_845 VGND VPWR sky130_fd_sc_hd__tapvpwrvgnd_1
XFILLER_71_617 VGND VGND VPWR VPWR sky130_fd_sc_hd__fill_2
XFILLER_83_444 VGND VGND VPWR VPWR sky130_fd_sc_hd__decap_3
X_4077_ _8404_/Q _8485_/Q _4077_/S VGND VGND VPWR VPWR _4078_/B sky130_fd_sc_hd__mux2_2
XFILLER_36_371 VGND VGND VPWR VPWR sky130_fd_sc_hd__decap_3
XFILLER_83_499 VGND VGND VPWR VPWR sky130_fd_sc_hd__fill_1
X_7905_ _8725_/CLK _7905_/D load_slew491/X VGND VGND VPWR VPWR _7905_/Q sky130_fd_sc_hd__dfrtp_2
XFILLER_36_382 VGND VGND VPWR VPWR sky130_fd_sc_hd__fill_2
X_7836_ _8495_/CLK _7836_/D load_slew511/X VGND VGND VPWR VPWR _7836_/Q sky130_fd_sc_hd__dfrtp_2
XFILLER_24_566 VGND VGND VPWR VPWR sky130_fd_sc_hd__decap_3
XFILLER_51_352 VGND VGND VPWR VPWR sky130_fd_sc_hd__decap_3
XFILLER_51_396 VGND VGND VPWR VPWR sky130_fd_sc_hd__fill_2
XTAP_TAPCELL_ROW_121_1984 VGND VPWR sky130_fd_sc_hd__tapvpwrvgnd_1
X_7767_ _8749_/CLK _7767_/D load_slew623/X VGND VGND VPWR VPWR _7767_/Q sky130_fd_sc_hd__dfrtp_2
X_4979_ _4979_/A VGND VGND VPWR VPWR _7565_/D sky130_fd_sc_hd__buf_1
Xclkload3 clkload3/A VGND VGND VPWR VPWR clkload3/X sky130_fd_sc_hd__clkbuf_8
X_7698_ _8518_/CLK _7698_/D fanout703/X VGND VGND VPWR VPWR _7698_/Q sky130_fd_sc_hd__dfrtp_2
X_6718_ _6718_/A VGND VGND VPWR VPWR _8404_/D sky130_fd_sc_hd__buf_2
XFILLER_126_6 VGND VGND VPWR VPWR sky130_fd_sc_hd__decap_3
X_6649_ _6649_/A VGND VGND VPWR VPWR _8373_/D sky130_fd_sc_hd__buf_2
XFILLER_106_800 VGND VGND VPWR VPWR sky130_fd_sc_hd__decap_3
XTAP_TAPCELL_ROW_59_1116 VGND VPWR sky130_fd_sc_hd__tapvpwrvgnd_1
Xclkbuf_leaf_118_CLK clkbuf_5_16__f_CLK/X VGND VGND VPWR VPWR _8583_/CLK sky130_fd_sc_hd__clkbuf_8
XFILLER_118_682 VGND VGND VPWR VPWR sky130_fd_sc_hd__decap_3
XFILLER_121_803 VGND VGND VPWR VPWR sky130_fd_sc_hd__fill_1
XFILLER_133_641 VGND VGND VPWR VPWR sky130_fd_sc_hd__decap_3
XTAP_TAPCELL_ROW_72_1305 VGND VPWR sky130_fd_sc_hd__tapvpwrvgnd_1
X_8319_ _8400_/CLK _8319_/D wire555/X VGND VGND VPWR VPWR _8319_/Q sky130_fd_sc_hd__dfrtp_2
XFILLER_132_162 VGND VGND VPWR VPWR sky130_fd_sc_hd__decap_3
XFILLER_133_685 VGND VGND VPWR VPWR sky130_fd_sc_hd__decap_3
XFILLER_78_205 VGND VGND VPWR VPWR sky130_fd_sc_hd__decap_3
XFILLER_120_324 VGND VGND VPWR VPWR sky130_fd_sc_hd__decap_3
XFILLER_132_195 VGND VGND VPWR VPWR sky130_fd_sc_hd__fill_1
XFILLER_47_614 VGND VGND VPWR VPWR sky130_fd_sc_hd__fill_2
XFILLER_59_441 VGND VGND VPWR VPWR sky130_fd_sc_hd__decap_3
XFILLER_87_783 VGND VGND VPWR VPWR sky130_fd_sc_hd__fill_1
XFILLER_101_582 VGND VGND VPWR VPWR sky130_fd_sc_hd__decap_3
XFILLER_47_636 VGND VGND VPWR VPWR sky130_fd_sc_hd__decap_3
XFILLER_75_33 VGND VGND VPWR VPWR sky130_fd_sc_hd__decap_3
Xfanout284 _4526_/S VGND VGND VPWR VPWR _3707_/B sky130_fd_sc_hd__clkdlybuf4s25_1
Xfanout295 _3853_/C1 VGND VGND VPWR VPWR _4364_/C1 sky130_fd_sc_hd__clkdlybuf4s25_1
XFILLER_46_135 VGND VGND VPWR VPWR sky130_fd_sc_hd__decap_3
XFILLER_74_466 VGND VGND VPWR VPWR sky130_fd_sc_hd__fill_1
XFILLER_15_511 VGND VGND VPWR VPWR sky130_fd_sc_hd__decap_3
XFILLER_27_371 VGND VGND VPWR VPWR sky130_fd_sc_hd__fill_1
XFILLER_62_639 VGND VGND VPWR VPWR sky130_fd_sc_hd__decap_3
XTAP_TAPCELL_ROW_17_528 VGND VPWR sky130_fd_sc_hd__tapvpwrvgnd_1
XFILLER_131_72 VGND VGND VPWR VPWR sky130_fd_sc_hd__decap_3
XFILLER_15_588 VGND VGND VPWR VPWR sky130_fd_sc_hd__decap_3
XTAP_TAPCELL_ROW_83_1456 VGND VPWR sky130_fd_sc_hd__tapvpwrvgnd_1
XFILLER_30_525 VGND VGND VPWR VPWR sky130_fd_sc_hd__decap_3
XFILLER_11_750 VGND VGND VPWR VPWR sky130_fd_sc_hd__decap_3
XFILLER_11_783 VGND VGND VPWR VPWR sky130_fd_sc_hd__fill_1
XFILLER_11_794 VGND VGND VPWR VPWR sky130_fd_sc_hd__decap_3
XFILLER_128_424 VGND VGND VPWR VPWR sky130_fd_sc_hd__decap_3
XFILLER_7_721 VGND VGND VPWR VPWR sky130_fd_sc_hd__decap_3
XFILLER_7_732 VGND VGND VPWR VPWR sky130_fd_sc_hd__decap_3
XFILLER_128_457 VGND VGND VPWR VPWR sky130_fd_sc_hd__decap_3
XFILLER_6_253 VGND VGND VPWR VPWR sky130_fd_sc_hd__decap_3
XFILLER_7_765 VGND VGND VPWR VPWR sky130_fd_sc_hd__decap_3
Xclkbuf_leaf_109_CLK clkload7/A VGND VGND VPWR VPWR _8710_/CLK sky130_fd_sc_hd__clkbuf_8
XFILLER_109_682 VGND VGND VPWR VPWR sky130_fd_sc_hd__decap_3
XFILLER_40_80 VGND VGND VPWR VPWR sky130_fd_sc_hd__decap_3
XFILLER_111_346 VGND VGND VPWR VPWR sky130_fd_sc_hd__decap_3
XFILLER_97_558 VGND VGND VPWR VPWR sky130_fd_sc_hd__fill_2
X_4000_ _4000_/A _4000_/B VGND VGND VPWR VPWR _4000_/X sky130_fd_sc_hd__or2_2
XFILLER_1_30 VGND VGND VPWR VPWR sky130_fd_sc_hd__decap_3
XFILLER_1_63 VGND VGND VPWR VPWR sky130_fd_sc_hd__decap_3
XFILLER_37_146 VGND VGND VPWR VPWR sky130_fd_sc_hd__decap_3
XTAP_TAPCELL_ROW_125_2040 VGND VPWR sky130_fd_sc_hd__tapvpwrvgnd_1
XFILLER_1_96 VGND VGND VPWR VPWR sky130_fd_sc_hd__decap_3
XFILLER_53_617 VGND VGND VPWR VPWR sky130_fd_sc_hd__fill_2
XFILLER_92_274 VGND VGND VPWR VPWR sky130_fd_sc_hd__decap_3
X_5951_ _5946_/X _5958_/A2 _4908_/X _5958_/B1 hold842/X VGND VGND VPWR VPWR _8035_/D
+ sky130_fd_sc_hd__a32o_2
XFILLER_45_190 VGND VGND VPWR VPWR sky130_fd_sc_hd__decap_3
X_8670_ _8670_/CLK _8670_/D load_slew633/X VGND VGND VPWR VPWR _8670_/Q sky130_fd_sc_hd__dfrtp_2
X_4902_ _4902_/A _4902_/B VGND VGND VPWR VPWR _4903_/A sky130_fd_sc_hd__and2_2
XFILLER_21_503 VGND VGND VPWR VPWR sky130_fd_sc_hd__fill_1
XFILLER_33_363 VGND VGND VPWR VPWR sky130_fd_sc_hd__decap_3
X_5882_ _5947_/A VGND VGND VPWR VPWR _5882_/X sky130_fd_sc_hd__clkbuf_1
XFILLER_21_547 VGND VGND VPWR VPWR sky130_fd_sc_hd__decap_3
X_7621_ _8638_/CLK _7621_/D load_slew582/X VGND VGND VPWR VPWR _7621_/Q sky130_fd_sc_hd__dfrtp_2
X_4833_ _4833_/A VGND VGND VPWR VPWR _4833_/X sky130_fd_sc_hd__buf_1
X_7552_ _8777_/CLK _7552_/D load_slew750/X VGND VGND VPWR VPWR _7552_/Q sky130_fd_sc_hd__dfrtp_2
X_4764_ _4764_/A _4764_/B VGND VGND VPWR VPWR _4765_/A sky130_fd_sc_hd__and2_2
X_3715_ _8053_/Q input2/X VGND VGND VPWR VPWR _3716_/B sky130_fd_sc_hd__or2b_2
X_7483_ _5007_/X hold957/X _7495_/S VGND VGND VPWR VPWR _7484_/A sky130_fd_sc_hd__mux2_2
X_6503_ _4977_/X _8304_/Q _6507_/S VGND VGND VPWR VPWR _6504_/A sky130_fd_sc_hd__mux2_2
X_6434_ _4841_/X _8272_/Q _6440_/S VGND VGND VPWR VPWR _6435_/A sky130_fd_sc_hd__mux2_2
X_4695_ _8051_/Q _7282_/B VGND VGND VPWR VPWR _6141_/C sky130_fd_sc_hd__and2_4
XFILLER_106_129 VGND VGND VPWR VPWR sky130_fd_sc_hd__decap_3
XFILLER_134_427 VGND VGND VPWR VPWR sky130_fd_sc_hd__decap_3
X_6365_ _4703_/X _8239_/Q _6377_/S VGND VGND VPWR VPWR _6366_/A sky130_fd_sc_hd__mux2_2
XFILLER_103_803 VGND VGND VPWR VPWR sky130_fd_sc_hd__fill_1
X_8104_ _8753_/CLK _8104_/D load_slew640/X VGND VGND VPWR VPWR _8104_/Q sky130_fd_sc_hd__dfrtp_2
X_6296_ _4908_/X _8207_/Q _6310_/S VGND VGND VPWR VPWR _6297_/A sky130_fd_sc_hd__mux2_4
X_5316_ _5316_/A VGND VGND VPWR VPWR _7710_/D sky130_fd_sc_hd__buf_1
XFILLER_102_324 VGND VGND VPWR VPWR sky130_fd_sc_hd__decap_3
XFILLER_130_622 VGND VGND VPWR VPWR sky130_fd_sc_hd__decap_3
XTAP_TAPCELL_ROW_54_1046 VGND VPWR sky130_fd_sc_hd__tapvpwrvgnd_1
X_8035_ _8693_/CLK _8035_/D load_slew740/X VGND VGND VPWR VPWR _8035_/Q sky130_fd_sc_hd__dfrtp_2
X_5247_ _5247_/A0 _4769_/X _5247_/S VGND VGND VPWR VPWR _5248_/A sky130_fd_sc_hd__mux2_2
XFILLER_102_368 VGND VGND VPWR VPWR sky130_fd_sc_hd__decap_3
XFILLER_130_666 VGND VGND VPWR VPWR sky130_fd_sc_hd__decap_3
XFILLER_29_48 VGND VGND VPWR VPWR sky130_fd_sc_hd__decap_3
XFILLER_130_699 VGND VGND VPWR VPWR sky130_fd_sc_hd__fill_1
XFILLER_29_647 VGND VGND VPWR VPWR sky130_fd_sc_hd__fill_1
XFILLER_56_400 VGND VGND VPWR VPWR sky130_fd_sc_hd__fill_1
XFILLER_68_260 VGND VGND VPWR VPWR sky130_fd_sc_hd__fill_2
XFILLER_75_219 VGND VGND VPWR VPWR sky130_fd_sc_hd__decap_3
X_5178_ _7645_/Q _4973_/X _5184_/S VGND VGND VPWR VPWR _5179_/A sky130_fd_sc_hd__mux2_2
X_4129_ _4129_/A _4129_/B VGND VGND VPWR VPWR _4129_/X sky130_fd_sc_hd__or2_2
XFILLER_43_105 VGND VGND VPWR VPWR sky130_fd_sc_hd__decap_3
XFILLER_43_116 VGND VGND VPWR VPWR sky130_fd_sc_hd__decap_3
XFILLER_45_47 VGND VGND VPWR VPWR sky130_fd_sc_hd__decap_3
XFILLER_43_138 VGND VGND VPWR VPWR sky130_fd_sc_hd__decap_3
XFILLER_101_31 VGND VGND VPWR VPWR sky130_fd_sc_hd__fill_2
XFILLER_24_363 VGND VGND VPWR VPWR sky130_fd_sc_hd__fill_1
XFILLER_12_514 VGND VGND VPWR VPWR sky130_fd_sc_hd__decap_3
XFILLER_24_374 VGND VGND VPWR VPWR sky130_fd_sc_hd__decap_3
XTAP_TAPCELL_ROW_65_1197 VGND VPWR sky130_fd_sc_hd__tapvpwrvgnd_1
X_8799_ _8799_/CLK _8799_/D fanout609/A VGND VGND VPWR VPWR _8799_/Q sky130_fd_sc_hd__dfrtp_2
X_7819_ _8477_/CLK _7819_/D load_slew605/X VGND VGND VPWR VPWR _7819_/Q sky130_fd_sc_hd__dfrtp_2
XFILLER_61_57 VGND VGND VPWR VPWR sky130_fd_sc_hd__decap_3
XFILLER_8_507 VGND VGND VPWR VPWR sky130_fd_sc_hd__decap_3
XFILLER_8_518 VGND VGND VPWR VPWR sky130_fd_sc_hd__decap_3
XFILLER_124_3 VGND VGND VPWR VPWR sky130_fd_sc_hd__decap_3
XTAP_TAPCELL_ROW_22_597 VGND VPWR sky130_fd_sc_hd__tapvpwrvgnd_1
XFILLER_125_438 VGND VGND VPWR VPWR sky130_fd_sc_hd__decap_3
XFILLER_4_713 VGND VGND VPWR VPWR sky130_fd_sc_hd__decap_3
XFILLER_125_449 VGND VGND VPWR VPWR sky130_fd_sc_hd__decap_3
XFILLER_4_746 VGND VGND VPWR VPWR sky130_fd_sc_hd__decap_3
XFILLER_4_757 VGND VGND VPWR VPWR sky130_fd_sc_hd__decap_3
XFILLER_10_50 VGND VGND VPWR VPWR sky130_fd_sc_hd__decap_3
XFILLER_121_600 VGND VGND VPWR VPWR sky130_fd_sc_hd__fill_1
XFILLER_10_83 VGND VGND VPWR VPWR sky130_fd_sc_hd__fill_1
XFILLER_10_94 VGND VGND VPWR VPWR sky130_fd_sc_hd__decap_3
XFILLER_126_50 VGND VGND VPWR VPWR sky130_fd_sc_hd__decap_3
XFILLER_133_482 VGND VGND VPWR VPWR sky130_fd_sc_hd__decap_3
XFILLER_121_666 VGND VGND VPWR VPWR sky130_fd_sc_hd__decap_3
XFILLER_121_677 VGND VGND VPWR VPWR sky130_fd_sc_hd__fill_1
XFILLER_126_83 VGND VGND VPWR VPWR sky130_fd_sc_hd__fill_1
XFILLER_126_94 VGND VGND VPWR VPWR sky130_fd_sc_hd__decap_3
XFILLER_67_709 VGND VGND VPWR VPWR sky130_fd_sc_hd__decap_3
XFILLER_86_54 VGND VGND VPWR VPWR sky130_fd_sc_hd__decap_3
XFILLER_75_720 VGND VGND VPWR VPWR sky130_fd_sc_hd__decap_3
XFILLER_86_76 VGND VGND VPWR VPWR sky130_fd_sc_hd__decap_3
XFILLER_19_124 VGND VGND VPWR VPWR sky130_fd_sc_hd__decap_3
XFILLER_19_81 VGND VGND VPWR VPWR sky130_fd_sc_hd__decap_3
XFILLER_47_499 VGND VGND VPWR VPWR sky130_fd_sc_hd__decap_3
XFILLER_90_701 VGND VGND VPWR VPWR sky130_fd_sc_hd__decap_3
XFILLER_70_480 VGND VGND VPWR VPWR sky130_fd_sc_hd__decap_3
XFILLER_129_700 VGND VGND VPWR VPWR sky130_fd_sc_hd__decap_3
XFILLER_30_333 VGND VGND VPWR VPWR sky130_fd_sc_hd__decap_3
XFILLER_42_193 VGND VGND VPWR VPWR sky130_fd_sc_hd__decap_3
XFILLER_89_6 VGND VGND VPWR VPWR sky130_fd_sc_hd__fill_1
XFILLER_128_221 VGND VGND VPWR VPWR sky130_fd_sc_hd__decap_3
XFILLER_129_744 VGND VGND VPWR VPWR sky130_fd_sc_hd__decap_3
XFILLER_30_377 VGND VGND VPWR VPWR sky130_fd_sc_hd__fill_1
XTAP_TAPCELL_ROW_41_862 VGND VPWR sky130_fd_sc_hd__tapvpwrvgnd_1
XTAP_TAPCELL_ROW_41_873 VGND VPWR sky130_fd_sc_hd__tapvpwrvgnd_1
XFILLER_129_777 VGND VGND VPWR VPWR sky130_fd_sc_hd__decap_3
XFILLER_129_788 VGND VGND VPWR VPWR sky130_fd_sc_hd__decap_3
XFILLER_116_427 VGND VGND VPWR VPWR sky130_fd_sc_hd__decap_3
XFILLER_128_298 VGND VGND VPWR VPWR sky130_fd_sc_hd__fill_2
XFILLER_7_584 VGND VGND VPWR VPWR sky130_fd_sc_hd__decap_3
XTAP_TAPCELL_ROW_96_1636 VGND VPWR sky130_fd_sc_hd__tapvpwrvgnd_1
Xmax_cap226 _3828_/X VGND VGND VPWR VPWR _4639_/A1 sky130_fd_sc_hd__buf_6
Xmax_cap215 _5881_/X VGND VGND VPWR VPWR _5893_/A1 sky130_fd_sc_hd__buf_2
Xmax_cap204 _7231_/X VGND VGND VPWR VPWR _7242_/B1 sky130_fd_sc_hd__clkbuf_2
X_4480_ _8764_/Q _7539_/Q _7620_/Q _7701_/Q _4528_/S _4531_/S1 VGND VGND VPWR VPWR
+ _4480_/X sky130_fd_sc_hd__mux4_2
Xmax_cap259 _4032_/B VGND VGND VPWR VPWR _4629_/B sky130_fd_sc_hd__buf_6
Xmax_cap248 _3811_/X VGND VGND VPWR VPWR _4652_/A2 sky130_fd_sc_hd__buf_6
Xmax_cap237 _5907_/A VGND VGND VPWR VPWR _5946_/A sky130_fd_sc_hd__buf_6
XFILLER_124_471 VGND VGND VPWR VPWR sky130_fd_sc_hd__decap_3
X_6150_ _6150_/A VGND VGND VPWR VPWR _8137_/D sky130_fd_sc_hd__buf_6
XFILLER_111_121 VGND VGND VPWR VPWR sky130_fd_sc_hd__fill_1
Xload_slew421 _4528_/S VGND VGND VPWR VPWR _4523_/S0 sky130_fd_sc_hd__buf_4
X_5101_ _5101_/A VGND VGND VPWR VPWR _7609_/D sky130_fd_sc_hd__buf_1
XFILLER_97_355 VGND VGND VPWR VPWR sky130_fd_sc_hd__fill_2
XFILLER_97_366 VGND VGND VPWR VPWR sky130_fd_sc_hd__decap_3
Xload_slew465 _4559_/S VGND VGND VPWR VPWR _4630_/S sky130_fd_sc_hd__buf_4
Xload_slew432 _3973_/S VGND VGND VPWR VPWR _3996_/S sky130_fd_sc_hd__buf_4
X_6081_ _8106_/Q _4823_/A _6095_/S VGND VGND VPWR VPWR _6082_/A sky130_fd_sc_hd__mux2_2
XFILLER_111_165 VGND VGND VPWR VPWR sky130_fd_sc_hd__decap_3
XFILLER_111_187 VGND VGND VPWR VPWR sky130_fd_sc_hd__decap_3
XFILLER_112_699 VGND VGND VPWR VPWR sky130_fd_sc_hd__fill_1
XFILLER_66_731 VGND VGND VPWR VPWR sky130_fd_sc_hd__decap_3
X_5032_ _5118_/A VGND VGND VPWR VPWR _5053_/S sky130_fd_sc_hd__buf_2
XFILLER_26_639 VGND VGND VPWR VPWR sky130_fd_sc_hd__decap_3
XFILLER_93_561 VGND VGND VPWR VPWR sky130_fd_sc_hd__decap_3
XTAP_TAPCELL_ROW_49_973 VGND VPWR sky130_fd_sc_hd__tapvpwrvgnd_1
XTAP_TAPCELL_ROW_49_984 VGND VPWR sky130_fd_sc_hd__tapvpwrvgnd_1
XFILLER_53_447 VGND VGND VPWR VPWR sky130_fd_sc_hd__fill_1
XFILLER_65_285 VGND VGND VPWR VPWR sky130_fd_sc_hd__decap_3
X_6983_ _6983_/A VGND VGND VPWR VPWR _8529_/D sky130_fd_sc_hd__buf_6
XFILLER_15_39 VGND VGND VPWR VPWR sky130_fd_sc_hd__decap_3
XFILLER_81_789 VGND VGND VPWR VPWR sky130_fd_sc_hd__fill_2
XTAP_TAPCELL_ROW_105_1765 VGND VPWR sky130_fd_sc_hd__tapvpwrvgnd_1
X_8722_ _8803_/CLK _8722_/D wire547/X VGND VGND VPWR VPWR _8722_/Q sky130_fd_sc_hd__dfrtp_2
X_5934_ _5947_/A VGND VGND VPWR VPWR _5934_/X sky130_fd_sc_hd__clkbuf_1
XFILLER_40_119 VGND VGND VPWR VPWR sky130_fd_sc_hd__fill_1
X_8653_ _8660_/CLK _8653_/D load_slew526/X VGND VGND VPWR VPWR _8653_/Q sky130_fd_sc_hd__dfrtp_2
X_5865_ _5852_/X _5853_/X _4977_/X _5865_/B1 hold781/X VGND VGND VPWR VPWR _7970_/D
+ sky130_fd_sc_hd__a32o_2
X_7604_ _8586_/CLK _7604_/D fanout537/X VGND VGND VPWR VPWR _7604_/Q sky130_fd_sc_hd__dfrtp_2
X_4816_ _4815_/X _7527_/Q _4820_/S VGND VGND VPWR VPWR _4817_/A sky130_fd_sc_hd__mux2_2
XFILLER_119_210 VGND VGND VPWR VPWR sky130_fd_sc_hd__decap_3
XFILLER_21_366 VGND VGND VPWR VPWR sky130_fd_sc_hd__decap_3
X_8584_ _8740_/CLK _8584_/D wire638/X VGND VGND VPWR VPWR _8584_/Q sky130_fd_sc_hd__dfrtp_2
X_5796_ _5796_/A VGND VGND VPWR VPWR _7936_/D sky130_fd_sc_hd__buf_1
XFILLER_21_399 VGND VGND VPWR VPWR sky130_fd_sc_hd__decap_3
XFILLER_31_38 VGND VGND VPWR VPWR sky130_fd_sc_hd__decap_3
X_7535_ _8760_/CLK _7535_/D load_slew718/X VGND VGND VPWR VPWR _7535_/Q sky130_fd_sc_hd__dfrtp_2
X_4747_ _4747_/A VGND VGND VPWR VPWR _7510_/D sky130_fd_sc_hd__buf_1
XFILLER_119_276 VGND VGND VPWR VPWR sky130_fd_sc_hd__decap_3
XFILLER_135_725 VGND VGND VPWR VPWR sky130_fd_sc_hd__decap_3
XFILLER_135_747 VGND VGND VPWR VPWR sky130_fd_sc_hd__decap_3
X_7466_ _4973_/X hold970/X _7474_/S VGND VGND VPWR VPWR _7467_/A sky130_fd_sc_hd__mux2_2
X_4678_ _7800_/Q _7881_/Q _7962_/Q _8043_/Q _4680_/S _4681_/A VGND VGND VPWR VPWR
+ _4678_/X sky130_fd_sc_hd__mux4_2
XFILLER_134_224 VGND VGND VPWR VPWR sky130_fd_sc_hd__decap_3
XFILLER_134_235 VGND VGND VPWR VPWR sky130_fd_sc_hd__decap_3
XFILLER_135_769 VGND VGND VPWR VPWR sky130_fd_sc_hd__decap_3
X_7397_ _7397_/A0 _4832_/A _7407_/S VGND VGND VPWR VPWR _7398_/A sky130_fd_sc_hd__mux2_2
X_6417_ _4807_/X hold938/X _6419_/S VGND VGND VPWR VPWR _6418_/A sky130_fd_sc_hd__mux2_1
XFILLER_134_268 VGND VGND VPWR VPWR sky130_fd_sc_hd__decap_3
XFILLER_1_727 VGND VGND VPWR VPWR sky130_fd_sc_hd__fill_1
X_6348_ _5011_/X _8231_/Q _6356_/S VGND VGND VPWR VPWR _6349_/A sky130_fd_sc_hd__mux2_2
XFILLER_1_738 VGND VGND VPWR VPWR sky130_fd_sc_hd__decap_3
XFILLER_103_655 VGND VGND VPWR VPWR sky130_fd_sc_hd__decap_3
XFILLER_130_430 VGND VGND VPWR VPWR sky130_fd_sc_hd__decap_3
XFILLER_130_463 VGND VGND VPWR VPWR sky130_fd_sc_hd__decap_3
XFILLER_88_355 VGND VGND VPWR VPWR sky130_fd_sc_hd__decap_3
X_6279_ _4875_/X _8199_/Q _6289_/S VGND VGND VPWR VPWR _6280_/A sky130_fd_sc_hd__mux2_4
X_8018_ _8758_/CLK _8018_/D fanout713/X VGND VGND VPWR VPWR _8018_/Q sky130_fd_sc_hd__dfrtp_2
XFILLER_17_617 VGND VGND VPWR VPWR sky130_fd_sc_hd__decap_3
XFILLER_29_466 VGND VGND VPWR VPWR sky130_fd_sc_hd__fill_2
XFILLER_57_775 VGND VGND VPWR VPWR sky130_fd_sc_hd__decap_3
XFILLER_72_701 VGND VGND VPWR VPWR sky130_fd_sc_hd__decap_3
XFILLER_84_572 VGND VGND VPWR VPWR sky130_fd_sc_hd__decap_3
XFILLER_17_639 VGND VGND VPWR VPWR sky130_fd_sc_hd__decap_3
XFILLER_44_436 VGND VGND VPWR VPWR sky130_fd_sc_hd__fill_1
XFILLER_71_211 VGND VGND VPWR VPWR sky130_fd_sc_hd__decap_3
XTAP_TAPCELL_ROW_67_1226 VGND VPWR sky130_fd_sc_hd__tapvpwrvgnd_1
XTAP_TAPCELL_ROW_67_1237 VGND VPWR sky130_fd_sc_hd__tapvpwrvgnd_1
XFILLER_112_85 VGND VGND VPWR VPWR sky130_fd_sc_hd__fill_1
XFILLER_25_661 VGND VGND VPWR VPWR sky130_fd_sc_hd__decap_3
XTAP_TAPCELL_ROW_27_667 VGND VPWR sky130_fd_sc_hd__tapvpwrvgnd_1
XFILLER_112_96 VGND VGND VPWR VPWR sky130_fd_sc_hd__decap_3
XFILLER_52_480 VGND VGND VPWR VPWR sky130_fd_sc_hd__fill_1
XFILLER_72_56 VGND VGND VPWR VPWR sky130_fd_sc_hd__decap_3
XTAP_TAPCELL_ROW_80_1415 VGND VPWR sky130_fd_sc_hd__tapvpwrvgnd_1
XFILLER_12_333 VGND VGND VPWR VPWR sky130_fd_sc_hd__decap_3
XFILLER_40_631 VGND VGND VPWR VPWR sky130_fd_sc_hd__fill_1
XFILLER_40_653 VGND VGND VPWR VPWR sky130_fd_sc_hd__decap_3
XFILLER_126_747 VGND VGND VPWR VPWR sky130_fd_sc_hd__decap_3
XFILLER_21_60 VGND VGND VPWR VPWR sky130_fd_sc_hd__decap_3
XTAP_TAPCELL_ROW_78_1388 VGND VPWR sky130_fd_sc_hd__tapvpwrvgnd_1
XFILLER_113_408 VGND VGND VPWR VPWR sky130_fd_sc_hd__decap_3
XFILLER_125_279 VGND VGND VPWR VPWR sky130_fd_sc_hd__fill_1
XFILLER_98_108 VGND VGND VPWR VPWR sky130_fd_sc_hd__fill_1
XFILLER_4_598 VGND VGND VPWR VPWR sky130_fd_sc_hd__decap_3
XTAP_TAPCELL_ROW_91_1566 VGND VPWR sky130_fd_sc_hd__tapvpwrvgnd_1
Xclkbuf_leaf_40_CLK clkbuf_leaf_48_CLK/A VGND VGND VPWR VPWR _8799_/CLK sky130_fd_sc_hd__clkbuf_8
XFILLER_121_452 VGND VGND VPWR VPWR sky130_fd_sc_hd__fill_2
XFILLER_133_290 VGND VGND VPWR VPWR sky130_fd_sc_hd__decap_3
XFILLER_97_86 VGND VGND VPWR VPWR sky130_fd_sc_hd__fill_1
XFILLER_0_760 VGND VGND VPWR VPWR sky130_fd_sc_hd__decap_3
XFILLER_121_463 VGND VGND VPWR VPWR sky130_fd_sc_hd__decap_3
XFILLER_67_528 VGND VGND VPWR VPWR sky130_fd_sc_hd__decap_3
XFILLER_79_399 VGND VGND VPWR VPWR sky130_fd_sc_hd__decap_3
XTAP_TAPCELL_ROW_7_392 VGND VPWR sky130_fd_sc_hd__tapvpwrvgnd_1
XFILLER_62_200 VGND VGND VPWR VPWR sky130_fd_sc_hd__fill_1
XFILLER_90_531 VGND VGND VPWR VPWR sky130_fd_sc_hd__fill_1
XFILLER_90_542 VGND VGND VPWR VPWR sky130_fd_sc_hd__fill_2
XTAP_TAPCELL_ROW_46_932 VGND VPWR sky130_fd_sc_hd__tapvpwrvgnd_1
XTAP_TAPCELL_ROW_46_943 VGND VPWR sky130_fd_sc_hd__tapvpwrvgnd_1
XFILLER_23_609 VGND VGND VPWR VPWR sky130_fd_sc_hd__decap_3
X_3980_ _7980_/Q _4032_/B VGND VGND VPWR VPWR _3980_/X sky130_fd_sc_hd__or2_2
XFILLER_90_586 VGND VGND VPWR VPWR sky130_fd_sc_hd__fill_2
X_5650_ _7868_/Q _4887_/A _5654_/S VGND VGND VPWR VPWR _5651_/A sky130_fd_sc_hd__mux2_2
XFILLER_30_141 VGND VGND VPWR VPWR sky130_fd_sc_hd__decap_3
X_4601_ _8694_/Q _3768_/X _4600_/X VGND VGND VPWR VPWR _4601_/X sky130_fd_sc_hd__o21a_2
XFILLER_129_541 VGND VGND VPWR VPWR sky130_fd_sc_hd__decap_3
XTAP_TAPCELL_ROW_100_1695 VGND VPWR sky130_fd_sc_hd__tapvpwrvgnd_1
X_5581_ _5581_/A0 _4749_/A _5591_/S VGND VGND VPWR VPWR _5582_/A sky130_fd_sc_hd__mux2_2
XFILLER_129_585 VGND VGND VPWR VPWR sky130_fd_sc_hd__decap_3
XFILLER_7_51 VGND VGND VPWR VPWR sky130_fd_sc_hd__decap_3
X_7320_ _7320_/A VGND VGND VPWR VPWR _8719_/D sky130_fd_sc_hd__buf_1
X_4532_ _4529_/X _4530_/X _4531_/X _4534_/A VGND VGND VPWR VPWR _4532_/X sky130_fd_sc_hd__a22o_2
XFILLER_116_224 VGND VGND VPWR VPWR sky130_fd_sc_hd__decap_3
XFILLER_7_84 VGND VGND VPWR VPWR sky130_fd_sc_hd__decap_3
XTAP_TAPCELL_ROW_133_2150 VGND VPWR sky130_fd_sc_hd__tapvpwrvgnd_1
XTAP_TAPCELL_ROW_133_2161 VGND VPWR sky130_fd_sc_hd__tapvpwrvgnd_1
X_7251_ _7253_/A1 _4841_/X _7255_/A3 _7255_/B1 hold850/X VGND VGND VPWR VPWR _8677_/D
+ sky130_fd_sc_hd__a32o_2
X_4463_ _8114_/Q _8195_/Q _8276_/Q _8357_/Q _4554_/S _4552_/A1 VGND VGND VPWR VPWR
+ _4463_/X sky130_fd_sc_hd__mux4_2
XFILLER_131_205 VGND VGND VPWR VPWR sky130_fd_sc_hd__decap_3
XFILLER_132_728 VGND VGND VPWR VPWR sky130_fd_sc_hd__decap_3
X_6202_ _6202_/A VGND VGND VPWR VPWR _8162_/D sky130_fd_sc_hd__buf_6
XFILLER_125_791 VGND VGND VPWR VPWR sky130_fd_sc_hd__decap_3
XPHY_EDGE_ROW_15_Right_15 VGND VGND VPWR VPWR sky130_fd_sc_hd__decap_3
Xclkbuf_leaf_31_CLK clkload3/A VGND VGND VPWR VPWR _8688_/CLK sky130_fd_sc_hd__clkbuf_8
X_7182_ _7188_/A1 _4957_/X _7187_/A3 _7187_/B1 hold772/X VGND VGND VPWR VPWR _8623_/D
+ sky130_fd_sc_hd__a32o_2
X_4394_ _8108_/Q _8189_/Q _8270_/Q _8351_/Q _4435_/S _4442_/A VGND VGND VPWR VPWR
+ _4394_/X sky130_fd_sc_hd__mux4_2
XFILLER_112_430 VGND VGND VPWR VPWR sky130_fd_sc_hd__decap_3
XFILLER_131_249 VGND VGND VPWR VPWR sky130_fd_sc_hd__decap_3
XTAP_TAPCELL_ROW_51_1005 VGND VPWR sky130_fd_sc_hd__tapvpwrvgnd_1
X_6133_ _8131_/Q _4928_/A _6137_/S VGND VGND VPWR VPWR _6134_/A sky130_fd_sc_hd__mux2_2
XFILLER_100_625 VGND VGND VPWR VPWR sky130_fd_sc_hd__decap_3
XFILLER_112_474 VGND VGND VPWR VPWR sky130_fd_sc_hd__fill_2
XFILLER_133_18 VGND VGND VPWR VPWR sky130_fd_sc_hd__decap_3
XFILLER_98_697 VGND VGND VPWR VPWR sky130_fd_sc_hd__decap_3
Xhold1004 _8220_/Q VGND VGND VPWR VPWR _6325_/A1 sky130_fd_sc_hd__dlygate4sd3_1
Xhold1015 _7503_/Q VGND VGND VPWR VPWR _4716_/A1 sky130_fd_sc_hd__dlygate4sd3_1
X_6064_ _8098_/Q _4790_/A _6074_/S VGND VGND VPWR VPWR _6065_/A sky130_fd_sc_hd__mux2_2
Xhold1026 _8115_/Q VGND VGND VPWR VPWR _6100_/A0 sky130_fd_sc_hd__dlygate4sd3_1
Xhold1037 _8774_/Q VGND VGND VPWR VPWR _7435_/A0 sky130_fd_sc_hd__dlygate4sd3_1
Xhold1048 _8572_/Q VGND VGND VPWR VPWR _7074_/A1 sky130_fd_sc_hd__dlygate4sd3_1
X_5015_ _5015_/A VGND VGND VPWR VPWR _5015_/X sky130_fd_sc_hd__buf_1
XFILLER_54_701 VGND VGND VPWR VPWR sky130_fd_sc_hd__decap_3
Xhold1059 _7508_/Q VGND VGND VPWR VPWR _4736_/A1 sky130_fd_sc_hd__dlygate4sd3_1
XFILLER_26_27 VGND VGND VPWR VPWR sky130_fd_sc_hd__fill_1
XFILLER_26_38 VGND VGND VPWR VPWR sky130_fd_sc_hd__decap_3
XFILLER_38_296 VGND VGND VPWR VPWR sky130_fd_sc_hd__decap_3
XFILLER_54_723 VGND VGND VPWR VPWR sky130_fd_sc_hd__decap_3
XFILLER_81_520 VGND VGND VPWR VPWR sky130_fd_sc_hd__decap_3
XFILLER_53_244 VGND VGND VPWR VPWR sky130_fd_sc_hd__fill_1
XPHY_EDGE_ROW_24_Right_24 VGND VGND VPWR VPWR sky130_fd_sc_hd__decap_3
Xclkbuf_leaf_98_CLK clkbuf_leaf_99_CLK/A VGND VGND VPWR VPWR _8709_/CLK sky130_fd_sc_hd__clkbuf_8
X_6966_ _6966_/A VGND VGND VPWR VPWR _8521_/D sky130_fd_sc_hd__buf_6
XFILLER_13_108 VGND VGND VPWR VPWR sky130_fd_sc_hd__decap_3
XFILLER_13_119 VGND VGND VPWR VPWR sky130_fd_sc_hd__fill_2
XFILLER_41_428 VGND VGND VPWR VPWR sky130_fd_sc_hd__decap_3
XTAP_TAPCELL_ROW_24_626 VGND VPWR sky130_fd_sc_hd__tapvpwrvgnd_1
X_8705_ _8786_/CLK _8705_/D wire669/X VGND VGND VPWR VPWR _8705_/Q sky130_fd_sc_hd__dfrtp_2
X_5917_ _5919_/A1 _5919_/A2 _4803_/X _5919_/B1 hold811/X VGND VGND VPWR VPWR _8010_/D
+ sky130_fd_sc_hd__a32o_2
XFILLER_22_642 VGND VGND VPWR VPWR sky130_fd_sc_hd__fill_2
XFILLER_42_26 VGND VGND VPWR VPWR sky130_fd_sc_hd__fill_2
X_6897_ _7002_/S VGND VGND VPWR VPWR _6916_/S sky130_fd_sc_hd__buf_6
XTAP_TAPCELL_ROW_62_1156 VGND VPWR sky130_fd_sc_hd__tapvpwrvgnd_1
XTAP_TAPCELL_ROW_62_1167 VGND VPWR sky130_fd_sc_hd__tapvpwrvgnd_1
X_8636_ _8637_/CLK _8636_/D fanout595/A VGND VGND VPWR VPWR _8636_/Q sky130_fd_sc_hd__dfrtp_2
X_5848_ _5848_/A VGND VGND VPWR VPWR _7961_/D sky130_fd_sc_hd__buf_1
X_8567_ _8648_/CLK _8567_/D load_slew489/X VGND VGND VPWR VPWR _8567_/Q sky130_fd_sc_hd__dfrtp_2
X_5779_ _5779_/A VGND VGND VPWR VPWR _7928_/D sky130_fd_sc_hd__buf_1
XFILLER_108_714 VGND VGND VPWR VPWR sky130_fd_sc_hd__decap_3
XTAP_TAPCELL_ROW_118_1945 VGND VPWR sky130_fd_sc_hd__tapvpwrvgnd_1
X_7518_ _8743_/CLK _7518_/D fanout520/X VGND VGND VPWR VPWR _7518_/Q sky130_fd_sc_hd__dfrtp_2
XFILLER_108_769 VGND VGND VPWR VPWR sky130_fd_sc_hd__fill_1
XFILLER_135_533 VGND VGND VPWR VPWR sky130_fd_sc_hd__decap_3
X_8498_ _8737_/CLK _8498_/D fanout522/X VGND VGND VPWR VPWR _8498_/Q sky130_fd_sc_hd__dfrtp_2
XFILLER_1_502 VGND VGND VPWR VPWR sky130_fd_sc_hd__fill_2
XPHY_EDGE_ROW_33_Right_33 VGND VGND VPWR VPWR sky130_fd_sc_hd__decap_3
X_7449_ _8781_/Q _4936_/A _7449_/S VGND VGND VPWR VPWR _7450_/A sky130_fd_sc_hd__mux2_2
XFILLER_122_238 VGND VGND VPWR VPWR sky130_fd_sc_hd__fill_2
XFILLER_89_620 VGND VGND VPWR VPWR sky130_fd_sc_hd__decap_3
Xclkbuf_leaf_22_CLK clkbuf_5_9__f_CLK/X VGND VGND VPWR VPWR _8728_/CLK sky130_fd_sc_hd__clkbuf_8
Xhold860 _8008_/Q VGND VGND VPWR VPWR hold860/X sky130_fd_sc_hd__dlygate4sd3_1
Xhold871 _8656_/Q VGND VGND VPWR VPWR hold871/X sky130_fd_sc_hd__dlygate4sd3_1
Xhold882 _8678_/Q VGND VGND VPWR VPWR hold882/X sky130_fd_sc_hd__dlygate4sd3_1
XFILLER_103_430 VGND VGND VPWR VPWR sky130_fd_sc_hd__decap_3
XFILLER_103_452 VGND VGND VPWR VPWR sky130_fd_sc_hd__decap_3
XFILLER_131_750 VGND VGND VPWR VPWR sky130_fd_sc_hd__decap_3
Xhold893 _8041_/Q VGND VGND VPWR VPWR hold893/X sky130_fd_sc_hd__dlygate4sd3_1
XFILLER_103_485 VGND VGND VPWR VPWR sky130_fd_sc_hd__fill_2
XFILLER_131_783 VGND VGND VPWR VPWR sky130_fd_sc_hd__fill_1
XFILLER_131_794 VGND VGND VPWR VPWR sky130_fd_sc_hd__decap_3
XFILLER_89_686 VGND VGND VPWR VPWR sky130_fd_sc_hd__fill_2
XFILLER_130_293 VGND VGND VPWR VPWR sky130_fd_sc_hd__decap_3
XTAP_TAPCELL_ROW_4_351 VGND VPWR sky130_fd_sc_hd__tapvpwrvgnd_1
XFILLER_123_84 VGND VGND VPWR VPWR sky130_fd_sc_hd__decap_3
XFILLER_29_296 VGND VGND VPWR VPWR sky130_fd_sc_hd__decap_3
XPHY_EDGE_ROW_42_Right_42 VGND VGND VPWR VPWR sky130_fd_sc_hd__decap_3
Xclkbuf_leaf_89_CLK clkbuf_leaf_89_CLK/A VGND VGND VPWR VPWR _8671_/CLK sky130_fd_sc_hd__clkbuf_8
XFILLER_16_71 VGND VGND VPWR VPWR sky130_fd_sc_hd__decap_3
XFILLER_44_277 VGND VGND VPWR VPWR sky130_fd_sc_hd__decap_3
XFILLER_72_586 VGND VGND VPWR VPWR sky130_fd_sc_hd__fill_2
XFILLER_12_130 VGND VGND VPWR VPWR sky130_fd_sc_hd__decap_3
XFILLER_12_141 VGND VGND VPWR VPWR sky130_fd_sc_hd__decap_3
XFILLER_40_461 VGND VGND VPWR VPWR sky130_fd_sc_hd__decap_3
XFILLER_9_635 VGND VGND VPWR VPWR sky130_fd_sc_hd__decap_3
XFILLER_40_483 VGND VGND VPWR VPWR sky130_fd_sc_hd__decap_3
XFILLER_9_668 VGND VGND VPWR VPWR sky130_fd_sc_hd__decap_3
XFILLER_126_511 VGND VGND VPWR VPWR sky130_fd_sc_hd__decap_3
XFILLER_32_70 VGND VGND VPWR VPWR sky130_fd_sc_hd__decap_3
XFILLER_8_178 VGND VGND VPWR VPWR sky130_fd_sc_hd__decap_3
XFILLER_9_679 VGND VGND VPWR VPWR sky130_fd_sc_hd__decap_3
XPHY_EDGE_ROW_51_Right_51 VGND VGND VPWR VPWR sky130_fd_sc_hd__decap_3
XFILLER_126_566 VGND VGND VPWR VPWR sky130_fd_sc_hd__fill_2
XFILLER_126_577 VGND VGND VPWR VPWR sky130_fd_sc_hd__decap_3
Xclkbuf_leaf_13_CLK clkload0/A VGND VGND VPWR VPWR _8727_/CLK sky130_fd_sc_hd__clkbuf_8
XFILLER_121_260 VGND VGND VPWR VPWR sky130_fd_sc_hd__decap_3
XFILLER_67_325 VGND VGND VPWR VPWR sky130_fd_sc_hd__decap_3
XFILLER_79_163 VGND VGND VPWR VPWR sky130_fd_sc_hd__decap_3
XFILLER_79_185 VGND VGND VPWR VPWR sky130_fd_sc_hd__decap_3
XFILLER_94_133 VGND VGND VPWR VPWR sky130_fd_sc_hd__decap_3
XFILLER_94_144 VGND VGND VPWR VPWR sky130_fd_sc_hd__fill_1
XFILLER_95_645 VGND VGND VPWR VPWR sky130_fd_sc_hd__decap_3
XFILLER_36_701 VGND VGND VPWR VPWR sky130_fd_sc_hd__fill_1
XPHY_EDGE_ROW_60_Right_60 VGND VGND VPWR VPWR sky130_fd_sc_hd__decap_3
XFILLER_94_188 VGND VGND VPWR VPWR sky130_fd_sc_hd__decap_3
X_6820_ _8453_/Q _4920_/A _6828_/S VGND VGND VPWR VPWR _6821_/A sky130_fd_sc_hd__mux2_2
XFILLER_16_480 VGND VGND VPWR VPWR sky130_fd_sc_hd__decap_3
XTAP_TAPCELL_ROW_102_1724 VGND VPWR sky130_fd_sc_hd__tapvpwrvgnd_1
X_3963_ _8069_/Q _8150_/Q _8231_/Q _8312_/Q _3957_/S _4552_/A1 VGND VGND VPWR VPWR
+ _3963_/X sky130_fd_sc_hd__mux4_2
X_6751_ _8420_/Q _4781_/A _6765_/S VGND VGND VPWR VPWR _6752_/A sky130_fd_sc_hd__mux2_2
X_3894_ _3894_/A1 _3883_/X _3886_/X _3893_/X VGND VGND VPWR VPWR _3894_/X sky130_fd_sc_hd__o31a_2
X_6682_ _6682_/A VGND VGND VPWR VPWR _8387_/D sky130_fd_sc_hd__buf_2
X_5702_ _5849_/S VGND VGND VPWR VPWR _5721_/S sky130_fd_sc_hd__buf_2
XFILLER_12_18 VGND VGND VPWR VPWR sky130_fd_sc_hd__decap_3
XFILLER_31_472 VGND VGND VPWR VPWR sky130_fd_sc_hd__decap_3
XTAP_TAPCELL_ROW_135_2201 VGND VPWR sky130_fd_sc_hd__tapvpwrvgnd_1
X_8421_ _8745_/CLK _8421_/D fanout619/X VGND VGND VPWR VPWR _8421_/Q sky130_fd_sc_hd__dfrtp_2
X_5633_ _7860_/Q _4853_/A _5633_/S VGND VGND VPWR VPWR _5634_/A sky130_fd_sc_hd__mux2_2
XFILLER_117_500 VGND VGND VPWR VPWR sky130_fd_sc_hd__decap_3
XFILLER_128_18 VGND VGND VPWR VPWR sky130_fd_sc_hd__decap_3
XFILLER_12_29 VGND VGND VPWR VPWR sky130_fd_sc_hd__decap_3
X_8352_ _8773_/CLK _8352_/D load_slew712/X VGND VGND VPWR VPWR _8352_/Q sky130_fd_sc_hd__dfrtp_2
X_5564_ _5564_/A0 _4715_/A _5570_/S VGND VGND VPWR VPWR _5565_/A sky130_fd_sc_hd__mux2_2
XFILLER_128_29 VGND VGND VPWR VPWR sky130_fd_sc_hd__decap_3
XFILLER_129_393 VGND VGND VPWR VPWR sky130_fd_sc_hd__fill_2
XFILLER_8_690 VGND VGND VPWR VPWR sky130_fd_sc_hd__decap_3
X_7303_ _7303_/A VGND VGND VPWR VPWR _8711_/D sky130_fd_sc_hd__buf_1
X_4515_ _8119_/Q _8200_/Q _8281_/Q _8362_/Q _4544_/S0 _3705_/C VGND VGND VPWR VPWR
+ _4515_/X sky130_fd_sc_hd__mux4_2
XPHY_EDGE_ROW_103_Right_103 VGND VGND VPWR VPWR sky130_fd_sc_hd__decap_3
X_8283_ _8769_/CLK _8283_/D fanout553/X VGND VGND VPWR VPWR _8283_/Q sky130_fd_sc_hd__dfrtp_2
X_5495_ _7795_/Q _4920_/A _5503_/S VGND VGND VPWR VPWR _5496_/A sky130_fd_sc_hd__mux2_2
XFILLER_132_525 VGND VGND VPWR VPWR sky130_fd_sc_hd__decap_3
XFILLER_132_536 VGND VGND VPWR VPWR sky130_fd_sc_hd__decap_3
X_7234_ _7239_/A1 _4782_/X _7242_/A3 _7242_/B1 hold783/X VGND VGND VPWR VPWR _8663_/D
+ sky130_fd_sc_hd__a32o_2
X_4446_ _7779_/Q _7860_/Q _4446_/S VGND VGND VPWR VPWR _4446_/X sky130_fd_sc_hd__mux2_2
XFILLER_132_569 VGND VGND VPWR VPWR sky130_fd_sc_hd__decap_3
XTAP_TAPCELL_ROW_113_1875 VGND VPWR sky130_fd_sc_hd__tapvpwrvgnd_1
Xfanout614 input1/X VGND VGND VPWR VPWR fanout614/X sky130_fd_sc_hd__clkdlybuf4s25_1
X_7165_ _7165_/A VGND VGND VPWR VPWR _8615_/D sky130_fd_sc_hd__buf_2
X_4377_ _7692_/Q _3816_/X _4551_/B1 _7611_/Q _3732_/A VGND VGND VPWR VPWR _4377_/X
+ sky130_fd_sc_hd__o221a_2
XFILLER_113_794 VGND VGND VPWR VPWR sky130_fd_sc_hd__fill_2
XFILLER_58_303 VGND VGND VPWR VPWR sky130_fd_sc_hd__decap_3
XFILLER_86_601 VGND VGND VPWR VPWR sky130_fd_sc_hd__decap_3
XFILLER_98_483 VGND VGND VPWR VPWR sky130_fd_sc_hd__decap_3
Xfanout625 fanout629/X VGND VGND VPWR VPWR fanout625/X sky130_fd_sc_hd__clkdlybuf4s25_1
Xfanout658 fanout685/X VGND VGND VPWR VPWR fanout658/X sky130_fd_sc_hd__clkdlybuf4s25_1
X_6116_ _8123_/Q _4894_/A _6116_/S VGND VGND VPWR VPWR _6117_/A sky130_fd_sc_hd__mux2_2
XFILLER_100_433 VGND VGND VPWR VPWR sky130_fd_sc_hd__decap_3
XFILLER_100_444 VGND VGND VPWR VPWR sky130_fd_sc_hd__fill_2
XFILLER_112_282 VGND VGND VPWR VPWR sky130_fd_sc_hd__decap_3
X_7096_ _7096_/A VGND VGND VPWR VPWR _8582_/D sky130_fd_sc_hd__buf_2
XFILLER_100_477 VGND VGND VPWR VPWR sky130_fd_sc_hd__decap_3
XFILLER_37_26 VGND VGND VPWR VPWR sky130_fd_sc_hd__decap_3
XFILLER_39_561 VGND VGND VPWR VPWR sky130_fd_sc_hd__decap_3
XFILLER_86_678 VGND VGND VPWR VPWR sky130_fd_sc_hd__fill_1
X_6047_ _8090_/Q _4756_/A _6053_/S VGND VGND VPWR VPWR _6048_/A sky130_fd_sc_hd__mux2_2
XFILLER_26_200 VGND VGND VPWR VPWR sky130_fd_sc_hd__decap_3
XFILLER_39_583 VGND VGND VPWR VPWR sky130_fd_sc_hd__fill_2
XTAP_TAPCELL_ROW_1_310 VGND VPWR sky130_fd_sc_hd__tapvpwrvgnd_1
XFILLER_27_778 VGND VGND VPWR VPWR sky130_fd_sc_hd__decap_3
XFILLER_26_277 VGND VGND VPWR VPWR sky130_fd_sc_hd__decap_3
XFILLER_53_25 VGND VGND VPWR VPWR sky130_fd_sc_hd__decap_3
X_7998_ _8660_/CLK _7998_/D fanout514/X VGND VGND VPWR VPWR _7998_/Q sky130_fd_sc_hd__dfrtp_2
XFILLER_14_439 VGND VGND VPWR VPWR sky130_fd_sc_hd__decap_3
XFILLER_41_225 VGND VGND VPWR VPWR sky130_fd_sc_hd__decap_3
XFILLER_53_47 VGND VGND VPWR VPWR sky130_fd_sc_hd__fill_1
X_6949_ _6949_/A VGND VGND VPWR VPWR _8513_/D sky130_fd_sc_hd__buf_6
XFILLER_10_634 VGND VGND VPWR VPWR sky130_fd_sc_hd__decap_3
XFILLER_10_645 VGND VGND VPWR VPWR sky130_fd_sc_hd__decap_3
XFILLER_50_781 VGND VGND VPWR VPWR sky130_fd_sc_hd__fill_2
X_8619_ _8781_/CLK _8619_/D fanout749/X VGND VGND VPWR VPWR _8619_/Q sky130_fd_sc_hd__dfrtp_2
XFILLER_10_678 VGND VGND VPWR VPWR sky130_fd_sc_hd__decap_3
XFILLER_6_616 VGND VGND VPWR VPWR sky130_fd_sc_hd__decap_3
XFILLER_108_533 VGND VGND VPWR VPWR sky130_fd_sc_hd__fill_1
XFILLER_5_137 VGND VGND VPWR VPWR sky130_fd_sc_hd__decap_3
XFILLER_123_503 VGND VGND VPWR VPWR sky130_fd_sc_hd__fill_1
XFILLER_135_363 VGND VGND VPWR VPWR sky130_fd_sc_hd__fill_1
XTAP_TAPCELL_ROW_75_1336 VGND VPWR sky130_fd_sc_hd__tapvpwrvgnd_1
XFILLER_118_62 VGND VGND VPWR VPWR sky130_fd_sc_hd__decap_3
XFILLER_135_374 VGND VGND VPWR VPWR sky130_fd_sc_hd__fill_2
XFILLER_135_396 VGND VGND VPWR VPWR sky130_fd_sc_hd__decap_3
XTAP_TAPCELL_ROW_75_1347 VGND VPWR sky130_fd_sc_hd__tapvpwrvgnd_1
XTAP_TAPCELL_ROW_9_421 VGND VPWR sky130_fd_sc_hd__tapvpwrvgnd_1
XFILLER_89_461 VGND VGND VPWR VPWR sky130_fd_sc_hd__decap_3
XFILLER_89_483 VGND VGND VPWR VPWR sky130_fd_sc_hd__fill_2
XFILLER_131_591 VGND VGND VPWR VPWR sky130_fd_sc_hd__decap_3
XFILLER_134_50 VGND VGND VPWR VPWR sky130_fd_sc_hd__decap_3
XFILLER_76_122 VGND VGND VPWR VPWR sky130_fd_sc_hd__fill_1
XFILLER_76_133 VGND VGND VPWR VPWR sky130_fd_sc_hd__decap_3
XFILLER_77_634 VGND VGND VPWR VPWR sky130_fd_sc_hd__fill_2
XFILLER_77_645 VGND VGND VPWR VPWR sky130_fd_sc_hd__decap_3
XFILLER_134_83 VGND VGND VPWR VPWR sky130_fd_sc_hd__fill_1
XFILLER_134_94 VGND VGND VPWR VPWR sky130_fd_sc_hd__decap_3
XFILLER_18_701 VGND VGND VPWR VPWR sky130_fd_sc_hd__decap_3
XFILLER_92_626 VGND VGND VPWR VPWR sky130_fd_sc_hd__fill_2
XFILLER_45_520 VGND VGND VPWR VPWR sky130_fd_sc_hd__fill_1
XFILLER_91_103 VGND VGND VPWR VPWR sky130_fd_sc_hd__decap_3
XFILLER_91_136 VGND VGND VPWR VPWR sky130_fd_sc_hd__decap_3
XFILLER_92_648 VGND VGND VPWR VPWR sky130_fd_sc_hd__fill_1
XFILLER_27_81 VGND VGND VPWR VPWR sky130_fd_sc_hd__decap_3
XFILLER_45_564 VGND VGND VPWR VPWR sky130_fd_sc_hd__fill_1
XFILLER_91_169 VGND VGND VPWR VPWR sky130_fd_sc_hd__decap_3
XFILLER_32_214 VGND VGND VPWR VPWR sky130_fd_sc_hd__decap_3
XFILLER_60_501 VGND VGND VPWR VPWR sky130_fd_sc_hd__fill_2
XFILLER_60_512 VGND VGND VPWR VPWR sky130_fd_sc_hd__decap_3
XTAP_TAPCELL_ROW_86_1498 VGND VPWR sky130_fd_sc_hd__tapvpwrvgnd_1
XFILLER_60_556 VGND VGND VPWR VPWR sky130_fd_sc_hd__decap_3
Xclkbuf_leaf_2_CLK clkbuf_leaf_3_CLK/A VGND VGND VPWR VPWR _8804_/CLK sky130_fd_sc_hd__clkbuf_8
XFILLER_13_461 VGND VGND VPWR VPWR sky130_fd_sc_hd__fill_1
XFILLER_60_589 VGND VGND VPWR VPWR sky130_fd_sc_hd__decap_3
XFILLER_13_483 VGND VGND VPWR VPWR sky130_fd_sc_hd__decap_3
XFILLER_41_781 VGND VGND VPWR VPWR sky130_fd_sc_hd__decap_3
XFILLER_9_476 VGND VGND VPWR VPWR sky130_fd_sc_hd__decap_3
XFILLER_114_503 VGND VGND VPWR VPWR sky130_fd_sc_hd__decap_3
XFILLER_126_363 VGND VGND VPWR VPWR sky130_fd_sc_hd__fill_1
XFILLER_5_671 VGND VGND VPWR VPWR sky130_fd_sc_hd__fill_1
XFILLER_5_682 VGND VGND VPWR VPWR sky130_fd_sc_hd__decap_3
X_5280_ _5280_/A VGND VGND VPWR VPWR _7693_/D sky130_fd_sc_hd__buf_1
X_4300_ _4300_/A1 _4296_/X _4299_/X _3726_/A VGND VGND VPWR VPWR _4300_/X sky130_fd_sc_hd__a211o_2
XFILLER_4_41 VGND VGND VPWR VPWR sky130_fd_sc_hd__decap_3
X_4231_ _4231_/A _4231_/B VGND VGND VPWR VPWR _4231_/X sky130_fd_sc_hd__or2_2
XFILLER_4_74 VGND VGND VPWR VPWR sky130_fd_sc_hd__decap_3
XFILLER_4_85 VGND VGND VPWR VPWR sky130_fd_sc_hd__decap_3
XFILLER_67_111 VGND VGND VPWR VPWR sky130_fd_sc_hd__fill_1
XFILLER_67_122 VGND VGND VPWR VPWR sky130_fd_sc_hd__decap_3
XFILLER_95_431 VGND VGND VPWR VPWR sky130_fd_sc_hd__decap_3
X_4162_ _7997_/Q _3921_/X _4161_/X _4158_/A _4030_/S VGND VGND VPWR VPWR _4162_/X
+ sky130_fd_sc_hd__o221a_2
XFILLER_110_753 VGND VGND VPWR VPWR sky130_fd_sc_hd__decap_3
XFILLER_67_166 VGND VGND VPWR VPWR sky130_fd_sc_hd__fill_2
XFILLER_95_464 VGND VGND VPWR VPWR sky130_fd_sc_hd__decap_3
X_4093_ _4089_/X _4092_/X _4112_/S VGND VGND VPWR VPWR _4094_/A sky130_fd_sc_hd__mux2_2
XFILLER_95_497 VGND VGND VPWR VPWR sky130_fd_sc_hd__decap_3
XTAP_TAPCELL_ROW_128_2082 VGND VPWR sky130_fd_sc_hd__tapvpwrvgnd_1
X_7921_ _8734_/CLK _7921_/D fanout523/X VGND VGND VPWR VPWR _7921_/Q sky130_fd_sc_hd__dfrtp_2
XFILLER_48_391 VGND VGND VPWR VPWR sky130_fd_sc_hd__decap_3
XFILLER_23_203 VGND VGND VPWR VPWR sky130_fd_sc_hd__fill_1
XFILLER_24_737 VGND VGND VPWR VPWR sky130_fd_sc_hd__decap_3
XFILLER_36_586 VGND VGND VPWR VPWR sky130_fd_sc_hd__fill_2
XFILLER_51_512 VGND VGND VPWR VPWR sky130_fd_sc_hd__decap_3
X_7852_ _8274_/CLK _7852_/D load_slew696/X VGND VGND VPWR VPWR _7852_/Q sky130_fd_sc_hd__dfrtp_2
XFILLER_63_383 VGND VGND VPWR VPWR sky130_fd_sc_hd__fill_1
XFILLER_90_191 VGND VGND VPWR VPWR sky130_fd_sc_hd__fill_1
X_7783_ _8765_/CLK _7783_/D load_slew560/X VGND VGND VPWR VPWR _7783_/Q sky130_fd_sc_hd__dfrtp_2
X_6803_ _8445_/Q _4886_/A _6807_/S VGND VGND VPWR VPWR _6804_/A sky130_fd_sc_hd__mux2_2
X_4995_ _4995_/A VGND VGND VPWR VPWR _4995_/X sky130_fd_sc_hd__buf_1
XFILLER_11_409 VGND VGND VPWR VPWR sky130_fd_sc_hd__decap_3
XFILLER_23_17 VGND VGND VPWR VPWR sky130_fd_sc_hd__decap_3
XTAP_TAPCELL_ROW_34_765 VGND VPWR sky130_fd_sc_hd__tapvpwrvgnd_1
X_3946_ _7977_/Q _3811_/A _3880_/A _7896_/Q _3925_/A VGND VGND VPWR VPWR _3946_/X
+ sky130_fd_sc_hd__o221a_2
X_6734_ _8412_/Q _4748_/A _6744_/S VGND VGND VPWR VPWR _6735_/A sky130_fd_sc_hd__mux2_2
X_3877_ _4460_/A VGND VGND VPWR VPWR _3877_/X sky130_fd_sc_hd__clkbuf_2
X_8404_ _8727_/CLK _8404_/D load_slew533/X VGND VGND VPWR VPWR _8404_/Q sky130_fd_sc_hd__dfrtp_2
X_6665_ _8379_/Q _4952_/A _6681_/S VGND VGND VPWR VPWR _6666_/A sky130_fd_sc_hd__mux2_2
X_6596_ _4819_/X _8348_/Q _6612_/S VGND VGND VPWR VPWR _6597_/A sky130_fd_sc_hd__mux2_2
X_5616_ _5616_/A VGND VGND VPWR VPWR _7851_/D sky130_fd_sc_hd__buf_1
XFILLER_129_190 VGND VGND VPWR VPWR sky130_fd_sc_hd__decap_3
XTAP_TAPCELL_ROW_115_1904 VGND VPWR sky130_fd_sc_hd__tapvpwrvgnd_1
X_8335_ _8335_/CLK _8335_/D load_slew541/X VGND VGND VPWR VPWR _8335_/Q sky130_fd_sc_hd__dfrtp_2
X_5547_ _7819_/Q _5023_/A _5549_/S VGND VGND VPWR VPWR _5548_/A sky130_fd_sc_hd__mux2_2
XFILLER_2_118 VGND VGND VPWR VPWR sky130_fd_sc_hd__decap_3
X_8266_ _8753_/CLK _8266_/D fanout688/X VGND VGND VPWR VPWR _8266_/Q sky130_fd_sc_hd__dfrtp_2
X_5478_ _7787_/Q _4886_/A _5482_/S VGND VGND VPWR VPWR _5479_/A sky130_fd_sc_hd__mux2_2
XFILLER_132_355 VGND VGND VPWR VPWR sky130_fd_sc_hd__decap_3
XFILLER_3_9 VGND VGND VPWR VPWR sky130_fd_sc_hd__decap_3
XFILLER_78_409 VGND VGND VPWR VPWR sky130_fd_sc_hd__fill_2
XTAP_TAPCELL_ROW_57_1088 VGND VPWR sky130_fd_sc_hd__tapvpwrvgnd_1
X_7217_ _7269_/A VGND VGND VPWR VPWR _7217_/X sky130_fd_sc_hd__clkbuf_1
X_4429_ _7777_/Q _7858_/Q _7939_/Q _8020_/Q _4446_/S _4450_/A VGND VGND VPWR VPWR
+ _4429_/X sky130_fd_sc_hd__mux4_2
XFILLER_120_528 VGND VGND VPWR VPWR sky130_fd_sc_hd__fill_1
XFILLER_132_388 VGND VGND VPWR VPWR sky130_fd_sc_hd__decap_3
XFILLER_99_781 VGND VGND VPWR VPWR sky130_fd_sc_hd__decap_3
Xfanout422 _4524_/S0 VGND VGND VPWR VPWR _4502_/S sky130_fd_sc_hd__clkdlybuf4s25_1
X_8197_ _8764_/CLK _8197_/D fanout562/X VGND VGND VPWR VPWR _8197_/Q sky130_fd_sc_hd__dfrtp_2
XFILLER_58_111 VGND VGND VPWR VPWR sky130_fd_sc_hd__fill_2
XFILLER_58_133 VGND VGND VPWR VPWR sky130_fd_sc_hd__decap_3
XFILLER_86_442 VGND VGND VPWR VPWR sky130_fd_sc_hd__decap_3
XTAP_TAPCELL_ROW_70_1266 VGND VPWR sky130_fd_sc_hd__tapvpwrvgnd_1
Xfanout433 _8044_/Q VGND VGND VPWR VPWR fanout433/X sky130_fd_sc_hd__clkdlybuf4s25_1
Xfanout455 fanout474/X VGND VGND VPWR VPWR _4352_/S sky130_fd_sc_hd__clkdlybuf4s25_1
Xfanout466 fanout472/X VGND VGND VPWR VPWR _4568_/S sky130_fd_sc_hd__clkdlybuf4s25_1
X_7148_ _7148_/A VGND VGND VPWR VPWR _8607_/D sky130_fd_sc_hd__buf_2
XFILLER_100_230 VGND VGND VPWR VPWR sky130_fd_sc_hd__decap_3
XFILLER_48_69 VGND VGND VPWR VPWR sky130_fd_sc_hd__decap_3
XTAP_TAPCELL_ROW_70_1277 VGND VPWR sky130_fd_sc_hd__tapvpwrvgnd_1
Xfanout477 fanout507/X VGND VGND VPWR VPWR fanout477/X sky130_fd_sc_hd__clkdlybuf4s25_1
Xfanout488 fanout492/X VGND VGND VPWR VPWR fanout488/X sky130_fd_sc_hd__clkdlybuf4s25_1
X_7079_ _7079_/A VGND VGND VPWR VPWR _8574_/D sky130_fd_sc_hd__buf_2
XFILLER_104_42 VGND VGND VPWR VPWR sky130_fd_sc_hd__decap_3
XFILLER_58_177 VGND VGND VPWR VPWR sky130_fd_sc_hd__decap_3
XFILLER_86_486 VGND VGND VPWR VPWR sky130_fd_sc_hd__decap_3
XFILLER_27_531 VGND VGND VPWR VPWR sky130_fd_sc_hd__decap_3
XFILLER_64_35 VGND VGND VPWR VPWR sky130_fd_sc_hd__fill_2
XFILLER_42_512 VGND VGND VPWR VPWR sky130_fd_sc_hd__decap_3
XFILLER_64_79 VGND VGND VPWR VPWR sky130_fd_sc_hd__decap_3
XFILLER_73_169 VGND VGND VPWR VPWR sky130_fd_sc_hd__fill_1
XFILLER_54_383 VGND VGND VPWR VPWR sky130_fd_sc_hd__decap_3
XFILLER_42_578 VGND VGND VPWR VPWR sky130_fd_sc_hd__decap_3
XFILLER_42_589 VGND VGND VPWR VPWR sky130_fd_sc_hd__decap_3
XFILLER_127_105 VGND VGND VPWR VPWR sky130_fd_sc_hd__decap_3
XFILLER_128_628 VGND VGND VPWR VPWR sky130_fd_sc_hd__decap_3
XTAP_TAPCELL_ROW_12_459 VGND VPWR sky130_fd_sc_hd__tapvpwrvgnd_1
XFILLER_10_464 VGND VGND VPWR VPWR sky130_fd_sc_hd__decap_3
XFILLER_127_116 VGND VGND VPWR VPWR sky130_fd_sc_hd__decap_3
XFILLER_13_72 VGND VGND VPWR VPWR sky130_fd_sc_hd__decap_3
XFILLER_108_341 VGND VGND VPWR VPWR sky130_fd_sc_hd__fill_2
XFILLER_129_72 VGND VGND VPWR VPWR sky130_fd_sc_hd__decap_3
XFILLER_89_10 VGND VGND VPWR VPWR sky130_fd_sc_hd__decap_3
XFILLER_89_43 VGND VGND VPWR VPWR sky130_fd_sc_hd__decap_3
XFILLER_108_374 VGND VGND VPWR VPWR sky130_fd_sc_hd__fill_1
XFILLER_123_333 VGND VGND VPWR VPWR sky130_fd_sc_hd__decap_3
XFILLER_135_193 VGND VGND VPWR VPWR sky130_fd_sc_hd__decap_3
XFILLER_2_663 VGND VGND VPWR VPWR sky130_fd_sc_hd__decap_3
XFILLER_2_696 VGND VGND VPWR VPWR sky130_fd_sc_hd__decap_3
XFILLER_49_122 VGND VGND VPWR VPWR sky130_fd_sc_hd__decap_3
XTAP_TAPCELL_ROW_88_1527 VGND VPWR sky130_fd_sc_hd__tapvpwrvgnd_1
XFILLER_18_531 VGND VGND VPWR VPWR sky130_fd_sc_hd__fill_1
XFILLER_64_136 VGND VGND VPWR VPWR sky130_fd_sc_hd__decap_3
XFILLER_80_607 VGND VGND VPWR VPWR sky130_fd_sc_hd__decap_3
XFILLER_18_575 VGND VGND VPWR VPWR sky130_fd_sc_hd__decap_3
XFILLER_52_309 VGND VGND VPWR VPWR sky130_fd_sc_hd__decap_3
XFILLER_80_629 VGND VGND VPWR VPWR sky130_fd_sc_hd__decap_3
XFILLER_33_589 VGND VGND VPWR VPWR sky130_fd_sc_hd__decap_3
XFILLER_60_342 VGND VGND VPWR VPWR sky130_fd_sc_hd__fill_1
X_3800_ _3889_/A VGND VGND VPWR VPWR _3800_/X sky130_fd_sc_hd__clkbuf_2
X_4780_ _4951_/A VGND VGND VPWR VPWR _4818_/B sky130_fd_sc_hd__clkbuf_1
XTAP_TAPCELL_ROW_31_724 VGND VPWR sky130_fd_sc_hd__tapvpwrvgnd_1
X_3731_ _4525_/S VGND VGND VPWR VPWR _4117_/A sky130_fd_sc_hd__clkbuf_2
XFILLER_119_617 VGND VGND VPWR VPWR sky130_fd_sc_hd__decap_3
XFILLER_118_116 VGND VGND VPWR VPWR sky130_fd_sc_hd__decap_3
XFILLER_118_138 VGND VGND VPWR VPWR sky130_fd_sc_hd__fill_2
XTAP_TAPCELL_ROW_99_1678 VGND VPWR sky130_fd_sc_hd__tapvpwrvgnd_1
Xclkload10 clkload10/A VGND VGND VPWR VPWR clkload10/X sky130_fd_sc_hd__clkbuf_8
X_6450_ _6450_/A VGND VGND VPWR VPWR _8279_/D sky130_fd_sc_hd__buf_2
XFILLER_115_801 VGND VGND VPWR VPWR sky130_fd_sc_hd__decap_3
Xclkload21 _8746_/CLK VGND VGND VPWR VPWR clkload21/Y sky130_fd_sc_hd__clkinv_2
Xclkload32 _8687_/CLK VGND VGND VPWR VPWR clkload32/Y sky130_fd_sc_hd__bufinv_16
Xclkload43 _8662_/CLK VGND VGND VPWR VPWR clkload43/X sky130_fd_sc_hd__clkbuf_8
X_6381_ _6381_/A VGND VGND VPWR VPWR _8246_/D sky130_fd_sc_hd__buf_2
X_5401_ _7750_/Q _4730_/A _5419_/S VGND VGND VPWR VPWR _5402_/A sky130_fd_sc_hd__mux2_2
XFILLER_127_694 VGND VGND VPWR VPWR sky130_fd_sc_hd__decap_3
XFILLER_133_108 VGND VGND VPWR VPWR sky130_fd_sc_hd__decap_3
XFILLER_133_119 VGND VGND VPWR VPWR sky130_fd_sc_hd__decap_3
Xclkload54 _8788_/CLK VGND VGND VPWR VPWR clkload54/X sky130_fd_sc_hd__clkbuf_8
Xclkload65 _8756_/CLK VGND VGND VPWR VPWR clkload65/Y sky130_fd_sc_hd__clkinv_2
Xclkload76 _8776_/CLK VGND VGND VPWR VPWR clkload76/X sky130_fd_sc_hd__clkbuf_8
X_8120_ _8768_/CLK _8120_/D load_slew568/X VGND VGND VPWR VPWR _8120_/Q sky130_fd_sc_hd__dfrtp_2
X_5332_ _5332_/A VGND VGND VPWR VPWR _7718_/D sky130_fd_sc_hd__buf_1
XFILLER_126_182 VGND VGND VPWR VPWR sky130_fd_sc_hd__fill_1
XFILLER_88_707 VGND VGND VPWR VPWR sky130_fd_sc_hd__decap_3
XFILLER_102_528 VGND VGND VPWR VPWR sky130_fd_sc_hd__decap_3
XFILLER_87_217 VGND VGND VPWR VPWR sky130_fd_sc_hd__decap_3
X_8051_ _8763_/CLK _8051_/D fanout556/X VGND VGND VPWR VPWR _8051_/Q sky130_fd_sc_hd__dfrtp_2
X_5263_ _5263_/A VGND VGND VPWR VPWR _7685_/D sky130_fd_sc_hd__buf_1
XTAP_TAPCELL_ROW_110_1834 VGND VPWR sky130_fd_sc_hd__tapvpwrvgnd_1
X_7002_ _4941_/X _8539_/Q _7002_/S VGND VGND VPWR VPWR _7003_/A sky130_fd_sc_hd__mux2_2
X_5194_ _5194_/A VGND VGND VPWR VPWR _7652_/D sky130_fd_sc_hd__buf_1
X_4214_ _3726_/A _4205_/X _4208_/X _4211_/X _4213_/X VGND VGND VPWR VPWR _4214_/X
+ sky130_fd_sc_hd__o32a_2
XFILLER_110_561 VGND VGND VPWR VPWR sky130_fd_sc_hd__decap_3
XFILLER_96_751 VGND VGND VPWR VPWR sky130_fd_sc_hd__decap_3
X_4145_ _7753_/Q _7834_/Q _4150_/S VGND VGND VPWR VPWR _4146_/B sky130_fd_sc_hd__mux2_2
XFILLER_110_583 VGND VGND VPWR VPWR sky130_fd_sc_hd__decap_3
XFILLER_68_475 VGND VGND VPWR VPWR sky130_fd_sc_hd__fill_1
XFILLER_68_486 VGND VGND VPWR VPWR sky130_fd_sc_hd__fill_1
XFILLER_95_272 VGND VGND VPWR VPWR sky130_fd_sc_hd__decap_3
XTAP_TAPCELL_ROW_39_835 VGND VPWR sky130_fd_sc_hd__tapvpwrvgnd_1
X_4076_ _7989_/Q _4399_/A2 _3775_/X _7908_/Q wire280/A VGND VGND VPWR VPWR _4076_/X
+ sky130_fd_sc_hd__o221a_2
XFILLER_55_169 VGND VGND VPWR VPWR sky130_fd_sc_hd__decap_3
X_7904_ _8483_/CLK _7904_/D fanout502/A VGND VGND VPWR VPWR _7904_/Q sky130_fd_sc_hd__dfrtp_2
XFILLER_51_331 VGND VGND VPWR VPWR sky130_fd_sc_hd__decap_3
XFILLER_63_180 VGND VGND VPWR VPWR sky130_fd_sc_hd__decap_3
X_7835_ _8732_/CLK _7835_/D fanout479/A VGND VGND VPWR VPWR _7835_/Q sky130_fd_sc_hd__dfrtp_2
XFILLER_12_718 VGND VGND VPWR VPWR sky130_fd_sc_hd__decap_3
XFILLER_11_228 VGND VGND VPWR VPWR sky130_fd_sc_hd__decap_3
XTAP_TAPCELL_ROW_121_1985 VGND VPWR sky130_fd_sc_hd__tapvpwrvgnd_1
X_7766_ _8793_/CLK _7766_/D fanout639/X VGND VGND VPWR VPWR _7766_/Q sky130_fd_sc_hd__dfrtp_2
X_4978_ _4977_/X _7565_/Q _4986_/S VGND VGND VPWR VPWR _4979_/A sky130_fd_sc_hd__mux2_2
X_3929_ _7733_/Q _7814_/Q _4454_/S VGND VGND VPWR VPWR _3929_/X sky130_fd_sc_hd__mux2_2
Xclkload4 clkload4/A VGND VGND VPWR VPWR clkload4/X sky130_fd_sc_hd__clkbuf_8
X_7697_ _8760_/CLK _7697_/D fanout697/X VGND VGND VPWR VPWR _7697_/Q sky130_fd_sc_hd__dfrtp_2
X_6717_ _8404_/Q _4714_/A _6723_/S VGND VGND VPWR VPWR _6718_/A sky130_fd_sc_hd__mux2_2
X_6648_ _4925_/X _8373_/Q _6654_/S VGND VGND VPWR VPWR _6649_/A sky130_fd_sc_hd__mux2_2
XFILLER_119_6 VGND VGND VPWR VPWR sky130_fd_sc_hd__decap_3
XTAP_TAPCELL_ROW_59_1117 VGND VPWR sky130_fd_sc_hd__tapvpwrvgnd_1
XFILLER_133_620 VGND VGND VPWR VPWR sky130_fd_sc_hd__decap_3
X_8318_ _8729_/CLK _8318_/D load_slew489/X VGND VGND VPWR VPWR _8318_/Q sky130_fd_sc_hd__dfrtp_2
X_6579_ _4787_/X _8340_/Q _6591_/S VGND VGND VPWR VPWR _6580_/A sky130_fd_sc_hd__mux2_2
XFILLER_132_130 VGND VGND VPWR VPWR sky130_fd_sc_hd__decap_3
XFILLER_133_653 VGND VGND VPWR VPWR sky130_fd_sc_hd__decap_3
XFILLER_1_6 VGND VGND VPWR VPWR sky130_fd_sc_hd__decap_3
XTAP_TAPCELL_ROW_72_1306 VGND VPWR sky130_fd_sc_hd__tapvpwrvgnd_1
XFILLER_105_366 VGND VGND VPWR VPWR sky130_fd_sc_hd__decap_3
XFILLER_132_141 VGND VGND VPWR VPWR sky130_fd_sc_hd__decap_3
XFILLER_59_46 VGND VGND VPWR VPWR sky130_fd_sc_hd__decap_3
XFILLER_79_729 VGND VGND VPWR VPWR sky130_fd_sc_hd__fill_2
X_8249_ _8647_/CLK _8249_/D load_slew541/X VGND VGND VPWR VPWR _8249_/Q sky130_fd_sc_hd__dfrtp_2
XFILLER_120_336 VGND VGND VPWR VPWR sky130_fd_sc_hd__decap_3
XFILLER_132_174 VGND VGND VPWR VPWR sky130_fd_sc_hd__decap_3
XFILLER_133_697 VGND VGND VPWR VPWR sky130_fd_sc_hd__decap_3
XFILLER_78_239 VGND VGND VPWR VPWR sky130_fd_sc_hd__decap_3
XFILLER_115_41 VGND VGND VPWR VPWR sky130_fd_sc_hd__decap_3
XFILLER_115_63 VGND VGND VPWR VPWR sky130_fd_sc_hd__decap_3
XFILLER_101_561 VGND VGND VPWR VPWR sky130_fd_sc_hd__decap_3
XFILLER_19_306 VGND VGND VPWR VPWR sky130_fd_sc_hd__decap_3
XFILLER_74_412 VGND VGND VPWR VPWR sky130_fd_sc_hd__decap_3
XFILLER_86_294 VGND VGND VPWR VPWR sky130_fd_sc_hd__decap_3
XFILLER_131_51 VGND VGND VPWR VPWR sky130_fd_sc_hd__decap_3
XFILLER_15_501 VGND VGND VPWR VPWR sky130_fd_sc_hd__decap_3
XFILLER_27_361 VGND VGND VPWR VPWR sky130_fd_sc_hd__fill_1
XFILLER_61_106 VGND VGND VPWR VPWR sky130_fd_sc_hd__decap_3
XFILLER_131_84 VGND VGND VPWR VPWR sky130_fd_sc_hd__decap_3
XTAP_TAPCELL_ROW_17_529 VGND VPWR sky130_fd_sc_hd__tapvpwrvgnd_1
XFILLER_15_556 VGND VGND VPWR VPWR sky130_fd_sc_hd__decap_3
XFILLER_91_44 VGND VGND VPWR VPWR sky130_fd_sc_hd__decap_3
XFILLER_91_66 VGND VGND VPWR VPWR sky130_fd_sc_hd__decap_3
XTAP_TAPCELL_ROW_83_1457 VGND VPWR sky130_fd_sc_hd__tapvpwrvgnd_1
XFILLER_42_386 VGND VGND VPWR VPWR sky130_fd_sc_hd__decap_3
XFILLER_70_695 VGND VGND VPWR VPWR sky130_fd_sc_hd__fill_1
XFILLER_91_88 VGND VGND VPWR VPWR sky130_fd_sc_hd__decap_3
XFILLER_24_71 VGND VGND VPWR VPWR sky130_fd_sc_hd__decap_3
XFILLER_30_548 VGND VGND VPWR VPWR sky130_fd_sc_hd__decap_3
XFILLER_7_700 VGND VGND VPWR VPWR sky130_fd_sc_hd__decap_3
XFILLER_11_762 VGND VGND VPWR VPWR sky130_fd_sc_hd__decap_3
XFILLER_128_414 VGND VGND VPWR VPWR sky130_fd_sc_hd__decap_3
XFILLER_128_436 VGND VGND VPWR VPWR sky130_fd_sc_hd__decap_3
Xwire631 wire631/A VGND VGND VPWR VPWR wire631/X sky130_fd_sc_hd__clkbuf_4
XFILLER_10_283 VGND VGND VPWR VPWR sky130_fd_sc_hd__decap_3
XFILLER_128_469 VGND VGND VPWR VPWR sky130_fd_sc_hd__decap_3
XFILLER_7_744 VGND VGND VPWR VPWR sky130_fd_sc_hd__decap_3
XFILLER_7_777 VGND VGND VPWR VPWR sky130_fd_sc_hd__decap_3
XFILLER_109_694 VGND VGND VPWR VPWR sky130_fd_sc_hd__decap_3
XFILLER_7_788 VGND VGND VPWR VPWR sky130_fd_sc_hd__decap_3
XFILLER_97_526 VGND VGND VPWR VPWR sky130_fd_sc_hd__decap_3
XFILLER_111_325 VGND VGND VPWR VPWR sky130_fd_sc_hd__fill_2
XFILLER_2_460 VGND VGND VPWR VPWR sky130_fd_sc_hd__decap_3
XFILLER_34_6 VGND VGND VPWR VPWR sky130_fd_sc_hd__decap_3
Xload_slew647 fanout646/X VGND VGND VPWR VPWR load_slew647/X sky130_fd_sc_hd__buf_4
Xload_slew636 fanout635/X VGND VGND VPWR VPWR load_slew636/X sky130_fd_sc_hd__buf_4
XFILLER_38_604 VGND VGND VPWR VPWR sky130_fd_sc_hd__decap_3
XFILLER_37_103 VGND VGND VPWR VPWR sky130_fd_sc_hd__fill_1
XFILLER_38_637 VGND VGND VPWR VPWR sky130_fd_sc_hd__decap_3
XFILLER_1_42 VGND VGND VPWR VPWR sky130_fd_sc_hd__decap_3
XFILLER_65_434 VGND VGND VPWR VPWR sky130_fd_sc_hd__fill_1
XFILLER_93_754 VGND VGND VPWR VPWR sky130_fd_sc_hd__decap_3
XTAP_TAPCELL_ROW_125_2041 VGND VPWR sky130_fd_sc_hd__tapvpwrvgnd_1
XFILLER_18_350 VGND VGND VPWR VPWR sky130_fd_sc_hd__fill_1
XFILLER_1_75 VGND VGND VPWR VPWR sky130_fd_sc_hd__decap_3
XFILLER_25_309 VGND VGND VPWR VPWR sky130_fd_sc_hd__fill_1
XFILLER_37_169 VGND VGND VPWR VPWR sky130_fd_sc_hd__decap_3
XFILLER_92_253 VGND VGND VPWR VPWR sky130_fd_sc_hd__decap_3
XFILLER_93_798 VGND VGND VPWR VPWR sky130_fd_sc_hd__decap_3
X_5950_ _5946_/X _5958_/A2 _4903_/X _5958_/B1 hold841/X VGND VGND VPWR VPWR _8034_/D
+ sky130_fd_sc_hd__a32o_2
XFILLER_52_128 VGND VGND VPWR VPWR sky130_fd_sc_hd__decap_3
X_4901_ _4901_/A VGND VGND VPWR VPWR _7547_/D sky130_fd_sc_hd__buf_1
X_7620_ _8764_/CLK _7620_/D load_slew563/X VGND VGND VPWR VPWR _7620_/Q sky130_fd_sc_hd__dfrtp_2
X_5881_ _5946_/A VGND VGND VPWR VPWR _5881_/X sky130_fd_sc_hd__clkbuf_1
X_4832_ _4832_/A _4852_/B VGND VGND VPWR VPWR _4833_/A sky130_fd_sc_hd__and2_2
X_7551_ _8699_/CLK _7551_/D load_slew733/X VGND VGND VPWR VPWR _7551_/Q sky130_fd_sc_hd__dfrtp_2
X_4763_ _4763_/A VGND VGND VPWR VPWR _7514_/D sky130_fd_sc_hd__buf_1
X_3714_ _5962_/C _5962_/D VGND VGND VPWR VPWR _8051_/D sky130_fd_sc_hd__nor2_2
X_7482_ _7482_/A VGND VGND VPWR VPWR _8796_/D sky130_fd_sc_hd__buf_1
X_6502_ _6502_/A VGND VGND VPWR VPWR _8303_/D sky130_fd_sc_hd__buf_2
X_4694_ _8051_/Q _7282_/B VGND VGND VPWR VPWR _6141_/B sky130_fd_sc_hd__nor2_2
XFILLER_119_458 VGND VGND VPWR VPWR sky130_fd_sc_hd__fill_1
X_6433_ _6433_/A VGND VGND VPWR VPWR _8271_/D sky130_fd_sc_hd__buf_2
XFILLER_134_439 VGND VGND VPWR VPWR sky130_fd_sc_hd__decap_3
XFILLER_20_18 VGND VGND VPWR VPWR sky130_fd_sc_hd__decap_3
XFILLER_20_29 VGND VGND VPWR VPWR sky130_fd_sc_hd__decap_3
XFILLER_127_491 VGND VGND VPWR VPWR sky130_fd_sc_hd__decap_3
X_6364_ _6364_/A VGND VGND VPWR VPWR _8238_/D sky130_fd_sc_hd__buf_2
XFILLER_102_303 VGND VGND VPWR VPWR sky130_fd_sc_hd__fill_1
XFILLER_114_141 VGND VGND VPWR VPWR sky130_fd_sc_hd__decap_3
XFILLER_114_163 VGND VGND VPWR VPWR sky130_fd_sc_hd__decap_3
XFILLER_130_601 VGND VGND VPWR VPWR sky130_fd_sc_hd__decap_3
X_8103_ _8427_/CLK _8103_/D wire631/X VGND VGND VPWR VPWR _8103_/Q sky130_fd_sc_hd__dfrtp_2
X_6295_ _6295_/A VGND VGND VPWR VPWR _8206_/D sky130_fd_sc_hd__buf_6
X_5315_ _7710_/Q _4903_/X _5331_/S VGND VGND VPWR VPWR _5316_/A sky130_fd_sc_hd__mux2_2
XFILLER_130_634 VGND VGND VPWR VPWR sky130_fd_sc_hd__decap_3
XFILLER_130_645 VGND VGND VPWR VPWR sky130_fd_sc_hd__decap_3
XTAP_TAPCELL_ROW_54_1047 VGND VPWR sky130_fd_sc_hd__tapvpwrvgnd_1
X_8034_ _8530_/CLK _8034_/D fanout739/X VGND VGND VPWR VPWR _8034_/Q sky130_fd_sc_hd__dfrtp_2
X_5246_ _5246_/A VGND VGND VPWR VPWR _7677_/D sky130_fd_sc_hd__buf_1
XFILLER_130_678 VGND VGND VPWR VPWR sky130_fd_sc_hd__decap_3
XPHY_EDGE_ROW_89_Right_89 VGND VGND VPWR VPWR sky130_fd_sc_hd__decap_3
X_5177_ _5177_/A VGND VGND VPWR VPWR _7644_/D sky130_fd_sc_hd__buf_1
XFILLER_28_147 VGND VGND VPWR VPWR sky130_fd_sc_hd__decap_3
X_4128_ _8085_/Q _8166_/Q _8247_/Q _8328_/Q _4166_/S0 _4166_/S1 VGND VGND VPWR VPWR
+ _4129_/B sky130_fd_sc_hd__mux4_2
X_4059_ _4092_/S _4056_/X _4058_/X _3976_/X VGND VGND VPWR VPWR _4059_/X sky130_fd_sc_hd__o211a_2
XFILLER_101_54 VGND VGND VPWR VPWR sky130_fd_sc_hd__fill_2
XPHY_EDGE_ROW_98_Right_98 VGND VGND VPWR VPWR sky130_fd_sc_hd__decap_3
XTAP_TAPCELL_ROW_65_1198 VGND VPWR sky130_fd_sc_hd__tapvpwrvgnd_1
X_8798_ _8798_/CLK _8798_/D wire600/X VGND VGND VPWR VPWR _8798_/Q sky130_fd_sc_hd__dfrtp_2
X_7818_ _8800_/CLK _7818_/D load_slew593/X VGND VGND VPWR VPWR _7818_/Q sky130_fd_sc_hd__dfrtp_2
XFILLER_12_548 VGND VGND VPWR VPWR sky130_fd_sc_hd__decap_3
XFILLER_51_194 VGND VGND VPWR VPWR sky130_fd_sc_hd__decap_3
XFILLER_61_47 VGND VGND VPWR VPWR sky130_fd_sc_hd__decap_3
X_7749_ _8724_/CLK _7749_/D load_slew503/X VGND VGND VPWR VPWR _7749_/Q sky130_fd_sc_hd__dfrtp_2
XTAP_TAPCELL_ROW_22_598 VGND VPWR sky130_fd_sc_hd__tapvpwrvgnd_1
XFILLER_117_3 VGND VGND VPWR VPWR sky130_fd_sc_hd__decap_3
XFILLER_4_725 VGND VGND VPWR VPWR sky130_fd_sc_hd__decap_3
XFILLER_106_620 VGND VGND VPWR VPWR sky130_fd_sc_hd__decap_3
XFILLER_118_480 VGND VGND VPWR VPWR sky130_fd_sc_hd__fill_1
XFILLER_10_62 VGND VGND VPWR VPWR sky130_fd_sc_hd__decap_3
XFILLER_133_461 VGND VGND VPWR VPWR sky130_fd_sc_hd__decap_3
XFILLER_4_769 VGND VGND VPWR VPWR sky130_fd_sc_hd__decap_3
XFILLER_106_697 VGND VGND VPWR VPWR sky130_fd_sc_hd__decap_3
XFILLER_120_100 VGND VGND VPWR VPWR sky130_fd_sc_hd__decap_3
XFILLER_126_62 VGND VGND VPWR VPWR sky130_fd_sc_hd__decap_3
XFILLER_133_494 VGND VGND VPWR VPWR sky130_fd_sc_hd__decap_3
XFILLER_79_548 VGND VGND VPWR VPWR sky130_fd_sc_hd__decap_3
XFILLER_86_22 VGND VGND VPWR VPWR sky130_fd_sc_hd__decap_3
XFILLER_120_144 VGND VGND VPWR VPWR sky130_fd_sc_hd__decap_3
XFILLER_86_44 VGND VGND VPWR VPWR sky130_fd_sc_hd__decap_3
XFILLER_47_401 VGND VGND VPWR VPWR sky130_fd_sc_hd__decap_3
XFILLER_59_272 VGND VGND VPWR VPWR sky130_fd_sc_hd__decap_3
XFILLER_19_136 VGND VGND VPWR VPWR sky130_fd_sc_hd__decap_3
XFILLER_19_60 VGND VGND VPWR VPWR sky130_fd_sc_hd__decap_3
XFILLER_59_294 VGND VGND VPWR VPWR sky130_fd_sc_hd__decap_3
XFILLER_19_169 VGND VGND VPWR VPWR sky130_fd_sc_hd__decap_3
XFILLER_62_404 VGND VGND VPWR VPWR sky130_fd_sc_hd__fill_2
XFILLER_74_253 VGND VGND VPWR VPWR sky130_fd_sc_hd__decap_3
XFILLER_90_757 VGND VGND VPWR VPWR sky130_fd_sc_hd__fill_1
XFILLER_43_651 VGND VGND VPWR VPWR sky130_fd_sc_hd__decap_3
XFILLER_90_779 VGND VGND VPWR VPWR sky130_fd_sc_hd__fill_1
XFILLER_35_81 VGND VGND VPWR VPWR sky130_fd_sc_hd__decap_3
XFILLER_42_150 VGND VGND VPWR VPWR sky130_fd_sc_hd__fill_2
XFILLER_42_161 VGND VGND VPWR VPWR sky130_fd_sc_hd__decap_3
XFILLER_43_673 VGND VGND VPWR VPWR sky130_fd_sc_hd__decap_3
XFILLER_70_470 VGND VGND VPWR VPWR sky130_fd_sc_hd__decap_3
XFILLER_129_712 VGND VGND VPWR VPWR sky130_fd_sc_hd__decap_3
XFILLER_70_492 VGND VGND VPWR VPWR sky130_fd_sc_hd__decap_3
XFILLER_128_200 VGND VGND VPWR VPWR sky130_fd_sc_hd__decap_3
XTAP_TAPCELL_ROW_41_863 VGND VPWR sky130_fd_sc_hd__tapvpwrvgnd_1
XFILLER_11_581 VGND VGND VPWR VPWR sky130_fd_sc_hd__fill_2
XFILLER_11_592 VGND VGND VPWR VPWR sky130_fd_sc_hd__decap_3
XFILLER_128_233 VGND VGND VPWR VPWR sky130_fd_sc_hd__decap_3
XFILLER_129_756 VGND VGND VPWR VPWR sky130_fd_sc_hd__decap_3
Xwire450 _3747_/S VGND VGND VPWR VPWR _3824_/S sky130_fd_sc_hd__clkbuf_4
XFILLER_116_406 VGND VGND VPWR VPWR sky130_fd_sc_hd__decap_3
XTAP_TAPCELL_ROW_96_1637 VGND VPWR sky130_fd_sc_hd__tapvpwrvgnd_1
Xmax_cap216 _5868_/X VGND VGND VPWR VPWR _5880_/A1 sky130_fd_sc_hd__buf_2
XFILLER_7_596 VGND VGND VPWR VPWR sky130_fd_sc_hd__decap_3
Xmax_cap249 _3806_/X VGND VGND VPWR VPWR _4350_/A2 sky130_fd_sc_hd__buf_6
Xmax_cap238 _5970_/B VGND VGND VPWR VPWR _4951_/A sky130_fd_sc_hd__buf_2
Xmax_cap227 _3820_/X VGND VGND VPWR VPWR _4605_/A1 sky130_fd_sc_hd__clkbuf_8
XFILLER_124_461 VGND VGND VPWR VPWR sky130_fd_sc_hd__fill_1
XFILLER_124_483 VGND VGND VPWR VPWR sky130_fd_sc_hd__fill_2
XFILLER_32_3 VGND VGND VPWR VPWR sky130_fd_sc_hd__decap_3
XFILLER_3_780 VGND VGND VPWR VPWR sky130_fd_sc_hd__decap_3
XFILLER_3_791 VGND VGND VPWR VPWR sky130_fd_sc_hd__decap_3
Xload_slew411 _4100_/S VGND VGND VPWR VPWR _4150_/S sky130_fd_sc_hd__clkbuf_2
Xload_slew400 _4106_/S0 VGND VGND VPWR VPWR _4091_/S0 sky130_fd_sc_hd__clkbuf_4
X_6080_ _6080_/A VGND VGND VPWR VPWR _8105_/D sky130_fd_sc_hd__buf_1
X_5100_ _4819_/X _7609_/Q _5116_/S VGND VGND VPWR VPWR _5101_/A sky130_fd_sc_hd__mux2_2
XPHY_EDGE_ROW_29_Left_165 VGND VGND VPWR VPWR sky130_fd_sc_hd__decap_3
Xload_slew444 fanout443/X VGND VGND VPWR VPWR _4680_/S sky130_fd_sc_hd__buf_4
X_5031_ _5031_/A VGND VGND VPWR VPWR _5031_/X sky130_fd_sc_hd__buf_1
XFILLER_38_401 VGND VGND VPWR VPWR sky130_fd_sc_hd__fill_1
XFILLER_66_710 VGND VGND VPWR VPWR sky130_fd_sc_hd__decap_3
XFILLER_85_529 VGND VGND VPWR VPWR sky130_fd_sc_hd__decap_3
Xload_slew499 fanout498/X VGND VGND VPWR VPWR load_slew499/X sky130_fd_sc_hd__buf_4
XFILLER_66_743 VGND VGND VPWR VPWR sky130_fd_sc_hd__decap_3
XTAP_TAPCELL_ROW_49_974 VGND VPWR sky130_fd_sc_hd__tapvpwrvgnd_1
XTAP_TAPCELL_ROW_49_985 VGND VPWR sky130_fd_sc_hd__tapvpwrvgnd_1
XFILLER_19_670 VGND VGND VPWR VPWR sky130_fd_sc_hd__fill_2
X_8721_ _8721_/CLK _8721_/D fanout586/X VGND VGND VPWR VPWR _8721_/Q sky130_fd_sc_hd__dfrtp_2
X_6982_ _4899_/X _8529_/Q _7000_/S VGND VGND VPWR VPWR _6983_/A sky130_fd_sc_hd__mux2_4
XFILLER_15_18 VGND VGND VPWR VPWR sky130_fd_sc_hd__decap_3
XFILLER_18_191 VGND VGND VPWR VPWR sky130_fd_sc_hd__decap_3
XFILLER_34_640 VGND VGND VPWR VPWR sky130_fd_sc_hd__decap_3
XFILLER_34_651 VGND VGND VPWR VPWR sky130_fd_sc_hd__fill_1
XFILLER_53_459 VGND VGND VPWR VPWR sky130_fd_sc_hd__decap_3
XFILLER_80_256 VGND VGND VPWR VPWR sky130_fd_sc_hd__decap_3
XTAP_TAPCELL_ROW_105_1766 VGND VPWR sky130_fd_sc_hd__tapvpwrvgnd_1
X_5933_ _5946_/A VGND VGND VPWR VPWR _5933_/X sky130_fd_sc_hd__clkbuf_1
XFILLER_21_301 VGND VGND VPWR VPWR sky130_fd_sc_hd__decap_3
XFILLER_80_278 VGND VGND VPWR VPWR sky130_fd_sc_hd__decap_3
X_8652_ _8655_/CLK _8652_/D load_slew484/X VGND VGND VPWR VPWR _8652_/Q sky130_fd_sc_hd__dfrtp_2
X_5864_ _5852_/X _5853_/X _4973_/X _5865_/B1 hold821/X VGND VGND VPWR VPWR _7969_/D
+ sky130_fd_sc_hd__a32o_2
XFILLER_21_323 VGND VGND VPWR VPWR sky130_fd_sc_hd__decap_3
XFILLER_33_183 VGND VGND VPWR VPWR sky130_fd_sc_hd__decap_3
XPHY_EDGE_ROW_38_Left_174 VGND VGND VPWR VPWR sky130_fd_sc_hd__decap_3
X_8583_ _8583_/CLK _8583_/D fanout622/X VGND VGND VPWR VPWR _8583_/Q sky130_fd_sc_hd__dfrtp_2
X_7603_ _8701_/CLK _7603_/D load_slew647/X VGND VGND VPWR VPWR _7603_/Q sky130_fd_sc_hd__dfrtp_2
X_4815_ _4815_/A VGND VGND VPWR VPWR _4815_/X sky130_fd_sc_hd__buf_1
XFILLER_21_378 VGND VGND VPWR VPWR sky130_fd_sc_hd__decap_3
X_7534_ _8759_/CLK _7534_/D load_slew704/X VGND VGND VPWR VPWR _7534_/Q sky130_fd_sc_hd__dfrtp_2
X_5795_ _7936_/Q _4833_/A _5805_/S VGND VGND VPWR VPWR _5796_/A sky130_fd_sc_hd__mux2_2
XFILLER_119_222 VGND VGND VPWR VPWR sky130_fd_sc_hd__fill_2
XFILLER_135_704 VGND VGND VPWR VPWR sky130_fd_sc_hd__decap_3
X_4746_ _4745_/X hold991/X _4778_/S VGND VGND VPWR VPWR _4747_/A sky130_fd_sc_hd__mux2_2
XFILLER_107_417 VGND VGND VPWR VPWR sky130_fd_sc_hd__fill_1
XFILLER_134_203 VGND VGND VPWR VPWR sky130_fd_sc_hd__decap_3
X_7465_ _7465_/A VGND VGND VPWR VPWR _8788_/D sky130_fd_sc_hd__buf_1
X_4677_ _7719_/Q _3939_/X _3916_/B _7638_/Q _4677_/C1 VGND VGND VPWR VPWR _4677_/X
+ sky130_fd_sc_hd__o221a_2
XFILLER_107_439 VGND VGND VPWR VPWR sky130_fd_sc_hd__fill_1
XFILLER_134_247 VGND VGND VPWR VPWR sky130_fd_sc_hd__decap_3
X_7396_ _7396_/A VGND VGND VPWR VPWR _8755_/D sky130_fd_sc_hd__buf_1
X_6416_ _6416_/A VGND VGND VPWR VPWR _8263_/D sky130_fd_sc_hd__buf_2
XFILLER_1_706 VGND VGND VPWR VPWR sky130_fd_sc_hd__decap_3
X_6347_ _6347_/A VGND VGND VPWR VPWR _8230_/D sky130_fd_sc_hd__buf_2
XFILLER_88_312 VGND VGND VPWR VPWR sky130_fd_sc_hd__decap_3
XPHY_EDGE_ROW_47_Left_183 VGND VGND VPWR VPWR sky130_fd_sc_hd__decap_3
XFILLER_102_133 VGND VGND VPWR VPWR sky130_fd_sc_hd__fill_1
XFILLER_102_144 VGND VGND VPWR VPWR sky130_fd_sc_hd__fill_1
XFILLER_130_442 VGND VGND VPWR VPWR sky130_fd_sc_hd__decap_3
X_6278_ _6278_/A VGND VGND VPWR VPWR _8198_/D sky130_fd_sc_hd__buf_6
XFILLER_130_475 VGND VGND VPWR VPWR sky130_fd_sc_hd__fill_1
XFILLER_130_486 VGND VGND VPWR VPWR sky130_fd_sc_hd__decap_3
XFILLER_48_209 VGND VGND VPWR VPWR sky130_fd_sc_hd__decap_3
XFILLER_69_570 VGND VGND VPWR VPWR sky130_fd_sc_hd__fill_2
XFILLER_76_529 VGND VGND VPWR VPWR sky130_fd_sc_hd__decap_3
X_8017_ _8676_/CLK _8017_/D load_slew699/X VGND VGND VPWR VPWR _8017_/Q sky130_fd_sc_hd__dfrtp_2
X_5229_ hold983/X _4731_/X _5247_/S VGND VGND VPWR VPWR _5230_/A sky130_fd_sc_hd__mux2_2
XFILLER_56_220 VGND VGND VPWR VPWR sky130_fd_sc_hd__decap_3
XFILLER_56_47 VGND VGND VPWR VPWR sky130_fd_sc_hd__decap_3
XFILLER_56_242 VGND VGND VPWR VPWR sky130_fd_sc_hd__decap_3
XFILLER_57_765 VGND VGND VPWR VPWR sky130_fd_sc_hd__fill_1
XFILLER_16_139 VGND VGND VPWR VPWR sky130_fd_sc_hd__fill_1
XFILLER_84_595 VGND VGND VPWR VPWR sky130_fd_sc_hd__fill_1
XTAP_TAPCELL_ROW_67_1227 VGND VPWR sky130_fd_sc_hd__tapvpwrvgnd_1
XFILLER_112_53 VGND VGND VPWR VPWR sky130_fd_sc_hd__decap_3
XFILLER_44_459 VGND VGND VPWR VPWR sky130_fd_sc_hd__fill_2
XFILLER_71_245 VGND VGND VPWR VPWR sky130_fd_sc_hd__decap_3
XFILLER_71_267 VGND VGND VPWR VPWR sky130_fd_sc_hd__decap_3
XTAP_TAPCELL_ROW_27_668 VGND VPWR sky130_fd_sc_hd__tapvpwrvgnd_1
XFILLER_25_673 VGND VGND VPWR VPWR sky130_fd_sc_hd__decap_3
XFILLER_25_695 VGND VGND VPWR VPWR sky130_fd_sc_hd__decap_3
XPHY_EDGE_ROW_56_Left_192 VGND VGND VPWR VPWR sky130_fd_sc_hd__decap_3
XTAP_TAPCELL_ROW_80_1416 VGND VPWR sky130_fd_sc_hd__tapvpwrvgnd_1
XFILLER_24_183 VGND VGND VPWR VPWR sky130_fd_sc_hd__fill_1
XFILLER_40_687 VGND VGND VPWR VPWR sky130_fd_sc_hd__decap_3
XPHY_EDGE_ROW_117_Right_117 VGND VGND VPWR VPWR sky130_fd_sc_hd__decap_3
XFILLER_12_389 VGND VGND VPWR VPWR sky130_fd_sc_hd__decap_3
XFILLER_126_726 VGND VGND VPWR VPWR sky130_fd_sc_hd__decap_3
XFILLER_125_225 VGND VGND VPWR VPWR sky130_fd_sc_hd__decap_3
XFILLER_21_72 VGND VGND VPWR VPWR sky130_fd_sc_hd__decap_3
XTAP_TAPCELL_ROW_78_1378 VGND VPWR sky130_fd_sc_hd__tapvpwrvgnd_1
XTAP_TAPCELL_ROW_78_1389 VGND VPWR sky130_fd_sc_hd__tapvpwrvgnd_1
XFILLER_106_483 VGND VGND VPWR VPWR sky130_fd_sc_hd__fill_2
XFILLER_121_420 VGND VGND VPWR VPWR sky130_fd_sc_hd__decap_3
XFILLER_134_781 VGND VGND VPWR VPWR sky130_fd_sc_hd__decap_3
XFILLER_79_312 VGND VGND VPWR VPWR sky130_fd_sc_hd__decap_3
XFILLER_0_750 VGND VGND VPWR VPWR sky130_fd_sc_hd__decap_3
XFILLER_121_442 VGND VGND VPWR VPWR sky130_fd_sc_hd__decap_3
XFILLER_79_334 VGND VGND VPWR VPWR sky130_fd_sc_hd__fill_2
XFILLER_79_367 VGND VGND VPWR VPWR sky130_fd_sc_hd__decap_3
XTAP_TAPCELL_ROW_91_1567 VGND VPWR sky130_fd_sc_hd__tapvpwrvgnd_1
XFILLER_0_772 VGND VGND VPWR VPWR sky130_fd_sc_hd__decap_3
XFILLER_121_475 VGND VGND VPWR VPWR sky130_fd_sc_hd__decap_3
XTAP_TAPCELL_ROW_7_393 VGND VPWR sky130_fd_sc_hd__tapvpwrvgnd_1
XFILLER_0_794 VGND VGND VPWR VPWR sky130_fd_sc_hd__decap_3
XFILLER_47_253 VGND VGND VPWR VPWR sky130_fd_sc_hd__fill_2
XFILLER_75_551 VGND VGND VPWR VPWR sky130_fd_sc_hd__decap_3
XTAP_TAPCELL_ROW_122_2000 VGND VPWR sky130_fd_sc_hd__tapvpwrvgnd_1
XFILLER_35_426 VGND VGND VPWR VPWR sky130_fd_sc_hd__fill_2
XFILLER_35_437 VGND VGND VPWR VPWR sky130_fd_sc_hd__fill_2
XFILLER_47_275 VGND VGND VPWR VPWR sky130_fd_sc_hd__decap_3
XTAP_TAPCELL_ROW_46_933 VGND VPWR sky130_fd_sc_hd__tapvpwrvgnd_1
XFILLER_90_565 VGND VGND VPWR VPWR sky130_fd_sc_hd__decap_3
XFILLER_90_598 VGND VGND VPWR VPWR sky130_fd_sc_hd__decap_3
XFILLER_15_183 VGND VGND VPWR VPWR sky130_fd_sc_hd__fill_1
XFILLER_43_481 VGND VGND VPWR VPWR sky130_fd_sc_hd__fill_1
XFILLER_129_520 VGND VGND VPWR VPWR sky130_fd_sc_hd__decap_3
XFILLER_31_676 VGND VGND VPWR VPWR sky130_fd_sc_hd__fill_2
X_4600_ _8613_/Q _4600_/A2 _4599_/X _4633_/A wire326/X VGND VGND VPWR VPWR _4600_/X
+ sky130_fd_sc_hd__o221a_2
XFILLER_129_553 VGND VGND VPWR VPWR sky130_fd_sc_hd__decap_3
XFILLER_30_175 VGND VGND VPWR VPWR sky130_fd_sc_hd__fill_2
XFILLER_30_197 VGND VGND VPWR VPWR sky130_fd_sc_hd__decap_3
XFILLER_7_30 VGND VGND VPWR VPWR sky130_fd_sc_hd__decap_3
XTAP_TAPCELL_ROW_100_1696 VGND VPWR sky130_fd_sc_hd__tapvpwrvgnd_1
X_5580_ _5580_/A VGND VGND VPWR VPWR _7834_/D sky130_fd_sc_hd__buf_1
XFILLER_129_564 VGND VGND VPWR VPWR sky130_fd_sc_hd__decap_3
XFILLER_7_63 VGND VGND VPWR VPWR sky130_fd_sc_hd__decap_3
X_4531_ _7787_/Q _7868_/Q _7949_/Q _8030_/Q _4528_/S _4531_/S1 VGND VGND VPWR VPWR
+ _4531_/X sky130_fd_sc_hd__mux4_2
XFILLER_116_236 VGND VGND VPWR VPWR sky130_fd_sc_hd__decap_3
XFILLER_129_597 VGND VGND VPWR VPWR sky130_fd_sc_hd__decap_3
XFILLER_7_393 VGND VGND VPWR VPWR sky130_fd_sc_hd__decap_3
XTAP_TAPCELL_ROW_133_2151 VGND VPWR sky130_fd_sc_hd__tapvpwrvgnd_1
Xwire280 wire280/A VGND VGND VPWR VPWR _4030_/S sky130_fd_sc_hd__clkbuf_4
X_7250_ _7253_/A1 _4837_/X _7255_/A3 _7255_/B1 hold906/X VGND VGND VPWR VPWR _8676_/D
+ sky130_fd_sc_hd__a32o_2
X_4462_ _4462_/A _4462_/B VGND VGND VPWR VPWR _4462_/X sky130_fd_sc_hd__or2_2
XFILLER_116_247 VGND VGND VPWR VPWR sky130_fd_sc_hd__decap_3
XFILLER_132_707 VGND VGND VPWR VPWR sky130_fd_sc_hd__decap_3
X_6201_ _7063_/A0 _8162_/Q _6205_/S VGND VGND VPWR VPWR _6202_/A sky130_fd_sc_hd__mux2_4
XFILLER_131_217 VGND VGND VPWR VPWR sky130_fd_sc_hd__decap_3
XFILLER_131_228 VGND VGND VPWR VPWR sky130_fd_sc_hd__decap_3
X_7181_ _7188_/A1 _4953_/X _7176_/X _7179_/X hold904/X VGND VGND VPWR VPWR _8622_/D
+ sky130_fd_sc_hd__a32o_2
X_4393_ _4393_/A _4393_/B VGND VGND VPWR VPWR _4393_/X sky130_fd_sc_hd__or2_2
XFILLER_98_654 VGND VGND VPWR VPWR sky130_fd_sc_hd__decap_3
XTAP_TAPCELL_ROW_51_1006 VGND VPWR sky130_fd_sc_hd__tapvpwrvgnd_1
X_6132_ _6132_/A VGND VGND VPWR VPWR _8130_/D sky130_fd_sc_hd__buf_1
XFILLER_97_175 VGND VGND VPWR VPWR sky130_fd_sc_hd__fill_1
Xhold1005 _7524_/Q VGND VGND VPWR VPWR _4804_/A1 sky130_fd_sc_hd__dlygate4sd3_1
X_6063_ _6063_/A VGND VGND VPWR VPWR _8097_/D sky130_fd_sc_hd__buf_1
XFILLER_39_732 VGND VGND VPWR VPWR sky130_fd_sc_hd__fill_1
XFILLER_39_754 VGND VGND VPWR VPWR sky130_fd_sc_hd__decap_3
Xhold1016 _7623_/Q VGND VGND VPWR VPWR _5129_/A1 sky130_fd_sc_hd__dlygate4sd3_1
Xhold1027 _7835_/Q VGND VGND VPWR VPWR _5581_/A0 sky130_fd_sc_hd__dlygate4sd3_1
Xhold1038 _7939_/Q VGND VGND VPWR VPWR _5801_/A0 sky130_fd_sc_hd__dlygate4sd3_1
Xhold1049 _8091_/Q VGND VGND VPWR VPWR _6049_/A0 sky130_fd_sc_hd__dlygate4sd3_1
Xload_slew285 _3707_/B VGND VGND VPWR VPWR _4462_/A sky130_fd_sc_hd__buf_4
Xload_slew296 _4364_/C1 VGND VGND VPWR VPWR _4458_/B2 sky130_fd_sc_hd__buf_4
X_5014_ _5014_/A _5026_/B VGND VGND VPWR VPWR _5015_/A sky130_fd_sc_hd__and2_2
XFILLER_38_253 VGND VGND VPWR VPWR sky130_fd_sc_hd__decap_3
XFILLER_26_415 VGND VGND VPWR VPWR sky130_fd_sc_hd__fill_2
XFILLER_53_223 VGND VGND VPWR VPWR sky130_fd_sc_hd__fill_1
XFILLER_54_735 VGND VGND VPWR VPWR sky130_fd_sc_hd__decap_3
XFILLER_54_757 VGND VGND VPWR VPWR sky130_fd_sc_hd__decap_3
X_6965_ _4866_/X _8521_/Q _6979_/S VGND VGND VPWR VPWR _6966_/A sky130_fd_sc_hd__mux2_4
XTAP_TAPCELL_ROW_24_627 VGND VPWR sky130_fd_sc_hd__tapvpwrvgnd_1
X_8704_ _8785_/CLK _8704_/D fanout684/X VGND VGND VPWR VPWR _8704_/Q sky130_fd_sc_hd__dfrtp_2
X_5916_ _5907_/X _5908_/X _4799_/X _5909_/X hold888/X VGND VGND VPWR VPWR _8009_/D
+ sky130_fd_sc_hd__a32o_2
X_8635_ _8800_/CLK _8635_/D load_slew593/X VGND VGND VPWR VPWR _8635_/Q sky130_fd_sc_hd__dfrtp_2
X_6896_ _6896_/A VGND VGND VPWR VPWR _8488_/D sky130_fd_sc_hd__buf_6
XFILLER_42_49 VGND VGND VPWR VPWR sky130_fd_sc_hd__decap_3
XTAP_TAPCELL_ROW_62_1157 VGND VPWR sky130_fd_sc_hd__tapvpwrvgnd_1
X_5847_ _7961_/Q _4937_/A _5847_/S VGND VGND VPWR VPWR _5848_/A sky130_fd_sc_hd__mux2_2
XFILLER_22_698 VGND VGND VPWR VPWR sky130_fd_sc_hd__fill_2
X_8566_ _8647_/CLK _8566_/D fanout534/X VGND VGND VPWR VPWR _8566_/Q sky130_fd_sc_hd__dfrtp_2
X_5778_ _7928_/Q _4799_/A _5784_/S VGND VGND VPWR VPWR _5779_/A sky130_fd_sc_hd__mux2_2
XFILLER_135_501 VGND VGND VPWR VPWR sky130_fd_sc_hd__decap_3
XTAP_TAPCELL_ROW_118_1946 VGND VPWR sky130_fd_sc_hd__tapvpwrvgnd_1
X_8497_ _8735_/CLK _8497_/D load_slew536/X VGND VGND VPWR VPWR _8497_/Q sky130_fd_sc_hd__dfrtp_2
X_7517_ _8742_/CLK _7517_/D load_slew521/X VGND VGND VPWR VPWR _7517_/Q sky130_fd_sc_hd__dfrtp_2
X_4729_ _4729_/A VGND VGND VPWR VPWR _7506_/D sky130_fd_sc_hd__buf_1
XFILLER_107_225 VGND VGND VPWR VPWR sky130_fd_sc_hd__fill_2
XFILLER_135_523 VGND VGND VPWR VPWR sky130_fd_sc_hd__decap_3
XFILLER_135_545 VGND VGND VPWR VPWR sky130_fd_sc_hd__decap_3
X_7448_ _7448_/A VGND VGND VPWR VPWR _8780_/D sky130_fd_sc_hd__buf_1
XFILLER_123_729 VGND VGND VPWR VPWR sky130_fd_sc_hd__decap_3
XFILLER_135_567 VGND VGND VPWR VPWR sky130_fd_sc_hd__decap_3
XFILLER_135_589 VGND VGND VPWR VPWR sky130_fd_sc_hd__decap_3
XFILLER_122_217 VGND VGND VPWR VPWR sky130_fd_sc_hd__decap_3
Xhold850 _8677_/Q VGND VGND VPWR VPWR hold850/X sky130_fd_sc_hd__dlygate4sd3_1
Xhold861 _7998_/Q VGND VGND VPWR VPWR hold861/X sky130_fd_sc_hd__dlygate4sd3_1
Xhold872 _8647_/Q VGND VGND VPWR VPWR hold872/X sky130_fd_sc_hd__dlygate4sd3_1
X_7379_ _7379_/A VGND VGND VPWR VPWR _8747_/D sky130_fd_sc_hd__buf_1
XFILLER_103_420 VGND VGND VPWR VPWR sky130_fd_sc_hd__decap_3
XFILLER_1_558 VGND VGND VPWR VPWR sky130_fd_sc_hd__fill_2
Xhold883 _8011_/Q VGND VGND VPWR VPWR hold883/X sky130_fd_sc_hd__dlygate4sd3_1
Xhold894 _8634_/Q VGND VGND VPWR VPWR hold894/X sky130_fd_sc_hd__dlygate4sd3_1
XFILLER_131_762 VGND VGND VPWR VPWR sky130_fd_sc_hd__decap_3
XFILLER_67_57 VGND VGND VPWR VPWR sky130_fd_sc_hd__decap_3
XFILLER_89_676 VGND VGND VPWR VPWR sky130_fd_sc_hd__fill_1
XFILLER_103_497 VGND VGND VPWR VPWR sky130_fd_sc_hd__decap_3
XFILLER_88_197 VGND VGND VPWR VPWR sky130_fd_sc_hd__decap_3
XFILLER_123_52 VGND VGND VPWR VPWR sky130_fd_sc_hd__decap_3
XFILLER_45_702 VGND VGND VPWR VPWR sky130_fd_sc_hd__decap_3
XTAP_TAPCELL_ROW_4_352 VGND VPWR sky130_fd_sc_hd__tapvpwrvgnd_1
XFILLER_29_275 VGND VGND VPWR VPWR sky130_fd_sc_hd__decap_3
XFILLER_44_212 VGND VGND VPWR VPWR sky130_fd_sc_hd__decap_3
XFILLER_123_96 VGND VGND VPWR VPWR sky130_fd_sc_hd__decap_3
XFILLER_83_78 VGND VGND VPWR VPWR sky130_fd_sc_hd__fill_1
XPHY_EDGE_ROW_64_Left_200 VGND VGND VPWR VPWR sky130_fd_sc_hd__decap_3
XFILLER_16_50 VGND VGND VPWR VPWR sky130_fd_sc_hd__decap_3
XFILLER_32_429 VGND VGND VPWR VPWR sky130_fd_sc_hd__decap_3
XFILLER_16_83 VGND VGND VPWR VPWR sky130_fd_sc_hd__fill_1
XFILLER_13_676 VGND VGND VPWR VPWR sky130_fd_sc_hd__decap_3
XFILLER_40_440 VGND VGND VPWR VPWR sky130_fd_sc_hd__decap_3
XFILLER_9_603 VGND VGND VPWR VPWR sky130_fd_sc_hd__decap_3
XFILLER_40_473 VGND VGND VPWR VPWR sky130_fd_sc_hd__decap_3
XFILLER_9_647 VGND VGND VPWR VPWR sky130_fd_sc_hd__decap_3
XFILLER_12_197 VGND VGND VPWR VPWR sky130_fd_sc_hd__decap_3
XFILLER_8_157 VGND VGND VPWR VPWR sky130_fd_sc_hd__decap_3
XFILLER_126_523 VGND VGND VPWR VPWR sky130_fd_sc_hd__decap_3
XFILLER_4_330 VGND VGND VPWR VPWR sky130_fd_sc_hd__fill_1
XFILLER_107_781 VGND VGND VPWR VPWR sky130_fd_sc_hd__decap_3
XFILLER_113_228 VGND VGND VPWR VPWR sky130_fd_sc_hd__decap_3
XFILLER_126_589 VGND VGND VPWR VPWR sky130_fd_sc_hd__decap_3
XFILLER_4_363 VGND VGND VPWR VPWR sky130_fd_sc_hd__fill_1
XFILLER_4_374 VGND VGND VPWR VPWR sky130_fd_sc_hd__decap_3
XFILLER_99_429 VGND VGND VPWR VPWR sky130_fd_sc_hd__decap_3
XFILLER_121_272 VGND VGND VPWR VPWR sky130_fd_sc_hd__decap_3
XFILLER_67_337 VGND VGND VPWR VPWR sky130_fd_sc_hd__fill_1
XFILLER_94_112 VGND VGND VPWR VPWR sky130_fd_sc_hd__decap_3
XFILLER_95_657 VGND VGND VPWR VPWR sky130_fd_sc_hd__decap_3
XFILLER_36_724 VGND VGND VPWR VPWR sky130_fd_sc_hd__decap_3
XFILLER_75_370 VGND VGND VPWR VPWR sky130_fd_sc_hd__decap_3
XFILLER_35_234 VGND VGND VPWR VPWR sky130_fd_sc_hd__decap_3
XFILLER_35_256 VGND VGND VPWR VPWR sky130_fd_sc_hd__decap_3
XFILLER_36_757 VGND VGND VPWR VPWR sky130_fd_sc_hd__fill_1
XFILLER_50_204 VGND VGND VPWR VPWR sky130_fd_sc_hd__decap_3
XFILLER_51_727 VGND VGND VPWR VPWR sky130_fd_sc_hd__fill_1
XFILLER_90_362 VGND VGND VPWR VPWR sky130_fd_sc_hd__fill_2
XTAP_TAPCELL_ROW_102_1714 VGND VPWR sky130_fd_sc_hd__tapvpwrvgnd_1
X_6750_ _6750_/A VGND VGND VPWR VPWR _8419_/D sky130_fd_sc_hd__buf_2
XTAP_TAPCELL_ROW_102_1725 VGND VPWR sky130_fd_sc_hd__tapvpwrvgnd_1
X_3962_ _4591_/S _3962_/B VGND VGND VPWR VPWR _3962_/X sky130_fd_sc_hd__or2_2
X_5701_ _5701_/A VGND VGND VPWR VPWR _7891_/D sky130_fd_sc_hd__buf_1
X_3893_ _3888_/X _3891_/X _3892_/X _3875_/A _3735_/X VGND VGND VPWR VPWR _3893_/X
+ sky130_fd_sc_hd__a221o_2
X_6681_ _8387_/Q _4984_/A _6681_/S VGND VGND VPWR VPWR _6682_/A sky130_fd_sc_hd__mux2_2
XFILLER_31_495 VGND VGND VPWR VPWR sky130_fd_sc_hd__decap_3
XTAP_TAPCELL_ROW_135_2202 VGND VPWR sky130_fd_sc_hd__tapvpwrvgnd_1
X_8420_ _8751_/CLK _8420_/D load_slew626/X VGND VGND VPWR VPWR _8420_/Q sky130_fd_sc_hd__dfrtp_2
X_5632_ _5632_/A VGND VGND VPWR VPWR _7859_/D sky130_fd_sc_hd__buf_1
X_8351_ _8756_/CLK _8351_/D wire701/X VGND VGND VPWR VPWR _8351_/Q sky130_fd_sc_hd__dfrtp_2
X_5563_ _5563_/A VGND VGND VPWR VPWR _7826_/D sky130_fd_sc_hd__buf_1
X_7302_ _8711_/Q _4984_/A _7302_/S VGND VGND VPWR VPWR _7303_/A sky130_fd_sc_hd__mux2_2
X_4514_ _4512_/X _4513_/X _4514_/S VGND VGND VPWR VPWR _4514_/X sky130_fd_sc_hd__mux2_2
XFILLER_132_504 VGND VGND VPWR VPWR sky130_fd_sc_hd__decap_3
X_8282_ _8687_/CLK _8282_/D load_slew568/X VGND VGND VPWR VPWR _8282_/Q sky130_fd_sc_hd__dfrtp_2
X_5494_ _5494_/A VGND VGND VPWR VPWR _7794_/D sky130_fd_sc_hd__buf_1
XFILLER_105_729 VGND VGND VPWR VPWR sky130_fd_sc_hd__decap_3
X_7233_ _7239_/A1 _4777_/X _7230_/X _7231_/X hold908/X VGND VGND VPWR VPWR _8662_/D
+ sky130_fd_sc_hd__a32o_2
X_4445_ _4458_/B2 _4434_/X _4437_/X _4440_/X _4444_/X VGND VGND VPWR VPWR _4445_/X
+ sky130_fd_sc_hd__o32a_2
XFILLER_113_751 VGND VGND VPWR VPWR sky130_fd_sc_hd__fill_1
XFILLER_132_548 VGND VGND VPWR VPWR sky130_fd_sc_hd__decap_3
XTAP_TAPCELL_ROW_113_1876 VGND VPWR sky130_fd_sc_hd__tapvpwrvgnd_1
Xfanout604 fanout606/X VGND VGND VPWR VPWR fanout604/X sky130_fd_sc_hd__clkdlybuf4s25_1
Xfanout615 fanout619/X VGND VGND VPWR VPWR fanout615/X sky130_fd_sc_hd__clkdlybuf4s25_1
X_7164_ _4921_/X _8615_/Q _7172_/S VGND VGND VPWR VPWR _7165_/A sky130_fd_sc_hd__mux2_2
X_4376_ _8755_/Q _7530_/Q _4402_/S VGND VGND VPWR VPWR _4376_/X sky130_fd_sc_hd__mux2_2
XFILLER_112_250 VGND VGND VPWR VPWR sky130_fd_sc_hd__fill_2
XFILLER_98_451 VGND VGND VPWR VPWR sky130_fd_sc_hd__decap_3
Xfanout637 fanout643/X VGND VGND VPWR VPWR wire638/A sky130_fd_sc_hd__clkdlybuf4s25_1
Xfanout648 fanout648/A VGND VGND VPWR VPWR fanout648/X sky130_fd_sc_hd__clkdlybuf4s25_1
X_6115_ _6115_/A VGND VGND VPWR VPWR _8122_/D sky130_fd_sc_hd__buf_1
XFILLER_112_294 VGND VGND VPWR VPWR sky130_fd_sc_hd__decap_3
XFILLER_58_326 VGND VGND VPWR VPWR sky130_fd_sc_hd__decap_3
X_7095_ _4782_/X hold946/X _7109_/S VGND VGND VPWR VPWR _7096_/A sky130_fd_sc_hd__mux2_1
XFILLER_39_551 VGND VGND VPWR VPWR sky130_fd_sc_hd__fill_1
XFILLER_85_167 VGND VGND VPWR VPWR sky130_fd_sc_hd__fill_1
XTAP_TAPCELL_ROW_1_300 VGND VPWR sky130_fd_sc_hd__tapvpwrvgnd_1
X_6046_ _6046_/A VGND VGND VPWR VPWR _8089_/D sky130_fd_sc_hd__buf_1
XFILLER_26_212 VGND VGND VPWR VPWR sky130_fd_sc_hd__decap_3
XFILLER_39_573 VGND VGND VPWR VPWR sky130_fd_sc_hd__fill_1
XTAP_TAPCELL_ROW_1_311 VGND VPWR sky130_fd_sc_hd__tapvpwrvgnd_1
XFILLER_41_215 VGND VGND VPWR VPWR sky130_fd_sc_hd__decap_3
X_7997_ _8655_/CLK _7997_/D fanout483/X VGND VGND VPWR VPWR _7997_/Q sky130_fd_sc_hd__dfrtp_2
XFILLER_35_790 VGND VGND VPWR VPWR sky130_fd_sc_hd__fill_1
XFILLER_41_248 VGND VGND VPWR VPWR sky130_fd_sc_hd__fill_2
XFILLER_42_749 VGND VGND VPWR VPWR sky130_fd_sc_hd__decap_3
X_6948_ _4833_/X _8513_/Q _6958_/S VGND VGND VPWR VPWR _6949_/A sky130_fd_sc_hd__mux2_4
X_6879_ _5036_/X _8480_/Q _6895_/S VGND VGND VPWR VPWR _6880_/A sky130_fd_sc_hd__mux2_4
XFILLER_10_613 VGND VGND VPWR VPWR sky130_fd_sc_hd__decap_3
X_8618_ _8699_/CLK _8618_/D fanout725/X VGND VGND VPWR VPWR _8618_/Q sky130_fd_sc_hd__dfrtp_2
XFILLER_10_657 VGND VGND VPWR VPWR sky130_fd_sc_hd__decap_3
X_8549_ _8747_/CLK _8549_/D fanout634/X VGND VGND VPWR VPWR _8549_/Q sky130_fd_sc_hd__dfrtp_2
XFILLER_108_523 VGND VGND VPWR VPWR sky130_fd_sc_hd__decap_3
XFILLER_6_628 VGND VGND VPWR VPWR sky130_fd_sc_hd__decap_3
XFILLER_123_526 VGND VGND VPWR VPWR sky130_fd_sc_hd__decap_3
XTAP_TAPCELL_ROW_75_1337 VGND VPWR sky130_fd_sc_hd__tapvpwrvgnd_1
XTAP_TAPCELL_ROW_75_1348 VGND VPWR sky130_fd_sc_hd__tapvpwrvgnd_1
XTAP_TAPCELL_ROW_9_422 VGND VPWR sky130_fd_sc_hd__tapvpwrvgnd_1
XFILLER_104_751 VGND VGND VPWR VPWR sky130_fd_sc_hd__fill_1
XFILLER_118_85 VGND VGND VPWR VPWR sky130_fd_sc_hd__fill_2
XFILLER_123_548 VGND VGND VPWR VPWR sky130_fd_sc_hd__decap_3
XFILLER_123_559 VGND VGND VPWR VPWR sky130_fd_sc_hd__fill_1
XFILLER_1_311 VGND VGND VPWR VPWR sky130_fd_sc_hd__fill_1
XFILLER_131_570 VGND VGND VPWR VPWR sky130_fd_sc_hd__decap_3
XFILLER_89_473 VGND VGND VPWR VPWR sky130_fd_sc_hd__decap_3
XFILLER_134_62 VGND VGND VPWR VPWR sky130_fd_sc_hd__decap_3
XFILLER_49_326 VGND VGND VPWR VPWR sky130_fd_sc_hd__decap_3
XFILLER_49_337 VGND VGND VPWR VPWR sky130_fd_sc_hd__decap_3
XFILLER_77_657 VGND VGND VPWR VPWR sky130_fd_sc_hd__decap_3
XFILLER_64_307 VGND VGND VPWR VPWR sky130_fd_sc_hd__fill_1
XFILLER_92_605 VGND VGND VPWR VPWR sky130_fd_sc_hd__decap_3
XFILLER_57_370 VGND VGND VPWR VPWR sky130_fd_sc_hd__fill_1
XFILLER_64_318 VGND VGND VPWR VPWR sky130_fd_sc_hd__decap_3
XFILLER_17_223 VGND VGND VPWR VPWR sky130_fd_sc_hd__fill_1
XFILLER_17_234 VGND VGND VPWR VPWR sky130_fd_sc_hd__decap_3
XFILLER_18_757 VGND VGND VPWR VPWR sky130_fd_sc_hd__fill_1
XFILLER_27_60 VGND VGND VPWR VPWR sky130_fd_sc_hd__decap_3
XFILLER_91_148 VGND VGND VPWR VPWR sky130_fd_sc_hd__decap_3
XFILLER_17_278 VGND VGND VPWR VPWR sky130_fd_sc_hd__fill_2
XFILLER_18_779 VGND VGND VPWR VPWR sky130_fd_sc_hd__decap_3
XFILLER_27_93 VGND VGND VPWR VPWR sky130_fd_sc_hd__decap_3
XFILLER_33_705 VGND VGND VPWR VPWR sky130_fd_sc_hd__fill_1
XFILLER_33_727 VGND VGND VPWR VPWR sky130_fd_sc_hd__fill_1
XFILLER_32_226 VGND VGND VPWR VPWR sky130_fd_sc_hd__fill_1
XFILLER_45_598 VGND VGND VPWR VPWR sky130_fd_sc_hd__decap_3
XTAP_TAPCELL_ROW_86_1499 VGND VPWR sky130_fd_sc_hd__tapvpwrvgnd_1
XFILLER_9_444 VGND VGND VPWR VPWR sky130_fd_sc_hd__decap_3
XFILLER_9_488 VGND VGND VPWR VPWR sky130_fd_sc_hd__decap_3
XFILLER_5_650 VGND VGND VPWR VPWR sky130_fd_sc_hd__decap_3
XTAP_TAPCELL_ROW_130_2110 VGND VPWR sky130_fd_sc_hd__tapvpwrvgnd_1
XFILLER_114_559 VGND VGND VPWR VPWR sky130_fd_sc_hd__decap_3
XFILLER_5_694 VGND VGND VPWR VPWR sky130_fd_sc_hd__decap_3
X_4230_ _8094_/Q _8175_/Q _8256_/Q _8337_/Q _4272_/S _4227_/A VGND VGND VPWR VPWR
+ _4231_/B sky130_fd_sc_hd__mux4_2
XFILLER_4_53 VGND VGND VPWR VPWR sky130_fd_sc_hd__decap_3
X_4161_ _7754_/Q _7835_/Q _4193_/S VGND VGND VPWR VPWR _4161_/X sky130_fd_sc_hd__mux2_2
XFILLER_110_732 VGND VGND VPWR VPWR sky130_fd_sc_hd__decap_3
XFILLER_122_581 VGND VGND VPWR VPWR sky130_fd_sc_hd__decap_3
XFILLER_4_97 VGND VGND VPWR VPWR sky130_fd_sc_hd__decap_3
XFILLER_67_134 VGND VGND VPWR VPWR sky130_fd_sc_hd__decap_3
XFILLER_95_443 VGND VGND VPWR VPWR sky130_fd_sc_hd__decap_3
XFILLER_95_476 VGND VGND VPWR VPWR sky130_fd_sc_hd__decap_3
X_4092_ _4090_/X _4091_/X _4092_/S VGND VGND VPWR VPWR _4092_/X sky130_fd_sc_hd__mux2_2
XFILLER_82_104 VGND VGND VPWR VPWR sky130_fd_sc_hd__decap_3
XTAP_TAPCELL_ROW_128_2083 VGND VPWR sky130_fd_sc_hd__tapvpwrvgnd_1
X_7920_ _8748_/CLK _7920_/D load_slew536/X VGND VGND VPWR VPWR _7920_/Q sky130_fd_sc_hd__dfrtp_2
XFILLER_36_554 VGND VGND VPWR VPWR sky130_fd_sc_hd__decap_3
XFILLER_63_340 VGND VGND VPWR VPWR sky130_fd_sc_hd__fill_2
X_7851_ _8671_/CLK _7851_/D load_slew687/X VGND VGND VPWR VPWR _7851_/Q sky130_fd_sc_hd__dfrtp_2
XFILLER_91_660 VGND VGND VPWR VPWR sky130_fd_sc_hd__decap_3
X_6802_ _6802_/A VGND VGND VPWR VPWR _8444_/D sky130_fd_sc_hd__buf_2
XFILLER_23_237 VGND VGND VPWR VPWR sky130_fd_sc_hd__decap_3
XFILLER_51_546 VGND VGND VPWR VPWR sky130_fd_sc_hd__decap_3
X_7782_ _8768_/CLK _7782_/D load_slew565/X VGND VGND VPWR VPWR _7782_/Q sky130_fd_sc_hd__dfrtp_2
X_4994_ input5/X _5026_/B VGND VGND VPWR VPWR _4995_/A sky130_fd_sc_hd__and2_2
XTAP_TAPCELL_ROW_34_766 VGND VPWR sky130_fd_sc_hd__tapvpwrvgnd_1
X_3945_ _4455_/A _3945_/B VGND VGND VPWR VPWR _3945_/X sky130_fd_sc_hd__or2_2
X_6733_ _6733_/A VGND VGND VPWR VPWR _8411_/D sky130_fd_sc_hd__buf_2
XFILLER_23_29 VGND VGND VPWR VPWR sky130_fd_sc_hd__decap_3
XFILLER_32_793 VGND VGND VPWR VPWR sky130_fd_sc_hd__decap_3
X_6664_ _6664_/A VGND VGND VPWR VPWR _8378_/D sky130_fd_sc_hd__buf_2
XFILLER_31_281 VGND VGND VPWR VPWR sky130_fd_sc_hd__decap_3
XTAP_TAPCELL_ROW_14_490 VGND VPWR sky130_fd_sc_hd__tapvpwrvgnd_1
X_3876_ _8386_/Q _8467_/Q _8548_/Q _8629_/Q _3868_/S _3869_/A VGND VGND VPWR VPWR
+ _3876_/X sky130_fd_sc_hd__mux4_2
X_8403_ _8646_/CLK _8403_/D load_slew533/X VGND VGND VPWR VPWR _8403_/Q sky130_fd_sc_hd__dfrtp_2
X_5615_ _7851_/Q _4815_/A _5633_/S VGND VGND VPWR VPWR _5616_/A sky130_fd_sc_hd__mux2_2
X_6595_ _6595_/A VGND VGND VPWR VPWR _8347_/D sky130_fd_sc_hd__buf_2
XTAP_TAPCELL_ROW_115_1905 VGND VPWR sky130_fd_sc_hd__tapvpwrvgnd_1
X_8334_ _8657_/CLK _8334_/D load_slew513/X VGND VGND VPWR VPWR _8334_/Q sky130_fd_sc_hd__dfrtp_2
X_5546_ _5546_/A VGND VGND VPWR VPWR _7818_/D sky130_fd_sc_hd__buf_1
XFILLER_105_515 VGND VGND VPWR VPWR sky130_fd_sc_hd__fill_2
XFILLER_117_386 VGND VGND VPWR VPWR sky130_fd_sc_hd__decap_3
XFILLER_132_301 VGND VGND VPWR VPWR sky130_fd_sc_hd__decap_3
XFILLER_132_312 VGND VGND VPWR VPWR sky130_fd_sc_hd__decap_3
X_8265_ _8747_/CLK _8265_/D load_slew633/X VGND VGND VPWR VPWR _8265_/Q sky130_fd_sc_hd__dfrtp_2
X_5477_ _5477_/A VGND VGND VPWR VPWR _7786_/D sky130_fd_sc_hd__buf_1
XFILLER_105_559 VGND VGND VPWR VPWR sky130_fd_sc_hd__fill_1
XFILLER_132_334 VGND VGND VPWR VPWR sky130_fd_sc_hd__decap_3
X_7216_ _7215_/X _4727_/X _7216_/A3 _7216_/B1 hold900/X VGND VGND VPWR VPWR _8650_/D
+ sky130_fd_sc_hd__a32o_2
X_4428_ _4455_/A _4426_/X _4427_/X VGND VGND VPWR VPWR _4428_/X sky130_fd_sc_hd__o21a_2
XTAP_TAPCELL_ROW_57_1089 VGND VPWR sky130_fd_sc_hd__tapvpwrvgnd_1
Xfanout401 _4110_/S0 VGND VGND VPWR VPWR _4035_/S sky130_fd_sc_hd__clkdlybuf4s25_1
X_8196_ _8763_/CLK _8196_/D fanout557/X VGND VGND VPWR VPWR _8196_/Q sky130_fd_sc_hd__dfrtp_2
XFILLER_101_710 VGND VGND VPWR VPWR sky130_fd_sc_hd__decap_3
XFILLER_101_732 VGND VGND VPWR VPWR sky130_fd_sc_hd__decap_3
XFILLER_113_581 VGND VGND VPWR VPWR sky130_fd_sc_hd__decap_3
XFILLER_86_421 VGND VGND VPWR VPWR sky130_fd_sc_hd__fill_1
Xclkbuf_5_16__f_CLK clkbuf_4_8_0_CLK/X VGND VGND VPWR VPWR clkbuf_5_16__f_CLK/X sky130_fd_sc_hd__clkbuf_16
Xfanout434 _4680_/S VGND VGND VPWR VPWR _4327_/S sky130_fd_sc_hd__clkdlybuf4s25_1
Xfanout445 _3845_/S VGND VGND VPWR VPWR _3887_/S sky130_fd_sc_hd__clkdlybuf4s25_1
X_7147_ _4887_/X _8607_/Q _7151_/S VGND VGND VPWR VPWR _7148_/A sky130_fd_sc_hd__mux2_2
X_4359_ _4444_/A1 _4355_/X _4358_/X _4364_/C1 VGND VGND VPWR VPWR _4359_/X sky130_fd_sc_hd__a211o_2
XFILLER_100_242 VGND VGND VPWR VPWR sky130_fd_sc_hd__fill_1
XFILLER_100_253 VGND VGND VPWR VPWR sky130_fd_sc_hd__decap_3
XFILLER_46_307 VGND VGND VPWR VPWR sky130_fd_sc_hd__fill_1
XTAP_TAPCELL_ROW_70_1267 VGND VPWR sky130_fd_sc_hd__tapvpwrvgnd_1
XTAP_TAPCELL_ROW_70_1278 VGND VPWR sky130_fd_sc_hd__tapvpwrvgnd_1
X_7078_ _4749_/X hold995/X _7088_/S VGND VGND VPWR VPWR _7079_/A sky130_fd_sc_hd__mux2_1
XFILLER_100_264 VGND VGND VPWR VPWR sky130_fd_sc_hd__decap_3
XFILLER_27_510 VGND VGND VPWR VPWR sky130_fd_sc_hd__decap_3
XFILLER_74_649 VGND VGND VPWR VPWR sky130_fd_sc_hd__fill_2
X_6029_ _6029_/A VGND VGND VPWR VPWR _8081_/D sky130_fd_sc_hd__buf_2
XFILLER_27_543 VGND VGND VPWR VPWR sky130_fd_sc_hd__decap_3
XFILLER_27_554 VGND VGND VPWR VPWR sky130_fd_sc_hd__decap_3
XFILLER_64_14 VGND VGND VPWR VPWR sky130_fd_sc_hd__fill_2
XFILLER_73_159 VGND VGND VPWR VPWR sky130_fd_sc_hd__decap_3
XFILLER_82_660 VGND VGND VPWR VPWR sky130_fd_sc_hd__decap_3
XFILLER_27_598 VGND VGND VPWR VPWR sky130_fd_sc_hd__decap_3
XFILLER_14_259 VGND VGND VPWR VPWR sky130_fd_sc_hd__decap_3
XFILLER_42_557 VGND VGND VPWR VPWR sky130_fd_sc_hd__decap_3
XFILLER_120_97 VGND VGND VPWR VPWR sky130_fd_sc_hd__decap_3
XFILLER_23_782 VGND VGND VPWR VPWR sky130_fd_sc_hd__fill_2
XFILLER_80_46 VGND VGND VPWR VPWR sky130_fd_sc_hd__fill_1
XFILLER_10_421 VGND VGND VPWR VPWR sky130_fd_sc_hd__fill_2
XFILLER_128_607 VGND VGND VPWR VPWR sky130_fd_sc_hd__decap_3
XFILLER_13_51 VGND VGND VPWR VPWR sky130_fd_sc_hd__decap_3
XFILLER_129_51 VGND VGND VPWR VPWR sky130_fd_sc_hd__decap_3
XFILLER_13_84 VGND VGND VPWR VPWR sky130_fd_sc_hd__decap_3
XFILLER_129_84 VGND VGND VPWR VPWR sky130_fd_sc_hd__decap_3
XFILLER_135_150 VGND VGND VPWR VPWR sky130_fd_sc_hd__decap_3
XFILLER_135_172 VGND VGND VPWR VPWR sky130_fd_sc_hd__decap_3
XFILLER_89_55 VGND VGND VPWR VPWR sky130_fd_sc_hd__fill_1
XFILLER_2_631 VGND VGND VPWR VPWR sky130_fd_sc_hd__decap_3
XFILLER_2_675 VGND VGND VPWR VPWR sky130_fd_sc_hd__decap_3
XFILLER_104_592 VGND VGND VPWR VPWR sky130_fd_sc_hd__decap_3
XFILLER_123_389 VGND VGND VPWR VPWR sky130_fd_sc_hd__decap_3
XFILLER_29_9 VGND VGND VPWR VPWR sky130_fd_sc_hd__decap_3
XFILLER_89_281 VGND VGND VPWR VPWR sky130_fd_sc_hd__decap_3
XFILLER_96_229 VGND VGND VPWR VPWR sky130_fd_sc_hd__decap_3
XFILLER_49_134 VGND VGND VPWR VPWR sky130_fd_sc_hd__decap_3
XFILLER_38_70 VGND VGND VPWR VPWR sky130_fd_sc_hd__decap_3
XFILLER_49_189 VGND VGND VPWR VPWR sky130_fd_sc_hd__decap_3
XFILLER_65_649 VGND VGND VPWR VPWR sky130_fd_sc_hd__decap_3
XFILLER_77_476 VGND VGND VPWR VPWR sky130_fd_sc_hd__decap_3
XFILLER_92_402 VGND VGND VPWR VPWR sky130_fd_sc_hd__decap_3
XFILLER_92_424 VGND VGND VPWR VPWR sky130_fd_sc_hd__decap_3
XTAP_TAPCELL_ROW_88_1528 VGND VPWR sky130_fd_sc_hd__tapvpwrvgnd_1
XFILLER_58_690 VGND VGND VPWR VPWR sky130_fd_sc_hd__decap_3
XFILLER_72_170 VGND VGND VPWR VPWR sky130_fd_sc_hd__fill_2
XFILLER_72_181 VGND VGND VPWR VPWR sky130_fd_sc_hd__decap_3
XFILLER_73_682 VGND VGND VPWR VPWR sky130_fd_sc_hd__fill_1
XFILLER_54_91 VGND VGND VPWR VPWR sky130_fd_sc_hd__fill_2
XFILLER_60_365 VGND VGND VPWR VPWR sky130_fd_sc_hd__fill_1
XFILLER_14_782 VGND VGND VPWR VPWR sky130_fd_sc_hd__fill_1
XTAP_TAPCELL_ROW_31_725 VGND VPWR sky130_fd_sc_hd__tapvpwrvgnd_1
X_3730_ _3890_/A VGND VGND VPWR VPWR _4590_/S sky130_fd_sc_hd__clkbuf_2
XFILLER_119_629 VGND VGND VPWR VPWR sky130_fd_sc_hd__fill_2
XFILLER_118_106 VGND VGND VPWR VPWR sky130_fd_sc_hd__fill_2
XFILLER_9_274 VGND VGND VPWR VPWR sky130_fd_sc_hd__decap_3
XFILLER_9_285 VGND VGND VPWR VPWR sky130_fd_sc_hd__decap_3
XTAP_TAPCELL_ROW_99_1679 VGND VPWR sky130_fd_sc_hd__tapvpwrvgnd_1
XFILLER_127_651 VGND VGND VPWR VPWR sky130_fd_sc_hd__decap_3
Xclkload11 clkload11/A VGND VGND VPWR VPWR clkload11/X sky130_fd_sc_hd__clkbuf_8
Xclkload22 _8742_/CLK VGND VGND VPWR VPWR clkload22/Y sky130_fd_sc_hd__bufinv_16
Xclkload33 _8685_/CLK VGND VGND VPWR VPWR clkload33/X sky130_fd_sc_hd__clkbuf_8
Xclkload44 _8427_/CLK VGND VGND VPWR VPWR clkload44/Y sky130_fd_sc_hd__bufinv_16
X_6380_ _4731_/X hold956/X _6398_/S VGND VGND VPWR VPWR _6381_/A sky130_fd_sc_hd__mux2_1
X_5400_ _5463_/A VGND VGND VPWR VPWR _5419_/S sky130_fd_sc_hd__buf_2
XFILLER_114_312 VGND VGND VPWR VPWR sky130_fd_sc_hd__fill_1
XFILLER_127_673 VGND VGND VPWR VPWR sky130_fd_sc_hd__decap_3
Xclkload55 _8791_/CLK VGND VGND VPWR VPWR clkload55/Y sky130_fd_sc_hd__clkinv_4
Xclkload66 _8760_/CLK VGND VGND VPWR VPWR clkload66/X sky130_fd_sc_hd__clkbuf_8
Xclkload77 _8775_/CLK VGND VGND VPWR VPWR clkload77/X sky130_fd_sc_hd__clkbuf_8
X_5331_ _7718_/Q _4937_/X _5331_/S VGND VGND VPWR VPWR _5332_/A sky130_fd_sc_hd__mux2_2
XFILLER_5_491 VGND VGND VPWR VPWR sky130_fd_sc_hd__fill_1
X_8050_ _8400_/CLK _8050_/D wire555/X VGND VGND VPWR VPWR _8050_/Q sky130_fd_sc_hd__dfrtp_2
XPHY_EDGE_ROW_10_Left_146 VGND VGND VPWR VPWR sky130_fd_sc_hd__decap_3
X_7001_ _7001_/A VGND VGND VPWR VPWR _8538_/D sky130_fd_sc_hd__buf_6
X_5262_ _7685_/Q _4799_/X _5268_/S VGND VGND VPWR VPWR _5263_/A sky130_fd_sc_hd__mux2_2
XFILLER_68_421 VGND VGND VPWR VPWR sky130_fd_sc_hd__fill_1
XFILLER_96_741 VGND VGND VPWR VPWR sky130_fd_sc_hd__fill_2
XTAP_TAPCELL_ROW_110_1835 VGND VPWR sky130_fd_sc_hd__tapvpwrvgnd_1
X_5193_ _7652_/Q _5003_/X _5205_/S VGND VGND VPWR VPWR _5194_/A sky130_fd_sc_hd__mux2_2
X_4213_ _4617_/B1 _4212_/X _4617_/A1 VGND VGND VPWR VPWR _4213_/X sky130_fd_sc_hd__a21o_2
XFILLER_96_763 VGND VGND VPWR VPWR sky130_fd_sc_hd__fill_2
X_4144_ _3733_/A _4135_/X _4138_/X _4143_/X VGND VGND VPWR VPWR _4144_/X sky130_fd_sc_hd__o31a_2
XFILLER_18_18 VGND VGND VPWR VPWR sky130_fd_sc_hd__decap_3
XFILLER_18_29 VGND VGND VPWR VPWR sky130_fd_sc_hd__decap_3
XTAP_TAPCELL_ROW_39_836 VGND VPWR sky130_fd_sc_hd__tapvpwrvgnd_1
XFILLER_55_137 VGND VGND VPWR VPWR sky130_fd_sc_hd__fill_2
XFILLER_83_435 VGND VGND VPWR VPWR sky130_fd_sc_hd__decap_3
X_4075_ _4146_/A _4075_/B VGND VGND VPWR VPWR _4075_/X sky130_fd_sc_hd__or2_2
XFILLER_36_340 VGND VGND VPWR VPWR sky130_fd_sc_hd__decap_3
X_7903_ _8804_/CLK _7903_/D load_slew499/X VGND VGND VPWR VPWR _7903_/Q sky130_fd_sc_hd__dfrtp_2
XFILLER_91_490 VGND VGND VPWR VPWR sky130_fd_sc_hd__decap_3
XTAP_TAPCELL_ROW_19_560 VGND VPWR sky130_fd_sc_hd__tapvpwrvgnd_1
X_7834_ _8646_/CLK _7834_/D load_slew529/X VGND VGND VPWR VPWR _7834_/Q sky130_fd_sc_hd__dfrtp_2
XFILLER_24_579 VGND VGND VPWR VPWR sky130_fd_sc_hd__decap_3
XFILLER_51_343 VGND VGND VPWR VPWR sky130_fd_sc_hd__decap_3
X_7765_ _8747_/CLK _7765_/D wire631/X VGND VGND VPWR VPWR _7765_/Q sky130_fd_sc_hd__dfrtp_2
XTAP_TAPCELL_ROW_121_1986 VGND VPWR sky130_fd_sc_hd__tapvpwrvgnd_1
X_6716_ _6716_/A VGND VGND VPWR VPWR _8403_/D sky130_fd_sc_hd__buf_2
X_4977_ _4977_/A VGND VGND VPWR VPWR _4977_/X sky130_fd_sc_hd__buf_1
XFILLER_133_9 VGND VGND VPWR VPWR sky130_fd_sc_hd__decap_3
XFILLER_20_741 VGND VGND VPWR VPWR sky130_fd_sc_hd__fill_2
X_3928_ _3900_/S _3923_/X _3925_/X _3927_/X VGND VGND VPWR VPWR _3928_/X sky130_fd_sc_hd__a22o_2
Xclkload5 clkload5/A VGND VGND VPWR VPWR clkload5/X sky130_fd_sc_hd__clkbuf_8
X_7696_ _8518_/CLK _7696_/D fanout705/X VGND VGND VPWR VPWR _7696_/Q sky130_fd_sc_hd__dfrtp_2
XFILLER_109_106 VGND VGND VPWR VPWR sky130_fd_sc_hd__decap_3
XFILLER_50_49 VGND VGND VPWR VPWR sky130_fd_sc_hd__decap_3
X_3859_ _3831_/A _3855_/X _3857_/X _3858_/X VGND VGND VPWR VPWR _3859_/X sky130_fd_sc_hd__a22o_2
X_6647_ _6647_/A VGND VGND VPWR VPWR _8372_/D sky130_fd_sc_hd__buf_2
XTAP_TAPCELL_ROW_59_1118 VGND VPWR sky130_fd_sc_hd__tapvpwrvgnd_1
X_6578_ _6578_/A VGND VGND VPWR VPWR _8339_/D sky130_fd_sc_hd__buf_2
XFILLER_118_673 VGND VGND VPWR VPWR sky130_fd_sc_hd__decap_3
X_8317_ _8560_/CLK _8317_/D _8053_/SET_B VGND VGND VPWR VPWR _8317_/Q sky130_fd_sc_hd__dfrtp_2
X_5529_ _5529_/A VGND VGND VPWR VPWR _7810_/D sky130_fd_sc_hd__buf_1
XFILLER_133_632 VGND VGND VPWR VPWR sky130_fd_sc_hd__decap_3
XTAP_TAPCELL_ROW_72_1307 VGND VPWR sky130_fd_sc_hd__tapvpwrvgnd_1
XFILLER_132_153 VGND VGND VPWR VPWR sky130_fd_sc_hd__decap_3
XFILLER_133_665 VGND VGND VPWR VPWR sky130_fd_sc_hd__decap_3
XFILLER_133_676 VGND VGND VPWR VPWR sky130_fd_sc_hd__decap_3
X_8248_ _8735_/CLK _8248_/D fanout535/X VGND VGND VPWR VPWR _8248_/Q sky130_fd_sc_hd__dfrtp_2
XFILLER_120_315 VGND VGND VPWR VPWR sky130_fd_sc_hd__decap_3
XFILLER_132_186 VGND VGND VPWR VPWR sky130_fd_sc_hd__decap_3
XFILLER_132_197 VGND VGND VPWR VPWR sky130_fd_sc_hd__decap_3
XFILLER_78_229 VGND VGND VPWR VPWR sky130_fd_sc_hd__decap_3
X_8179_ _8746_/CLK _8179_/D load_slew526/X VGND VGND VPWR VPWR _8179_/Q sky130_fd_sc_hd__dfrtp_2
XFILLER_120_348 VGND VGND VPWR VPWR sky130_fd_sc_hd__decap_3
XFILLER_101_573 VGND VGND VPWR VPWR sky130_fd_sc_hd__decap_3
XFILLER_74_424 VGND VGND VPWR VPWR sky130_fd_sc_hd__decap_3
XFILLER_87_785 VGND VGND VPWR VPWR sky130_fd_sc_hd__fill_2
Xfanout286 fanout289/X VGND VGND VPWR VPWR _4083_/C1 sky130_fd_sc_hd__clkdlybuf4s25_1
Xfanout297 fanout299/X VGND VGND VPWR VPWR _4665_/C1 sky130_fd_sc_hd__clkdlybuf4s25_1
XFILLER_75_57 VGND VGND VPWR VPWR sky130_fd_sc_hd__decap_3
XFILLER_131_30 VGND VGND VPWR VPWR sky130_fd_sc_hd__decap_3
XFILLER_55_671 VGND VGND VPWR VPWR sky130_fd_sc_hd__fill_1
XFILLER_131_63 VGND VGND VPWR VPWR sky130_fd_sc_hd__decap_3
XFILLER_42_321 VGND VGND VPWR VPWR sky130_fd_sc_hd__fill_1
XFILLER_131_96 VGND VGND VPWR VPWR sky130_fd_sc_hd__decap_3
XFILLER_15_579 VGND VGND VPWR VPWR sky130_fd_sc_hd__decap_3
XTAP_TAPCELL_ROW_83_1458 VGND VPWR sky130_fd_sc_hd__tapvpwrvgnd_1
XFILLER_24_50 VGND VGND VPWR VPWR sky130_fd_sc_hd__decap_3
XFILLER_42_365 VGND VGND VPWR VPWR sky130_fd_sc_hd__decap_3
XFILLER_70_674 VGND VGND VPWR VPWR sky130_fd_sc_hd__decap_3
XFILLER_11_741 VGND VGND VPWR VPWR sky130_fd_sc_hd__decap_3
XFILLER_24_83 VGND VGND VPWR VPWR sky130_fd_sc_hd__fill_1
XFILLER_10_240 VGND VGND VPWR VPWR sky130_fd_sc_hd__decap_3
XFILLER_10_262 VGND VGND VPWR VPWR sky130_fd_sc_hd__decap_3
XFILLER_11_774 VGND VGND VPWR VPWR sky130_fd_sc_hd__decap_3
XFILLER_11_785 VGND VGND VPWR VPWR sky130_fd_sc_hd__decap_3
XFILLER_7_712 VGND VGND VPWR VPWR sky130_fd_sc_hd__decap_3
XFILLER_109_651 VGND VGND VPWR VPWR sky130_fd_sc_hd__decap_3
XFILLER_128_448 VGND VGND VPWR VPWR sky130_fd_sc_hd__decap_3
XFILLER_6_233 VGND VGND VPWR VPWR sky130_fd_sc_hd__decap_3
XFILLER_7_756 VGND VGND VPWR VPWR sky130_fd_sc_hd__decap_3
XFILLER_108_150 VGND VGND VPWR VPWR sky130_fd_sc_hd__decap_3
XFILLER_109_673 VGND VGND VPWR VPWR sky130_fd_sc_hd__decap_3
XFILLER_123_153 VGND VGND VPWR VPWR sky130_fd_sc_hd__decap_3
XFILLER_97_505 VGND VGND VPWR VPWR sky130_fd_sc_hd__decap_3
XFILLER_111_304 VGND VGND VPWR VPWR sky130_fd_sc_hd__decap_3
XFILLER_111_337 VGND VGND VPWR VPWR sky130_fd_sc_hd__decap_3
XFILLER_123_175 VGND VGND VPWR VPWR sky130_fd_sc_hd__decap_3
XFILLER_124_698 VGND VGND VPWR VPWR sky130_fd_sc_hd__fill_2
XFILLER_69_218 VGND VGND VPWR VPWR sky130_fd_sc_hd__fill_2
Xload_slew626 fanout625/X VGND VGND VPWR VPWR load_slew626/X sky130_fd_sc_hd__buf_4
XFILLER_27_6 VGND VGND VPWR VPWR sky130_fd_sc_hd__decap_3
XFILLER_78_752 VGND VGND VPWR VPWR sky130_fd_sc_hd__decap_3
Xload_slew659 fanout658/X VGND VGND VPWR VPWR fanout656/A sky130_fd_sc_hd__buf_4
XFILLER_1_21 VGND VGND VPWR VPWR sky130_fd_sc_hd__decap_3
XFILLER_93_722 VGND VGND VPWR VPWR sky130_fd_sc_hd__fill_1
XFILLER_1_54 VGND VGND VPWR VPWR sky130_fd_sc_hd__fill_2
XFILLER_37_126 VGND VGND VPWR VPWR sky130_fd_sc_hd__fill_2
XFILLER_37_137 VGND VGND VPWR VPWR sky130_fd_sc_hd__decap_3
XFILLER_93_766 VGND VGND VPWR VPWR sky130_fd_sc_hd__fill_2
XTAP_TAPCELL_ROW_125_2042 VGND VPWR sky130_fd_sc_hd__tapvpwrvgnd_1
XFILLER_1_87 VGND VGND VPWR VPWR sky130_fd_sc_hd__decap_3
XFILLER_46_671 VGND VGND VPWR VPWR sky130_fd_sc_hd__fill_1
XFILLER_92_265 VGND VGND VPWR VPWR sky130_fd_sc_hd__decap_3
XFILLER_93_777 VGND VGND VPWR VPWR sky130_fd_sc_hd__decap_3
XFILLER_46_693 VGND VGND VPWR VPWR sky130_fd_sc_hd__decap_3
XFILLER_61_630 VGND VGND VPWR VPWR sky130_fd_sc_hd__fill_2
XFILLER_80_427 VGND VGND VPWR VPWR sky130_fd_sc_hd__fill_2
XFILLER_92_298 VGND VGND VPWR VPWR sky130_fd_sc_hd__fill_1
X_5880_ _5880_/A1 _5869_/X _5027_/X _5870_/X hold874/X VGND VGND VPWR VPWR _7982_/D
+ sky130_fd_sc_hd__a32o_2
X_4900_ _4899_/X _7547_/Q _4904_/S VGND VGND VPWR VPWR _4901_/A sky130_fd_sc_hd__mux2_2
XFILLER_61_652 VGND VGND VPWR VPWR sky130_fd_sc_hd__decap_3
XFILLER_61_663 VGND VGND VPWR VPWR sky130_fd_sc_hd__decap_3
X_4831_ _4831_/A VGND VGND VPWR VPWR _7530_/D sky130_fd_sc_hd__buf_1
XFILLER_21_516 VGND VGND VPWR VPWR sky130_fd_sc_hd__fill_1
X_7550_ _8775_/CLK _7550_/D fanout726/X VGND VGND VPWR VPWR _7550_/Q sky130_fd_sc_hd__dfrtp_2
X_4762_ _4761_/X _7514_/Q _4778_/S VGND VGND VPWR VPWR _4763_/A sky130_fd_sc_hd__mux2_2
XFILLER_119_426 VGND VGND VPWR VPWR sky130_fd_sc_hd__decap_3
XFILLER_119_437 VGND VGND VPWR VPWR sky130_fd_sc_hd__fill_2
X_3713_ _7267_/A _6658_/B _8051_/Q VGND VGND VPWR VPWR _5962_/D sky130_fd_sc_hd__a21oi_2
X_7481_ _5003_/X hold988/X _7495_/S VGND VGND VPWR VPWR _7482_/A sky130_fd_sc_hd__mux2_2
X_6501_ _4973_/X _8303_/Q _6507_/S VGND VGND VPWR VPWR _6502_/A sky130_fd_sc_hd__mux2_2
X_4693_ _6314_/C VGND VGND VPWR VPWR _7004_/C sky130_fd_sc_hd__inv_2
X_6432_ _4837_/X _8271_/Q _6440_/S VGND VGND VPWR VPWR _6433_/A sky130_fd_sc_hd__mux2_2
XFILLER_106_109 VGND VGND VPWR VPWR sky130_fd_sc_hd__fill_1
XFILLER_127_470 VGND VGND VPWR VPWR sky130_fd_sc_hd__decap_3
XFILLER_134_407 VGND VGND VPWR VPWR sky130_fd_sc_hd__fill_1
XFILLER_115_632 VGND VGND VPWR VPWR sky130_fd_sc_hd__decap_3
X_8102_ _8750_/CLK _8102_/D fanout641/X VGND VGND VPWR VPWR _8102_/Q sky130_fd_sc_hd__dfrtp_2
X_6363_ _4691_/X _8238_/Q _6377_/S VGND VGND VPWR VPWR _6364_/A sky130_fd_sc_hd__mux2_2
X_6294_ _4903_/X _8206_/Q _6310_/S VGND VGND VPWR VPWR _6295_/A sky130_fd_sc_hd__mux2_4
X_5314_ _5314_/A VGND VGND VPWR VPWR _7709_/D sky130_fd_sc_hd__buf_1
XFILLER_114_175 VGND VGND VPWR VPWR sky130_fd_sc_hd__fill_2
XFILLER_130_613 VGND VGND VPWR VPWR sky130_fd_sc_hd__decap_3
XFILLER_88_527 VGND VGND VPWR VPWR sky130_fd_sc_hd__fill_1
XTAP_TAPCELL_ROW_54_1048 VGND VPWR sky130_fd_sc_hd__tapvpwrvgnd_1
X_8033_ _8697_/CLK _8033_/D load_slew720/X VGND VGND VPWR VPWR _8033_/Q sky130_fd_sc_hd__dfrtp_2
X_5245_ _7677_/Q _4765_/X _5247_/S VGND VGND VPWR VPWR _5246_/A sky130_fd_sc_hd__mux2_2
XFILLER_114_197 VGND VGND VPWR VPWR sky130_fd_sc_hd__decap_3
XFILLER_130_657 VGND VGND VPWR VPWR sky130_fd_sc_hd__decap_3
XFILLER_29_39 VGND VGND VPWR VPWR sky130_fd_sc_hd__decap_3
XFILLER_69_763 VGND VGND VPWR VPWR sky130_fd_sc_hd__fill_1
XFILLER_29_605 VGND VGND VPWR VPWR sky130_fd_sc_hd__decap_3
XFILLER_29_638 VGND VGND VPWR VPWR sky130_fd_sc_hd__decap_3
XFILLER_69_785 VGND VGND VPWR VPWR sky130_fd_sc_hd__decap_3
XFILLER_96_582 VGND VGND VPWR VPWR sky130_fd_sc_hd__fill_2
X_5176_ _7644_/Q _4969_/X _5184_/S VGND VGND VPWR VPWR _5177_/A sky130_fd_sc_hd__mux2_2
XFILLER_56_424 VGND VGND VPWR VPWR sky130_fd_sc_hd__fill_1
XFILLER_83_210 VGND VGND VPWR VPWR sky130_fd_sc_hd__decap_3
XFILLER_84_755 VGND VGND VPWR VPWR sky130_fd_sc_hd__fill_1
X_4127_ _4129_/A _4123_/X _4125_/X _4126_/X VGND VGND VPWR VPWR _4127_/X sky130_fd_sc_hd__a22o_2
XFILLER_44_608 VGND VGND VPWR VPWR sky130_fd_sc_hd__fill_2
XFILLER_71_405 VGND VGND VPWR VPWR sky130_fd_sc_hd__decap_3
X_4058_ _4120_/A _4058_/B VGND VGND VPWR VPWR _4058_/X sky130_fd_sc_hd__or2_2
XFILLER_37_682 VGND VGND VPWR VPWR sky130_fd_sc_hd__decap_3
XFILLER_83_287 VGND VGND VPWR VPWR sky130_fd_sc_hd__decap_3
XFILLER_83_298 VGND VGND VPWR VPWR sky130_fd_sc_hd__decap_3
XFILLER_40_803 VGND VGND VPWR VPWR sky130_fd_sc_hd__fill_1
XFILLER_12_505 VGND VGND VPWR VPWR sky130_fd_sc_hd__decap_3
XFILLER_24_365 VGND VGND VPWR VPWR sky130_fd_sc_hd__decap_3
X_8797_ _8800_/CLK _8797_/D load_slew593/X VGND VGND VPWR VPWR _8797_/Q sky130_fd_sc_hd__dfrtp_2
X_7817_ _8634_/CLK _7817_/D wire603/A VGND VGND VPWR VPWR _7817_/Q sky130_fd_sc_hd__dfrtp_2
XFILLER_61_37 VGND VGND VPWR VPWR sky130_fd_sc_hd__fill_1
XTAP_TAPCELL_ROW_65_1199 VGND VPWR sky130_fd_sc_hd__tapvpwrvgnd_1
X_7748_ _8649_/CLK _7748_/D wire531/X VGND VGND VPWR VPWR _7748_/Q sky130_fd_sc_hd__dfrtp_2
XFILLER_131_6 VGND VGND VPWR VPWR sky130_fd_sc_hd__decap_3
XFILLER_20_560 VGND VGND VPWR VPWR sky130_fd_sc_hd__decap_3
X_7679_ _8746_/CLK _7679_/D fanout525/X VGND VGND VPWR VPWR _7679_/Q sky130_fd_sc_hd__dfrtp_2
XTAP_TAPCELL_ROW_22_599 VGND VPWR sky130_fd_sc_hd__tapvpwrvgnd_1
XFILLER_125_429 VGND VGND VPWR VPWR sky130_fd_sc_hd__decap_3
XFILLER_4_704 VGND VGND VPWR VPWR sky130_fd_sc_hd__decap_3
XFILLER_3_225 VGND VGND VPWR VPWR sky130_fd_sc_hd__decap_3
XFILLER_4_737 VGND VGND VPWR VPWR sky130_fd_sc_hd__decap_3
XFILLER_106_654 VGND VGND VPWR VPWR sky130_fd_sc_hd__decap_3
XFILLER_10_41 VGND VGND VPWR VPWR sky130_fd_sc_hd__decap_3
XFILLER_79_516 VGND VGND VPWR VPWR sky130_fd_sc_hd__decap_3
XFILLER_10_74 VGND VGND VPWR VPWR sky130_fd_sc_hd__decap_3
XFILLER_10_85 VGND VGND VPWR VPWR sky130_fd_sc_hd__decap_3
XFILLER_121_613 VGND VGND VPWR VPWR sky130_fd_sc_hd__decap_3
XFILLER_126_41 VGND VGND VPWR VPWR sky130_fd_sc_hd__decap_3
XFILLER_133_473 VGND VGND VPWR VPWR sky130_fd_sc_hd__decap_3
XFILLER_126_74 VGND VGND VPWR VPWR sky130_fd_sc_hd__decap_3
XFILLER_126_85 VGND VGND VPWR VPWR sky130_fd_sc_hd__decap_3
XFILLER_120_156 VGND VGND VPWR VPWR sky130_fd_sc_hd__decap_3
XFILLER_120_167 VGND VGND VPWR VPWR sky130_fd_sc_hd__fill_1
XFILLER_47_413 VGND VGND VPWR VPWR sky130_fd_sc_hd__fill_1
XFILLER_59_251 VGND VGND VPWR VPWR sky130_fd_sc_hd__decap_3
XFILLER_75_700 VGND VGND VPWR VPWR sky130_fd_sc_hd__decap_3
XFILLER_86_89 VGND VGND VPWR VPWR sky130_fd_sc_hd__decap_3
XFILLER_19_72 VGND VGND VPWR VPWR sky130_fd_sc_hd__decap_3
XFILLER_47_435 VGND VGND VPWR VPWR sky130_fd_sc_hd__decap_3
XFILLER_47_446 VGND VGND VPWR VPWR sky130_fd_sc_hd__fill_2
XFILLER_59_284 VGND VGND VPWR VPWR sky130_fd_sc_hd__decap_3
XFILLER_75_744 VGND VGND VPWR VPWR sky130_fd_sc_hd__fill_1
XFILLER_75_766 VGND VGND VPWR VPWR sky130_fd_sc_hd__fill_1
XFILLER_75_788 VGND VGND VPWR VPWR sky130_fd_sc_hd__fill_2
XFILLER_55_490 VGND VGND VPWR VPWR sky130_fd_sc_hd__decap_3
XFILLER_30_302 VGND VGND VPWR VPWR sky130_fd_sc_hd__decap_3
XFILLER_35_93 VGND VGND VPWR VPWR sky130_fd_sc_hd__decap_3
XFILLER_30_324 VGND VGND VPWR VPWR sky130_fd_sc_hd__decap_3
XFILLER_42_184 VGND VGND VPWR VPWR sky130_fd_sc_hd__decap_3
XFILLER_128_212 VGND VGND VPWR VPWR sky130_fd_sc_hd__decap_3
XFILLER_129_724 VGND VGND VPWR VPWR sky130_fd_sc_hd__decap_3
XFILLER_129_735 VGND VGND VPWR VPWR sky130_fd_sc_hd__decap_3
XFILLER_30_357 VGND VGND VPWR VPWR sky130_fd_sc_hd__decap_3
XFILLER_30_368 VGND VGND VPWR VPWR sky130_fd_sc_hd__decap_3
XTAP_TAPCELL_ROW_41_864 VGND VPWR sky130_fd_sc_hd__tapvpwrvgnd_1
XFILLER_128_245 VGND VGND VPWR VPWR sky130_fd_sc_hd__decap_3
XFILLER_129_768 VGND VGND VPWR VPWR sky130_fd_sc_hd__decap_3
XFILLER_7_520 VGND VGND VPWR VPWR sky130_fd_sc_hd__decap_3
XFILLER_128_256 VGND VGND VPWR VPWR sky130_fd_sc_hd__decap_3
XFILLER_128_267 VGND VGND VPWR VPWR sky130_fd_sc_hd__fill_1
XFILLER_7_564 VGND VGND VPWR VPWR sky130_fd_sc_hd__decap_3
XTAP_TAPCELL_ROW_96_1638 VGND VPWR sky130_fd_sc_hd__tapvpwrvgnd_1
Xmax_cap217 _5852_/X VGND VGND VPWR VPWR _5867_/A1 sky130_fd_sc_hd__buf_2
Xmax_cap206 _7205_/X VGND VGND VPWR VPWR _7216_/B1 sky130_fd_sc_hd__buf_4
Xmax_cap239 _4065_/X VGND VGND VPWR VPWR _4436_/B1 sky130_fd_sc_hd__buf_6
Xmax_cap228 _3817_/X VGND VGND VPWR VPWR _4648_/B1 sky130_fd_sc_hd__buf_6
XFILLER_112_602 VGND VGND VPWR VPWR sky130_fd_sc_hd__decap_3
Xload_slew412 _4077_/S VGND VGND VPWR VPWR _4100_/S sky130_fd_sc_hd__clkbuf_4
XFILLER_111_134 VGND VGND VPWR VPWR sky130_fd_sc_hd__decap_3
XFILLER_97_346 VGND VGND VPWR VPWR sky130_fd_sc_hd__decap_3
Xload_slew456 _4352_/S VGND VGND VPWR VPWR _4367_/S sky130_fd_sc_hd__clkbuf_4
X_5030_ _5030_/A _5030_/B VGND VGND VPWR VPWR _5031_/A sky130_fd_sc_hd__and2_2
XFILLER_111_178 VGND VGND VPWR VPWR sky130_fd_sc_hd__decap_3
XFILLER_25_3 VGND VGND VPWR VPWR sky130_fd_sc_hd__decap_3
XFILLER_66_722 VGND VGND VPWR VPWR sky130_fd_sc_hd__decap_3
Xload_slew489 fanout488/X VGND VGND VPWR VPWR load_slew489/X sky130_fd_sc_hd__buf_4
Xload_slew478 fanout477/X VGND VGND VPWR VPWR fanout475/A sky130_fd_sc_hd__clkbuf_4
Xload_slew467 _4568_/S VGND VGND VPWR VPWR _4662_/S sky130_fd_sc_hd__buf_4
XFILLER_120_690 VGND VGND VPWR VPWR sky130_fd_sc_hd__fill_1
XFILLER_38_424 VGND VGND VPWR VPWR sky130_fd_sc_hd__decap_3
XFILLER_66_755 VGND VGND VPWR VPWR sky130_fd_sc_hd__fill_1
XTAP_TAPCELL_ROW_49_975 VGND VPWR sky130_fd_sc_hd__tapvpwrvgnd_1
X_6981_ _7002_/S VGND VGND VPWR VPWR _7000_/S sky130_fd_sc_hd__buf_6
XFILLER_53_438 VGND VGND VPWR VPWR sky130_fd_sc_hd__decap_3
X_8720_ _8796_/CLK _8720_/D fanout609/A VGND VGND VPWR VPWR _8720_/Q sky130_fd_sc_hd__dfrtp_2
X_5932_ _5920_/X _5932_/A2 _4853_/X _5932_/B1 hold898/X VGND VGND VPWR VPWR _8022_/D
+ sky130_fd_sc_hd__a32o_2
XTAP_TAPCELL_ROW_105_1756 VGND VPWR sky130_fd_sc_hd__tapvpwrvgnd_1
XFILLER_34_685 VGND VGND VPWR VPWR sky130_fd_sc_hd__decap_3
XFILLER_61_471 VGND VGND VPWR VPWR sky130_fd_sc_hd__decap_3
XTAP_TAPCELL_ROW_105_1767 VGND VPWR sky130_fd_sc_hd__tapvpwrvgnd_1
X_8651_ _8655_/CLK _8651_/D fanout485/X VGND VGND VPWR VPWR _8651_/Q sky130_fd_sc_hd__dfrtp_2
X_5863_ _5867_/A1 _5867_/A2 _4969_/X _5857_/X hold803/X VGND VGND VPWR VPWR _7968_/D
+ sky130_fd_sc_hd__a32o_2
XFILLER_21_335 VGND VGND VPWR VPWR sky130_fd_sc_hd__fill_1
XFILLER_21_346 VGND VGND VPWR VPWR sky130_fd_sc_hd__decap_3
XFILLER_33_195 VGND VGND VPWR VPWR sky130_fd_sc_hd__decap_3
X_8582_ _8751_/CLK _8582_/D fanout629/X VGND VGND VPWR VPWR _8582_/Q sky130_fd_sc_hd__dfrtp_2
X_7602_ _8410_/CLK _7602_/D load_slew526/X VGND VGND VPWR VPWR _7602_/Q sky130_fd_sc_hd__dfrtp_2
X_5794_ _5794_/A VGND VGND VPWR VPWR _7935_/D sky130_fd_sc_hd__buf_1
X_4814_ _4814_/A _4818_/B VGND VGND VPWR VPWR _4815_/A sky130_fd_sc_hd__and2_2
XFILLER_119_201 VGND VGND VPWR VPWR sky130_fd_sc_hd__decap_3
X_7533_ _8597_/CLK _7533_/D load_slew710/X VGND VGND VPWR VPWR _7533_/Q sky130_fd_sc_hd__dfrtp_2
X_4745_ _4745_/A VGND VGND VPWR VPWR _4745_/X sky130_fd_sc_hd__buf_1
XFILLER_31_18 VGND VGND VPWR VPWR sky130_fd_sc_hd__fill_2
XFILLER_135_716 VGND VGND VPWR VPWR sky130_fd_sc_hd__decap_3
XFILLER_135_738 VGND VGND VPWR VPWR sky130_fd_sc_hd__decap_3
X_7464_ _4969_/X _8788_/Q _7474_/S VGND VGND VPWR VPWR _7465_/A sky130_fd_sc_hd__mux2_2
X_4676_ _4681_/A _4676_/B VGND VGND VPWR VPWR _4676_/X sky130_fd_sc_hd__or2_2
XFILLER_128_790 VGND VGND VPWR VPWR sky130_fd_sc_hd__decap_3
XFILLER_134_215 VGND VGND VPWR VPWR sky130_fd_sc_hd__decap_3
X_7395_ _8755_/Q _4828_/A _7407_/S VGND VGND VPWR VPWR _7396_/A sky130_fd_sc_hd__mux2_2
X_6415_ _4803_/X hold962/X _6419_/S VGND VGND VPWR VPWR _6416_/A sky130_fd_sc_hd__mux2_1
XFILLER_134_259 VGND VGND VPWR VPWR sky130_fd_sc_hd__decap_3
XFILLER_1_718 VGND VGND VPWR VPWR sky130_fd_sc_hd__decap_3
X_6346_ _5007_/X _6346_/A1 _6356_/S VGND VGND VPWR VPWR _6347_/A sky130_fd_sc_hd__mux2_1
XFILLER_1_729 VGND VGND VPWR VPWR sky130_fd_sc_hd__decap_3
XFILLER_0_239 VGND VGND VPWR VPWR sky130_fd_sc_hd__decap_3
XFILLER_130_421 VGND VGND VPWR VPWR sky130_fd_sc_hd__decap_3
XFILLER_130_454 VGND VGND VPWR VPWR sky130_fd_sc_hd__decap_3
X_8016_ _8593_/CLK _8016_/D load_slew710/X VGND VGND VPWR VPWR _8016_/Q sky130_fd_sc_hd__dfrtp_2
X_6277_ _4871_/X _8198_/Q _6289_/S VGND VGND VPWR VPWR _6278_/A sky130_fd_sc_hd__mux2_4
XFILLER_102_167 VGND VGND VPWR VPWR sky130_fd_sc_hd__decap_3
X_5228_ _5333_/S VGND VGND VPWR VPWR _5247_/S sky130_fd_sc_hd__clkbuf_2
XFILLER_130_498 VGND VGND VPWR VPWR sky130_fd_sc_hd__decap_3
XFILLER_29_424 VGND VGND VPWR VPWR sky130_fd_sc_hd__decap_3
XFILLER_29_446 VGND VGND VPWR VPWR sky130_fd_sc_hd__fill_2
XFILLER_69_593 VGND VGND VPWR VPWR sky130_fd_sc_hd__decap_3
X_5159_ _5159_/A VGND VGND VPWR VPWR _7637_/D sky130_fd_sc_hd__buf_1
XFILLER_29_457 VGND VGND VPWR VPWR sky130_fd_sc_hd__decap_3
XFILLER_56_265 VGND VGND VPWR VPWR sky130_fd_sc_hd__decap_3
XFILLER_112_21 VGND VGND VPWR VPWR sky130_fd_sc_hd__decap_3
XTAP_TAPCELL_ROW_67_1228 VGND VPWR sky130_fd_sc_hd__tapvpwrvgnd_1
XFILLER_25_652 VGND VGND VPWR VPWR sky130_fd_sc_hd__decap_3
XFILLER_37_490 VGND VGND VPWR VPWR sky130_fd_sc_hd__decap_3
XFILLER_44_449 VGND VGND VPWR VPWR sky130_fd_sc_hd__decap_3
XTAP_TAPCELL_ROW_27_669 VGND VPWR sky130_fd_sc_hd__tapvpwrvgnd_1
XFILLER_71_279 VGND VGND VPWR VPWR sky130_fd_sc_hd__fill_1
XTAP_TAPCELL_ROW_80_1406 VGND VPWR sky130_fd_sc_hd__tapvpwrvgnd_1
XTAP_TAPCELL_ROW_80_1417 VGND VPWR sky130_fd_sc_hd__tapvpwrvgnd_1
XFILLER_21_51 VGND VGND VPWR VPWR sky130_fd_sc_hd__decap_3
XFILLER_4_523 VGND VGND VPWR VPWR sky130_fd_sc_hd__decap_3
XTAP_TAPCELL_ROW_78_1379 VGND VPWR sky130_fd_sc_hd__tapvpwrvgnd_1
XFILLER_134_760 VGND VGND VPWR VPWR sky130_fd_sc_hd__decap_3
XFILLER_21_84 VGND VGND VPWR VPWR sky130_fd_sc_hd__decap_3
XFILLER_4_545 VGND VGND VPWR VPWR sky130_fd_sc_hd__decap_3
XFILLER_133_270 VGND VGND VPWR VPWR sky130_fd_sc_hd__decap_3
XFILLER_134_793 VGND VGND VPWR VPWR sky130_fd_sc_hd__decap_3
XFILLER_4_589 VGND VGND VPWR VPWR sky130_fd_sc_hd__decap_3
XFILLER_97_44 VGND VGND VPWR VPWR sky130_fd_sc_hd__fill_1
XFILLER_121_432 VGND VGND VPWR VPWR sky130_fd_sc_hd__decap_3
XFILLER_133_281 VGND VGND VPWR VPWR sky130_fd_sc_hd__decap_3
XTAP_TAPCELL_ROW_91_1568 VGND VPWR sky130_fd_sc_hd__tapvpwrvgnd_1
XFILLER_67_508 VGND VGND VPWR VPWR sky130_fd_sc_hd__fill_2
XFILLER_11_9 VGND VGND VPWR VPWR sky130_fd_sc_hd__decap_3
XFILLER_48_755 VGND VGND VPWR VPWR sky130_fd_sc_hd__fill_1
XTAP_TAPCELL_ROW_7_394 VGND VPWR sky130_fd_sc_hd__tapvpwrvgnd_1
XFILLER_47_287 VGND VGND VPWR VPWR sky130_fd_sc_hd__decap_3
XFILLER_62_213 VGND VGND VPWR VPWR sky130_fd_sc_hd__decap_3
XFILLER_63_725 VGND VGND VPWR VPWR sky130_fd_sc_hd__decap_3
XFILLER_90_533 VGND VGND VPWR VPWR sky130_fd_sc_hd__decap_3
XTAP_TAPCELL_ROW_122_2001 VGND VPWR sky130_fd_sc_hd__tapvpwrvgnd_1
XTAP_TAPCELL_ROW_46_934 VGND VPWR sky130_fd_sc_hd__tapvpwrvgnd_1
XFILLER_35_449 VGND VGND VPWR VPWR sky130_fd_sc_hd__decap_3
XFILLER_16_663 VGND VGND VPWR VPWR sky130_fd_sc_hd__fill_1
XFILLER_30_132 VGND VGND VPWR VPWR sky130_fd_sc_hd__decap_3
XFILLER_129_532 VGND VGND VPWR VPWR sky130_fd_sc_hd__decap_3
XTAP_TAPCELL_ROW_100_1686 VGND VPWR sky130_fd_sc_hd__tapvpwrvgnd_1
XFILLER_117_727 VGND VGND VPWR VPWR sky130_fd_sc_hd__fill_1
XFILLER_129_576 VGND VGND VPWR VPWR sky130_fd_sc_hd__decap_3
XFILLER_7_42 VGND VGND VPWR VPWR sky130_fd_sc_hd__decap_3
XTAP_TAPCELL_ROW_100_1697 VGND VPWR sky130_fd_sc_hd__tapvpwrvgnd_1
X_4530_ _7706_/Q _3767_/A _4631_/A2 _7625_/Q _4514_/S VGND VGND VPWR VPWR _4530_/X
+ sky130_fd_sc_hd__o221a_2
XFILLER_117_738 VGND VGND VPWR VPWR sky130_fd_sc_hd__fill_1
XFILLER_7_75 VGND VGND VPWR VPWR sky130_fd_sc_hd__decap_3
XTAP_TAPCELL_ROW_133_2152 VGND VPWR sky130_fd_sc_hd__tapvpwrvgnd_1
X_4461_ _8438_/Q _8519_/Q _8600_/Q _8681_/Q _4554_/S _4503_/A VGND VGND VPWR VPWR
+ _4462_/B sky130_fd_sc_hd__mux4_2
XFILLER_132_719 VGND VGND VPWR VPWR sky130_fd_sc_hd__decap_3
X_7180_ _7188_/A1 _4945_/X _7187_/A3 _7187_/B1 hold886/X VGND VGND VPWR VPWR _8621_/D
+ sky130_fd_sc_hd__a32o_2
X_6200_ _6200_/A VGND VGND VPWR VPWR _8161_/D sky130_fd_sc_hd__buf_6
XFILLER_112_410 VGND VGND VPWR VPWR sky130_fd_sc_hd__decap_3
X_6131_ _8130_/Q _4924_/A _6137_/S VGND VGND VPWR VPWR _6132_/A sky130_fd_sc_hd__mux2_2
X_4392_ _8432_/Q _8513_/Q _8594_/Q _8675_/Q _4435_/S _4442_/A VGND VGND VPWR VPWR
+ _4393_/B sky130_fd_sc_hd__mux4_2
XFILLER_112_421 VGND VGND VPWR VPWR sky130_fd_sc_hd__decap_3
XFILLER_124_281 VGND VGND VPWR VPWR sky130_fd_sc_hd__decap_3
XFILLER_97_110 VGND VGND VPWR VPWR sky130_fd_sc_hd__fill_2
XTAP_TAPCELL_ROW_51_1007 VGND VPWR sky130_fd_sc_hd__tapvpwrvgnd_1
XFILLER_112_465 VGND VGND VPWR VPWR sky130_fd_sc_hd__decap_3
XFILLER_97_165 VGND VGND VPWR VPWR sky130_fd_sc_hd__decap_3
XFILLER_98_688 VGND VGND VPWR VPWR sky130_fd_sc_hd__decap_3
Xhold1006 _7620_/Q VGND VGND VPWR VPWR _5123_/A1 sky130_fd_sc_hd__dlygate4sd3_1
X_6062_ _8097_/Q _4786_/A _6074_/S VGND VGND VPWR VPWR _6063_/A sky130_fd_sc_hd__mux2_2
XFILLER_38_221 VGND VGND VPWR VPWR sky130_fd_sc_hd__decap_3
Xhold1017 _8062_/Q VGND VGND VPWR VPWR _5988_/A0 sky130_fd_sc_hd__dlygate4sd3_1
Xhold1028 _8230_/Q VGND VGND VPWR VPWR _6346_/A1 sky130_fd_sc_hd__dlygate4sd3_1
Xhold1039 _7540_/Q VGND VGND VPWR VPWR _4872_/A1 sky130_fd_sc_hd__dlygate4sd3_1
X_5013_ _5013_/A VGND VGND VPWR VPWR _7573_/D sky130_fd_sc_hd__buf_1
XFILLER_38_243 VGND VGND VPWR VPWR sky130_fd_sc_hd__decap_3
XFILLER_39_788 VGND VGND VPWR VPWR sky130_fd_sc_hd__fill_1
XFILLER_26_18 VGND VGND VPWR VPWR sky130_fd_sc_hd__decap_3
XFILLER_26_29 VGND VGND VPWR VPWR sky130_fd_sc_hd__decap_3
XFILLER_26_405 VGND VGND VPWR VPWR sky130_fd_sc_hd__fill_1
XFILLER_38_287 VGND VGND VPWR VPWR sky130_fd_sc_hd__decap_3
XFILLER_54_747 VGND VGND VPWR VPWR sky130_fd_sc_hd__decap_3
XFILLER_66_585 VGND VGND VPWR VPWR sky130_fd_sc_hd__decap_3
XFILLER_81_511 VGND VGND VPWR VPWR sky130_fd_sc_hd__decap_3
XFILLER_93_360 VGND VGND VPWR VPWR sky130_fd_sc_hd__decap_3
XFILLER_53_235 VGND VGND VPWR VPWR sky130_fd_sc_hd__decap_3
XFILLER_81_544 VGND VGND VPWR VPWR sky130_fd_sc_hd__fill_1
XFILLER_93_393 VGND VGND VPWR VPWR sky130_fd_sc_hd__fill_1
XPHY_EDGE_ROW_5_Right_5 VGND VGND VPWR VPWR sky130_fd_sc_hd__decap_3
X_6964_ _6964_/A VGND VGND VPWR VPWR _8520_/D sky130_fd_sc_hd__buf_6
XFILLER_81_588 VGND VGND VPWR VPWR sky130_fd_sc_hd__decap_3
X_8703_ _8792_/CLK _8703_/D fanout656/A VGND VGND VPWR VPWR _8703_/Q sky130_fd_sc_hd__dfrtp_2
X_6895_ _4727_/X _8488_/Q _6895_/S VGND VGND VPWR VPWR _6896_/A sky130_fd_sc_hd__mux2_4
X_5915_ _5907_/X _5908_/X _4795_/X _5909_/X hold860/X VGND VGND VPWR VPWR _8008_/D
+ sky130_fd_sc_hd__a32o_2
XTAP_TAPCELL_ROW_24_628 VGND VPWR sky130_fd_sc_hd__tapvpwrvgnd_1
X_8634_ _8634_/CLK _8634_/D fanout606/X VGND VGND VPWR VPWR _8634_/Q sky130_fd_sc_hd__dfrtp_2
X_5846_ _5846_/A VGND VGND VPWR VPWR _7960_/D sky130_fd_sc_hd__buf_1
XTAP_TAPCELL_ROW_62_1158 VGND VPWR sky130_fd_sc_hd__tapvpwrvgnd_1
X_8565_ _8646_/CLK _8565_/D fanout543/X VGND VGND VPWR VPWR _8565_/Q sky130_fd_sc_hd__dfrtp_2
X_5777_ _5777_/A VGND VGND VPWR VPWR _7927_/D sky130_fd_sc_hd__buf_1
X_8496_ _8736_/CLK _8496_/D fanout487/X VGND VGND VPWR VPWR _8496_/Q sky130_fd_sc_hd__dfrtp_2
X_7516_ _8743_/CLK _7516_/D fanout520/X VGND VGND VPWR VPWR _7516_/Q sky130_fd_sc_hd__dfrtp_2
X_4728_ _4727_/X _7506_/Q _4736_/S VGND VGND VPWR VPWR _4729_/A sky130_fd_sc_hd__mux2_2
XFILLER_107_204 VGND VGND VPWR VPWR sky130_fd_sc_hd__decap_3
XFILLER_108_749 VGND VGND VPWR VPWR sky130_fd_sc_hd__decap_3
XTAP_TAPCELL_ROW_118_1947 VGND VPWR sky130_fd_sc_hd__tapvpwrvgnd_1
X_7447_ _8780_/Q _4932_/A _7449_/S VGND VGND VPWR VPWR _7448_/A sky130_fd_sc_hd__mux2_2
X_4659_ _7717_/Q _3816_/X _4658_/X _4569_/A _3819_/X VGND VGND VPWR VPWR _4659_/X
+ sky130_fd_sc_hd__o221a_2
XFILLER_135_557 VGND VGND VPWR VPWR sky130_fd_sc_hd__decap_3
XPHY_EDGE_ROW_2_Left_138 VGND VGND VPWR VPWR sky130_fd_sc_hd__decap_3
XFILLER_116_793 VGND VGND VPWR VPWR sky130_fd_sc_hd__decap_3
Xhold840 _8033_/Q VGND VGND VPWR VPWR hold840/X sky130_fd_sc_hd__dlygate4sd3_1
Xhold851 _8003_/Q VGND VGND VPWR VPWR hold851/X sky130_fd_sc_hd__dlygate4sd3_1
Xhold862 _8672_/Q VGND VGND VPWR VPWR hold862/X sky130_fd_sc_hd__dlygate4sd3_1
Xhold873 _8028_/Q VGND VGND VPWR VPWR hold873/X sky130_fd_sc_hd__dlygate4sd3_1
X_7378_ _8747_/Q _4794_/A _7386_/S VGND VGND VPWR VPWR _7379_/A sky130_fd_sc_hd__mux2_2
XFILLER_107_54 VGND VGND VPWR VPWR sky130_fd_sc_hd__fill_2
XFILLER_115_281 VGND VGND VPWR VPWR sky130_fd_sc_hd__decap_3
XFILLER_131_741 VGND VGND VPWR VPWR sky130_fd_sc_hd__decap_3
Xhold884 _7997_/Q VGND VGND VPWR VPWR hold884/X sky130_fd_sc_hd__dlygate4sd3_1
Xhold895 _7974_/Q VGND VGND VPWR VPWR hold895/X sky130_fd_sc_hd__dlygate4sd3_1
X_6329_ _4973_/X _8222_/Q _6335_/S VGND VGND VPWR VPWR _6330_/A sky130_fd_sc_hd__mux2_2
XFILLER_103_476 VGND VGND VPWR VPWR sky130_fd_sc_hd__decap_3
XFILLER_107_87 VGND VGND VPWR VPWR sky130_fd_sc_hd__fill_1
XFILLER_130_251 VGND VGND VPWR VPWR sky130_fd_sc_hd__fill_1
XFILLER_130_262 VGND VGND VPWR VPWR sky130_fd_sc_hd__decap_3
XFILLER_131_774 VGND VGND VPWR VPWR sky130_fd_sc_hd__decap_3
XFILLER_131_785 VGND VGND VPWR VPWR sky130_fd_sc_hd__decap_3
XFILLER_49_508 VGND VGND VPWR VPWR sky130_fd_sc_hd__fill_2
XFILLER_67_69 VGND VGND VPWR VPWR sky130_fd_sc_hd__decap_3
XFILLER_69_390 VGND VGND VPWR VPWR sky130_fd_sc_hd__fill_2
XTAP_TAPCELL_ROW_4_342 VGND VPWR sky130_fd_sc_hd__tapvpwrvgnd_1
XFILLER_123_20 VGND VGND VPWR VPWR sky130_fd_sc_hd__decap_3
XFILLER_91_308 VGND VGND VPWR VPWR sky130_fd_sc_hd__fill_1
XTAP_TAPCELL_ROW_4_353 VGND VPWR sky130_fd_sc_hd__tapvpwrvgnd_1
XFILLER_123_75 VGND VGND VPWR VPWR sky130_fd_sc_hd__decap_3
XFILLER_45_725 VGND VGND VPWR VPWR sky130_fd_sc_hd__decap_3
XFILLER_17_449 VGND VGND VPWR VPWR sky130_fd_sc_hd__decap_3
XFILLER_45_747 VGND VGND VPWR VPWR sky130_fd_sc_hd__decap_3
XFILLER_72_533 VGND VGND VPWR VPWR sky130_fd_sc_hd__decap_3
XFILLER_83_57 VGND VGND VPWR VPWR sky130_fd_sc_hd__decap_3
XFILLER_16_62 VGND VGND VPWR VPWR sky130_fd_sc_hd__decap_3
XFILLER_60_728 VGND VGND VPWR VPWR sky130_fd_sc_hd__decap_3
XFILLER_40_430 VGND VGND VPWR VPWR sky130_fd_sc_hd__fill_1
XFILLER_9_615 VGND VGND VPWR VPWR sky130_fd_sc_hd__fill_1
XFILLER_9_626 VGND VGND VPWR VPWR sky130_fd_sc_hd__decap_3
XFILLER_12_165 VGND VGND VPWR VPWR sky130_fd_sc_hd__decap_3
XFILLER_12_176 VGND VGND VPWR VPWR sky130_fd_sc_hd__decap_3
XFILLER_13_688 VGND VGND VPWR VPWR sky130_fd_sc_hd__fill_1
XFILLER_8_125 VGND VGND VPWR VPWR sky130_fd_sc_hd__fill_2
XFILLER_9_659 VGND VGND VPWR VPWR sky130_fd_sc_hd__decap_3
XFILLER_126_502 VGND VGND VPWR VPWR sky130_fd_sc_hd__decap_3
XFILLER_32_50 VGND VGND VPWR VPWR sky130_fd_sc_hd__decap_3
XFILLER_8_147 VGND VGND VPWR VPWR sky130_fd_sc_hd__fill_1
XFILLER_8_169 VGND VGND VPWR VPWR sky130_fd_sc_hd__decap_3
XFILLER_126_557 VGND VGND VPWR VPWR sky130_fd_sc_hd__decap_3
XFILLER_122_741 VGND VGND VPWR VPWR sky130_fd_sc_hd__decap_3
XFILLER_122_752 VGND VGND VPWR VPWR sky130_fd_sc_hd__decap_3
XFILLER_122_763 VGND VGND VPWR VPWR sky130_fd_sc_hd__decap_3
XFILLER_79_154 VGND VGND VPWR VPWR sky130_fd_sc_hd__decap_3
XFILLER_95_636 VGND VGND VPWR VPWR sky130_fd_sc_hd__decap_3
XFILLER_48_585 VGND VGND VPWR VPWR sky130_fd_sc_hd__decap_3
XFILLER_57_91 VGND VGND VPWR VPWR sky130_fd_sc_hd__decap_3
XFILLER_75_382 VGND VGND VPWR VPWR sky130_fd_sc_hd__fill_1
XFILLER_94_179 VGND VGND VPWR VPWR sky130_fd_sc_hd__decap_3
XFILLER_75_393 VGND VGND VPWR VPWR sky130_fd_sc_hd__decap_3
XFILLER_90_341 VGND VGND VPWR VPWR sky130_fd_sc_hd__decap_3
XFILLER_35_279 VGND VGND VPWR VPWR sky130_fd_sc_hd__fill_1
X_3961_ _8717_/Q _8798_/Q _7573_/Q _7654_/Q _3957_/S _4552_/A1 VGND VGND VPWR VPWR
+ _3962_/B sky130_fd_sc_hd__mux4_2
XFILLER_50_249 VGND VGND VPWR VPWR sky130_fd_sc_hd__decap_3
XFILLER_73_90 VGND VGND VPWR VPWR sky130_fd_sc_hd__decap_3
XTAP_TAPCELL_ROW_102_1715 VGND VPWR sky130_fd_sc_hd__tapvpwrvgnd_1
XTAP_TAPCELL_ROW_102_1726 VGND VPWR sky130_fd_sc_hd__tapvpwrvgnd_1
X_5700_ _7891_/Q _4985_/A _5700_/S VGND VGND VPWR VPWR _5701_/A sky130_fd_sc_hd__mux2_2
XFILLER_92_3 VGND VGND VPWR VPWR sky130_fd_sc_hd__decap_3
X_3892_ _7729_/Q _7810_/Q _7891_/Q _7972_/Q _3887_/S _3888_/A VGND VGND VPWR VPWR
+ _3892_/X sky130_fd_sc_hd__mux4_2
X_6680_ _6680_/A VGND VGND VPWR VPWR _8386_/D sky130_fd_sc_hd__buf_2
XTAP_TAPCELL_ROW_135_2203 VGND VPWR sky130_fd_sc_hd__tapvpwrvgnd_1
X_5631_ _7859_/Q _4849_/A _5633_/S VGND VGND VPWR VPWR _5632_/A sky130_fd_sc_hd__mux2_2
XFILLER_129_340 VGND VGND VPWR VPWR sky130_fd_sc_hd__decap_3
XFILLER_129_362 VGND VGND VPWR VPWR sky130_fd_sc_hd__decap_3
X_8350_ _8756_/CLK _8350_/D wire701/X VGND VGND VPWR VPWR _8350_/Q sky130_fd_sc_hd__dfrtp_2
X_5562_ _7826_/Q _4711_/A _5570_/S VGND VGND VPWR VPWR _5563_/A sky130_fd_sc_hd__mux2_2
XFILLER_8_681 VGND VGND VPWR VPWR sky130_fd_sc_hd__decap_3
X_8281_ _8770_/CLK _8281_/D fanout553/X VGND VGND VPWR VPWR _8281_/Q sky130_fd_sc_hd__dfrtp_2
X_7301_ _7301_/A VGND VGND VPWR VPWR _8710_/D sky130_fd_sc_hd__buf_1
X_4513_ _8767_/Q _7542_/Q _7623_/Q _7704_/Q _3716_/A _3705_/C VGND VGND VPWR VPWR
+ _4513_/X sky130_fd_sc_hd__mux4_2
X_7232_ _7239_/A1 _4773_/X _7230_/X _7231_/X hold767/X VGND VGND VPWR VPWR _8661_/D
+ sky130_fd_sc_hd__a32o_2
X_5493_ _7794_/Q _4916_/A _5503_/S VGND VGND VPWR VPWR _5494_/A sky130_fd_sc_hd__mux2_2
XFILLER_104_218 VGND VGND VPWR VPWR sky130_fd_sc_hd__decap_3
XFILLER_132_516 VGND VGND VPWR VPWR sky130_fd_sc_hd__decap_3
X_4444_ _4444_/A1 _4442_/X _4443_/X _4510_/A1 VGND VGND VPWR VPWR _4444_/X sky130_fd_sc_hd__a31o_2
X_7163_ _7163_/A VGND VGND VPWR VPWR _8614_/D sky130_fd_sc_hd__buf_2
X_4375_ _8016_/Q _3969_/X _4374_/X VGND VGND VPWR VPWR _4375_/X sky130_fd_sc_hd__o21a_2
XFILLER_113_785 VGND VGND VPWR VPWR sky130_fd_sc_hd__decap_3
XTAP_TAPCELL_ROW_113_1877 VGND VPWR sky130_fd_sc_hd__tapvpwrvgnd_1
Xfanout627 fanout629/X VGND VGND VPWR VPWR fanout627/X sky130_fd_sc_hd__clkdlybuf4s25_1
X_7094_ _7094_/A VGND VGND VPWR VPWR _8581_/D sky130_fd_sc_hd__buf_2
X_6114_ _8122_/Q _4890_/A _6116_/S VGND VGND VPWR VPWR _6115_/A sky130_fd_sc_hd__mux2_2
XFILLER_100_424 VGND VGND VPWR VPWR sky130_fd_sc_hd__decap_3
XFILLER_112_273 VGND VGND VPWR VPWR sky130_fd_sc_hd__decap_3
XFILLER_85_124 VGND VGND VPWR VPWR sky130_fd_sc_hd__decap_3
X_6045_ _8089_/Q _4752_/A _6053_/S VGND VGND VPWR VPWR _6046_/A sky130_fd_sc_hd__mux2_2
XFILLER_100_457 VGND VGND VPWR VPWR sky130_fd_sc_hd__fill_1
XFILLER_86_669 VGND VGND VPWR VPWR sky130_fd_sc_hd__decap_3
XFILLER_54_500 VGND VGND VPWR VPWR sky130_fd_sc_hd__decap_3
XFILLER_66_371 VGND VGND VPWR VPWR sky130_fd_sc_hd__decap_3
XTAP_TAPCELL_ROW_1_301 VGND VPWR sky130_fd_sc_hd__tapvpwrvgnd_1
XTAP_TAPCELL_ROW_1_312 VGND VPWR sky130_fd_sc_hd__tapvpwrvgnd_1
XFILLER_26_246 VGND VGND VPWR VPWR sky130_fd_sc_hd__decap_3
XFILLER_27_769 VGND VGND VPWR VPWR sky130_fd_sc_hd__decap_3
XFILLER_14_419 VGND VGND VPWR VPWR sky130_fd_sc_hd__fill_1
XFILLER_26_268 VGND VGND VPWR VPWR sky130_fd_sc_hd__decap_3
X_7996_ _8735_/CLK _7996_/D load_slew536/X VGND VGND VPWR VPWR _7996_/Q sky130_fd_sc_hd__dfrtp_2
X_6947_ _6947_/A VGND VGND VPWR VPWR _8512_/D sky130_fd_sc_hd__buf_6
X_6878_ _6878_/A VGND VGND VPWR VPWR _8479_/D sky130_fd_sc_hd__buf_6
XFILLER_10_625 VGND VGND VPWR VPWR sky130_fd_sc_hd__decap_3
XFILLER_22_463 VGND VGND VPWR VPWR sky130_fd_sc_hd__decap_3
XFILLER_22_474 VGND VGND VPWR VPWR sky130_fd_sc_hd__fill_2
X_8617_ _8698_/CLK _8617_/D load_slew748/X VGND VGND VPWR VPWR _8617_/Q sky130_fd_sc_hd__dfrtp_2
X_5829_ _7952_/Q _4899_/A _5847_/S VGND VGND VPWR VPWR _5830_/A sky130_fd_sc_hd__mux2_2
XFILLER_10_669 VGND VGND VPWR VPWR sky130_fd_sc_hd__decap_3
XFILLER_6_607 VGND VGND VPWR VPWR sky130_fd_sc_hd__decap_3
X_8548_ _8622_/CLK _8548_/D load_slew661/X VGND VGND VPWR VPWR _8548_/Q sky130_fd_sc_hd__dfrtp_2
XFILLER_5_128 VGND VGND VPWR VPWR sky130_fd_sc_hd__decap_3
XFILLER_108_546 VGND VGND VPWR VPWR sky130_fd_sc_hd__fill_1
XFILLER_135_354 VGND VGND VPWR VPWR sky130_fd_sc_hd__fill_1
X_8479_ _8560_/CLK _8479_/D _8053_/SET_B VGND VGND VPWR VPWR _8479_/Q sky130_fd_sc_hd__dfrtp_2
XFILLER_135_365 VGND VGND VPWR VPWR sky130_fd_sc_hd__decap_3
XTAP_TAPCELL_ROW_75_1338 VGND VPWR sky130_fd_sc_hd__tapvpwrvgnd_1
XTAP_TAPCELL_ROW_75_1349 VGND VPWR sky130_fd_sc_hd__tapvpwrvgnd_1
XTAP_TAPCELL_ROW_9_412 VGND VPWR sky130_fd_sc_hd__tapvpwrvgnd_1
XTAP_TAPCELL_ROW_9_423 VGND VPWR sky130_fd_sc_hd__tapvpwrvgnd_1
XFILLER_123_538 VGND VGND VPWR VPWR sky130_fd_sc_hd__fill_1
XFILLER_103_251 VGND VGND VPWR VPWR sky130_fd_sc_hd__decap_3
XFILLER_1_367 VGND VGND VPWR VPWR sky130_fd_sc_hd__decap_3
XFILLER_77_614 VGND VGND VPWR VPWR sky130_fd_sc_hd__fill_2
XFILLER_131_582 VGND VGND VPWR VPWR sky130_fd_sc_hd__decap_3
XFILLER_134_41 VGND VGND VPWR VPWR sky130_fd_sc_hd__decap_3
XFILLER_89_496 VGND VGND VPWR VPWR sky130_fd_sc_hd__decap_3
XFILLER_134_74 VGND VGND VPWR VPWR sky130_fd_sc_hd__decap_3
XFILLER_134_85 VGND VGND VPWR VPWR sky130_fd_sc_hd__decap_3
XFILLER_49_349 VGND VGND VPWR VPWR sky130_fd_sc_hd__decap_3
XFILLER_76_157 VGND VGND VPWR VPWR sky130_fd_sc_hd__decap_3
XFILLER_92_617 VGND VGND VPWR VPWR sky130_fd_sc_hd__decap_3
XFILLER_17_202 VGND VGND VPWR VPWR sky130_fd_sc_hd__decap_3
XFILLER_45_500 VGND VGND VPWR VPWR sky130_fd_sc_hd__decap_3
XFILLER_94_67 VGND VGND VPWR VPWR sky130_fd_sc_hd__fill_2
XFILLER_94_78 VGND VGND VPWR VPWR sky130_fd_sc_hd__decap_3
XFILLER_27_72 VGND VGND VPWR VPWR sky130_fd_sc_hd__decap_3
XFILLER_72_330 VGND VGND VPWR VPWR sky130_fd_sc_hd__decap_3
XFILLER_60_536 VGND VGND VPWR VPWR sky130_fd_sc_hd__decap_3
XFILLER_13_441 VGND VGND VPWR VPWR sky130_fd_sc_hd__decap_3
XFILLER_13_452 VGND VGND VPWR VPWR sky130_fd_sc_hd__decap_3
XFILLER_41_794 VGND VGND VPWR VPWR sky130_fd_sc_hd__fill_2
XFILLER_43_60 VGND VGND VPWR VPWR sky130_fd_sc_hd__decap_3
XFILLER_127_800 VGND VGND VPWR VPWR sky130_fd_sc_hd__decap_3
XFILLER_40_293 VGND VGND VPWR VPWR sky130_fd_sc_hd__fill_2
Xclkbuf_leaf_139_CLK clkbuf_5_4__f_CLK/X VGND VGND VPWR VPWR _8739_/CLK sky130_fd_sc_hd__clkbuf_8
XFILLER_126_321 VGND VGND VPWR VPWR sky130_fd_sc_hd__decap_3
XFILLER_126_365 VGND VGND VPWR VPWR sky130_fd_sc_hd__decap_3
XFILLER_4_150 VGND VGND VPWR VPWR sky130_fd_sc_hd__decap_3
XFILLER_5_662 VGND VGND VPWR VPWR sky130_fd_sc_hd__decap_3
XFILLER_5_673 VGND VGND VPWR VPWR sky130_fd_sc_hd__decap_3
XFILLER_99_216 VGND VGND VPWR VPWR sky130_fd_sc_hd__decap_3
XTAP_TAPCELL_ROW_130_2111 VGND VPWR sky130_fd_sc_hd__tapvpwrvgnd_1
XFILLER_4_21 VGND VGND VPWR VPWR sky130_fd_sc_hd__decap_3
XFILLER_4_32 VGND VGND VPWR VPWR sky130_fd_sc_hd__decap_3
XFILLER_4_65 VGND VGND VPWR VPWR sky130_fd_sc_hd__decap_3
X_4160_ _7916_/Q _4160_/B VGND VGND VPWR VPWR _4160_/X sky130_fd_sc_hd__or2_2
XFILLER_67_113 VGND VGND VPWR VPWR sky130_fd_sc_hd__decap_3
XFILLER_110_744 VGND VGND VPWR VPWR sky130_fd_sc_hd__decap_3
XFILLER_110_777 VGND VGND VPWR VPWR sky130_fd_sc_hd__decap_3
XFILLER_95_455 VGND VGND VPWR VPWR sky130_fd_sc_hd__decap_3
X_4091_ _8405_/Q _8486_/Q _8567_/Q _8648_/Q _4091_/S0 _4091_/S1 VGND VGND VPWR VPWR
+ _4091_/X sky130_fd_sc_hd__mux4_2
XFILLER_36_511 VGND VGND VPWR VPWR sky130_fd_sc_hd__decap_3
XFILLER_48_371 VGND VGND VPWR VPWR sky130_fd_sc_hd__decap_3
XFILLER_67_179 VGND VGND VPWR VPWR sky130_fd_sc_hd__decap_3
XFILLER_83_617 VGND VGND VPWR VPWR sky130_fd_sc_hd__fill_2
XTAP_TAPCELL_ROW_128_2084 VGND VPWR sky130_fd_sc_hd__tapvpwrvgnd_1
XFILLER_36_533 VGND VGND VPWR VPWR sky130_fd_sc_hd__fill_1
XFILLER_76_691 VGND VGND VPWR VPWR sky130_fd_sc_hd__decap_3
X_7850_ _8744_/CLK _7850_/D load_slew626/X VGND VGND VPWR VPWR _7850_/Q sky130_fd_sc_hd__dfrtp_2
XFILLER_36_566 VGND VGND VPWR VPWR sky130_fd_sc_hd__fill_2
XFILLER_36_577 VGND VGND VPWR VPWR sky130_fd_sc_hd__decap_3
X_6801_ _8444_/Q _4882_/A _6807_/S VGND VGND VPWR VPWR _6802_/A sky130_fd_sc_hd__mux2_2
XFILLER_90_182 VGND VGND VPWR VPWR sky130_fd_sc_hd__decap_3
XFILLER_91_694 VGND VGND VPWR VPWR sky130_fd_sc_hd__decap_3
X_7781_ _8763_/CLK _7781_/D fanout559/X VGND VGND VPWR VPWR _7781_/Q sky130_fd_sc_hd__dfrtp_2
X_4993_ _5970_/B VGND VGND VPWR VPWR _5030_/B sky130_fd_sc_hd__clkbuf_1
XFILLER_51_569 VGND VGND VPWR VPWR sky130_fd_sc_hd__decap_3
XTAP_TAPCELL_ROW_34_767 VGND VPWR sky130_fd_sc_hd__tapvpwrvgnd_1
X_3944_ _7734_/Q _7815_/Q _4367_/S VGND VGND VPWR VPWR _3945_/B sky130_fd_sc_hd__mux2_2
X_6732_ _8411_/Q _4744_/A _6744_/S VGND VGND VPWR VPWR _6733_/A sky130_fd_sc_hd__mux2_2
XPHY_EDGE_ROW_83_Left_219 VGND VGND VPWR VPWR sky130_fd_sc_hd__decap_3
X_3875_ _3875_/A _3875_/B VGND VGND VPWR VPWR _3875_/X sky130_fd_sc_hd__or2_2
X_6663_ _8378_/Q input3/X _6681_/S VGND VGND VPWR VPWR _6664_/A sky130_fd_sc_hd__mux2_2
XTAP_TAPCELL_ROW_14_491 VGND VPWR sky130_fd_sc_hd__tapvpwrvgnd_1
X_8402_ _8483_/CLK _8402_/D fanout506/X VGND VGND VPWR VPWR _8402_/Q sky130_fd_sc_hd__dfrtp_2
X_5614_ _5677_/S VGND VGND VPWR VPWR _5633_/S sky130_fd_sc_hd__buf_2
X_6594_ _4815_/X _8347_/Q _6612_/S VGND VGND VPWR VPWR _6595_/A sky130_fd_sc_hd__mux2_2
XFILLER_129_181 VGND VGND VPWR VPWR sky130_fd_sc_hd__decap_3
XFILLER_133_803 VGND VGND VPWR VPWR sky130_fd_sc_hd__fill_1
XTAP_TAPCELL_ROW_115_1906 VGND VPWR sky130_fd_sc_hd__tapvpwrvgnd_1
X_8333_ _8660_/CLK _8333_/D load_slew515/X VGND VGND VPWR VPWR _8333_/Q sky130_fd_sc_hd__dfrtp_2
X_5545_ _7818_/Q _5019_/A _5549_/S VGND VGND VPWR VPWR _5546_/A sky130_fd_sc_hd__mux2_2
XFILLER_105_505 VGND VGND VPWR VPWR sky130_fd_sc_hd__fill_1
XFILLER_117_376 VGND VGND VPWR VPWR sky130_fd_sc_hd__fill_1
XFILLER_2_109 VGND VGND VPWR VPWR sky130_fd_sc_hd__decap_3
X_8264_ _8793_/CLK _8264_/D load_slew640/X VGND VGND VPWR VPWR _8264_/Q sky130_fd_sc_hd__dfrtp_2
X_5476_ _7786_/Q _4882_/A _5482_/S VGND VGND VPWR VPWR _5477_/A sky130_fd_sc_hd__mux2_2
XFILLER_105_538 VGND VGND VPWR VPWR sky130_fd_sc_hd__decap_3
XFILLER_132_346 VGND VGND VPWR VPWR sky130_fd_sc_hd__decap_3
X_8195_ _8798_/CLK _8195_/D wire600/X VGND VGND VPWR VPWR _8195_/Q sky130_fd_sc_hd__dfrtp_2
X_7215_ _7267_/A VGND VGND VPWR VPWR _7215_/X sky130_fd_sc_hd__clkbuf_1
X_4427_ _7696_/Q _4652_/A2 _4648_/B1 _7615_/Q _3819_/X VGND VGND VPWR VPWR _4427_/X
+ sky130_fd_sc_hd__o221a_2
XFILLER_120_519 VGND VGND VPWR VPWR sky130_fd_sc_hd__decap_3
XFILLER_132_368 VGND VGND VPWR VPWR sky130_fd_sc_hd__fill_2
XFILLER_132_379 VGND VGND VPWR VPWR sky130_fd_sc_hd__decap_3
XPHY_EDGE_ROW_92_Left_228 VGND VGND VPWR VPWR sky130_fd_sc_hd__decap_3
Xfanout413 fanout414/X VGND VGND VPWR VPWR _4209_/S sky130_fd_sc_hd__clkdlybuf4s25_1
X_7146_ _7146_/A VGND VGND VPWR VPWR _8606_/D sky130_fd_sc_hd__buf_2
XFILLER_48_27 VGND VGND VPWR VPWR sky130_fd_sc_hd__fill_1
XFILLER_58_124 VGND VGND VPWR VPWR sky130_fd_sc_hd__decap_3
XFILLER_99_794 VGND VGND VPWR VPWR sky130_fd_sc_hd__fill_2
Xfanout424 fanout433/X VGND VGND VPWR VPWR _4524_/S0 sky130_fd_sc_hd__clkdlybuf4s25_1
Xfanout457 fanout474/X VGND VGND VPWR VPWR _4441_/S sky130_fd_sc_hd__clkdlybuf4s25_1
X_4358_ _4442_/A _4356_/X _4357_/X VGND VGND VPWR VPWR _4358_/X sky130_fd_sc_hd__o21a_2
XFILLER_100_221 VGND VGND VPWR VPWR sky130_fd_sc_hd__decap_3
XTAP_TAPCELL_ROW_70_1268 VGND VPWR sky130_fd_sc_hd__tapvpwrvgnd_1
XTAP_TAPCELL_ROW_70_1279 VGND VPWR sky130_fd_sc_hd__tapvpwrvgnd_1
Xfanout468 _4632_/S VGND VGND VPWR VPWR _4579_/S sky130_fd_sc_hd__clkdlybuf4s25_1
Xfanout479 fanout479/A VGND VGND VPWR VPWR fanout479/X sky130_fd_sc_hd__clkdlybuf4s25_1
X_7077_ _7077_/A VGND VGND VPWR VPWR _8573_/D sky130_fd_sc_hd__buf_2
X_4289_ _4666_/A1 _4280_/X _4283_/X _4288_/X VGND VGND VPWR VPWR _4289_/X sky130_fd_sc_hd__o31a_2
XFILLER_58_168 VGND VGND VPWR VPWR sky130_fd_sc_hd__decap_3
XFILLER_73_116 VGND VGND VPWR VPWR sky130_fd_sc_hd__decap_3
XFILLER_74_617 VGND VGND VPWR VPWR sky130_fd_sc_hd__decap_3
XFILLER_74_628 VGND VGND VPWR VPWR sky130_fd_sc_hd__decap_3
X_6028_ _8081_/Q _4718_/A _6032_/S VGND VGND VPWR VPWR _6029_/A sky130_fd_sc_hd__mux2_2
XFILLER_100_287 VGND VGND VPWR VPWR sky130_fd_sc_hd__decap_3
XFILLER_27_522 VGND VGND VPWR VPWR sky130_fd_sc_hd__decap_3
XFILLER_39_393 VGND VGND VPWR VPWR sky130_fd_sc_hd__decap_3
XFILLER_54_330 VGND VGND VPWR VPWR sky130_fd_sc_hd__decap_3
XFILLER_120_10 VGND VGND VPWR VPWR sky130_fd_sc_hd__decap_3
XFILLER_54_374 VGND VGND VPWR VPWR sky130_fd_sc_hd__decap_3
XFILLER_54_396 VGND VGND VPWR VPWR sky130_fd_sc_hd__decap_3
X_7979_ _8719_/CLK _7979_/D load_slew591/X VGND VGND VPWR VPWR _7979_/Q sky130_fd_sc_hd__dfrtp_2
XFILLER_23_794 VGND VGND VPWR VPWR sky130_fd_sc_hd__fill_2
XFILLER_80_25 VGND VGND VPWR VPWR sky130_fd_sc_hd__decap_3
XFILLER_10_444 VGND VGND VPWR VPWR sky130_fd_sc_hd__decap_3
XFILLER_128_619 VGND VGND VPWR VPWR sky130_fd_sc_hd__decap_3
XFILLER_13_30 VGND VGND VPWR VPWR sky130_fd_sc_hd__decap_3
XFILLER_22_271 VGND VGND VPWR VPWR sky130_fd_sc_hd__decap_3
XFILLER_129_30 VGND VGND VPWR VPWR sky130_fd_sc_hd__decap_3
XFILLER_13_63 VGND VGND VPWR VPWR sky130_fd_sc_hd__decap_3
XFILLER_6_415 VGND VGND VPWR VPWR sky130_fd_sc_hd__decap_3
XFILLER_129_63 VGND VGND VPWR VPWR sky130_fd_sc_hd__decap_3
XFILLER_124_803 VGND VGND VPWR VPWR sky130_fd_sc_hd__fill_1
XFILLER_129_96 VGND VGND VPWR VPWR sky130_fd_sc_hd__decap_3
XFILLER_135_184 VGND VGND VPWR VPWR sky130_fd_sc_hd__decap_3
XFILLER_2_610 VGND VGND VPWR VPWR sky130_fd_sc_hd__decap_3
XFILLER_97_709 VGND VGND VPWR VPWR sky130_fd_sc_hd__decap_3
XFILLER_111_508 VGND VGND VPWR VPWR sky130_fd_sc_hd__decap_3
XFILLER_2_643 VGND VGND VPWR VPWR sky130_fd_sc_hd__fill_1
XFILLER_2_654 VGND VGND VPWR VPWR sky130_fd_sc_hd__decap_3
XFILLER_104_571 VGND VGND VPWR VPWR sky130_fd_sc_hd__decap_3
XFILLER_2_687 VGND VGND VPWR VPWR sky130_fd_sc_hd__decap_3
XFILLER_65_606 VGND VGND VPWR VPWR sky130_fd_sc_hd__decap_3
XFILLER_77_433 VGND VGND VPWR VPWR sky130_fd_sc_hd__decap_3
XFILLER_89_293 VGND VGND VPWR VPWR sky130_fd_sc_hd__fill_1
XFILLER_18_500 VGND VGND VPWR VPWR sky130_fd_sc_hd__decap_3
XFILLER_65_617 VGND VGND VPWR VPWR sky130_fd_sc_hd__fill_2
XTAP_TAPCELL_ROW_88_1518 VGND VPWR sky130_fd_sc_hd__tapvpwrvgnd_1
XTAP_TAPCELL_ROW_88_1529 VGND VPWR sky130_fd_sc_hd__tapvpwrvgnd_1
XFILLER_18_522 VGND VGND VPWR VPWR sky130_fd_sc_hd__fill_1
XFILLER_18_533 VGND VGND VPWR VPWR sky130_fd_sc_hd__decap_3
XFILLER_38_82 VGND VGND VPWR VPWR sky130_fd_sc_hd__fill_2
XFILLER_45_330 VGND VGND VPWR VPWR sky130_fd_sc_hd__fill_2
XFILLER_92_436 VGND VGND VPWR VPWR sky130_fd_sc_hd__fill_2
XFILLER_61_801 VGND VGND VPWR VPWR sky130_fd_sc_hd__decap_3
XFILLER_33_536 VGND VGND VPWR VPWR sky130_fd_sc_hd__decap_3
XFILLER_45_396 VGND VGND VPWR VPWR sky130_fd_sc_hd__decap_3
XFILLER_14_750 VGND VGND VPWR VPWR sky130_fd_sc_hd__fill_2
XFILLER_54_81 VGND VGND VPWR VPWR sky130_fd_sc_hd__decap_3
XTAP_TAPCELL_ROW_31_726 VGND VPWR sky130_fd_sc_hd__tapvpwrvgnd_1
XFILLER_13_293 VGND VGND VPWR VPWR sky130_fd_sc_hd__decap_3
XTAP_TAPCELL_ROW_11_450 VGND VPWR sky130_fd_sc_hd__tapvpwrvgnd_1
XFILLER_9_297 VGND VGND VPWR VPWR sky130_fd_sc_hd__decap_3
Xclkbuf_5_22__f_CLK clkbuf_4_11_0_CLK/X VGND VGND VPWR VPWR clkbuf_leaf_99_CLK/A sky130_fd_sc_hd__clkbuf_16
Xclkload12 _8729_/CLK VGND VGND VPWR VPWR clkload12/X sky130_fd_sc_hd__clkbuf_4
Xclkload23 _8743_/CLK VGND VGND VPWR VPWR clkload23/X sky130_fd_sc_hd__clkbuf_4
Xclkload34 _8029_/CLK VGND VGND VPWR VPWR clkload34/X sky130_fd_sc_hd__clkbuf_4
XFILLER_127_685 VGND VGND VPWR VPWR sky130_fd_sc_hd__decap_3
XFILLER_55_3 VGND VGND VPWR VPWR sky130_fd_sc_hd__decap_3
Xclkload45 _8670_/CLK VGND VGND VPWR VPWR clkload45/X sky130_fd_sc_hd__clkbuf_8
Xclkload56 _8462_/CLK VGND VGND VPWR VPWR clkload56/Y sky130_fd_sc_hd__inv_4
Xclkload67 _8274_/CLK VGND VGND VPWR VPWR clkload67/X sky130_fd_sc_hd__clkbuf_8
Xclkload78 _8450_/CLK VGND VGND VPWR VPWR clkload78/Y sky130_fd_sc_hd__bufinv_16
X_5330_ _5330_/A VGND VGND VPWR VPWR _7717_/D sky130_fd_sc_hd__buf_1
X_5261_ _5261_/A VGND VGND VPWR VPWR _7684_/D sky130_fd_sc_hd__buf_1
XFILLER_102_508 VGND VGND VPWR VPWR sky130_fd_sc_hd__decap_3
XFILLER_102_519 VGND VGND VPWR VPWR sky130_fd_sc_hd__decap_3
XFILLER_114_368 VGND VGND VPWR VPWR sky130_fd_sc_hd__fill_1
X_7000_ _4937_/X _8538_/Q _7000_/S VGND VGND VPWR VPWR _7001_/A sky130_fd_sc_hd__mux2_4
X_4212_ _8416_/Q _8497_/Q _8578_/Q _8659_/Q _4209_/S _4151_/A VGND VGND VPWR VPWR
+ _4212_/X sky130_fd_sc_hd__mux4_2
XFILLER_96_731 VGND VGND VPWR VPWR sky130_fd_sc_hd__fill_1
XTAP_TAPCELL_ROW_110_1836 VGND VPWR sky130_fd_sc_hd__tapvpwrvgnd_1
X_5192_ _5192_/A VGND VGND VPWR VPWR _7651_/D sky130_fd_sc_hd__buf_1
XFILLER_110_552 VGND VGND VPWR VPWR sky130_fd_sc_hd__decap_3
X_4143_ _4231_/A _4139_/X _4141_/X _4142_/X _3735_/X VGND VGND VPWR VPWR _4143_/X
+ sky130_fd_sc_hd__a221o_2
XFILLER_68_477 VGND VGND VPWR VPWR sky130_fd_sc_hd__decap_3
X_4074_ _7746_/Q _7827_/Q _4074_/S VGND VGND VPWR VPWR _4075_/B sky130_fd_sc_hd__mux2_2
XFILLER_49_691 VGND VGND VPWR VPWR sky130_fd_sc_hd__decap_3
XFILLER_83_447 VGND VGND VPWR VPWR sky130_fd_sc_hd__fill_1
XFILLER_95_296 VGND VGND VPWR VPWR sky130_fd_sc_hd__decap_3
XTAP_TAPCELL_ROW_39_837 VGND VPWR sky130_fd_sc_hd__tapvpwrvgnd_1
X_7902_ _8731_/CLK _7902_/D load_slew496/X VGND VGND VPWR VPWR _7902_/Q sky130_fd_sc_hd__dfrtp_2
XFILLER_36_374 VGND VGND VPWR VPWR sky130_fd_sc_hd__decap_3
XTAP_TAPCELL_ROW_108_1798 VGND VPWR sky130_fd_sc_hd__tapvpwrvgnd_1
XTAP_TAPCELL_ROW_19_561 VGND VPWR sky130_fd_sc_hd__tapvpwrvgnd_1
X_7833_ _8410_/CLK _7833_/D load_slew524/X VGND VGND VPWR VPWR _7833_/Q sky130_fd_sc_hd__dfrtp_2
XFILLER_24_569 VGND VGND VPWR VPWR sky130_fd_sc_hd__fill_2
XFILLER_34_29 VGND VGND VPWR VPWR sky130_fd_sc_hd__fill_1
XFILLER_51_355 VGND VGND VPWR VPWR sky130_fd_sc_hd__fill_1
X_7764_ _8662_/CLK _7764_/D load_slew621/X VGND VGND VPWR VPWR _7764_/Q sky130_fd_sc_hd__dfrtp_2
XFILLER_51_377 VGND VGND VPWR VPWR sky130_fd_sc_hd__decap_3
XTAP_TAPCELL_ROW_121_1987 VGND VPWR sky130_fd_sc_hd__tapvpwrvgnd_1
X_6715_ _8403_/Q _4710_/A _6723_/S VGND VGND VPWR VPWR _6716_/A sky130_fd_sc_hd__mux2_2
X_4976_ _4976_/A _4988_/B VGND VGND VPWR VPWR _4977_/A sky130_fd_sc_hd__and2_2
X_3927_ _4510_/A1 _3926_/X _3732_/X VGND VGND VPWR VPWR _3927_/X sky130_fd_sc_hd__o21a_2
X_7695_ _8676_/CLK _7695_/D load_slew699/X VGND VGND VPWR VPWR _7695_/Q sky130_fd_sc_hd__dfrtp_2
XFILLER_126_9 VGND VGND VPWR VPWR sky130_fd_sc_hd__decap_3
XFILLER_20_786 VGND VGND VPWR VPWR sky130_fd_sc_hd__fill_2
X_3858_ _7646_/Q _3939_/A _4065_/A _7565_/Q _3890_/A VGND VGND VPWR VPWR _3858_/X
+ sky130_fd_sc_hd__o221a_2
Xclkload6 clkload6/A VGND VGND VPWR VPWR clkload6/X sky130_fd_sc_hd__clkbuf_8
X_6646_ _4921_/X _8372_/Q _6654_/S VGND VGND VPWR VPWR _6647_/A sky130_fd_sc_hd__mux2_2
XTAP_TAPCELL_ROW_59_1119 VGND VPWR sky130_fd_sc_hd__tapvpwrvgnd_1
X_3789_ _3783_/X _3787_/X _3788_/X _3827_/A1 VGND VGND VPWR VPWR _3789_/X sky130_fd_sc_hd__a22o_2
X_6577_ _4782_/X _8339_/Q _6591_/S VGND VGND VPWR VPWR _6578_/A sky130_fd_sc_hd__mux2_2
XFILLER_106_803 VGND VGND VPWR VPWR sky130_fd_sc_hd__fill_1
XFILLER_117_140 VGND VGND VPWR VPWR sky130_fd_sc_hd__fill_1
XFILLER_118_685 VGND VGND VPWR VPWR sky130_fd_sc_hd__decap_3
XFILLER_133_600 VGND VGND VPWR VPWR sky130_fd_sc_hd__decap_3
X_8316_ _8335_/CLK _8316_/D load_slew541/X VGND VGND VPWR VPWR _8316_/Q sky130_fd_sc_hd__dfrtp_2
X_5528_ _7810_/Q _4985_/A _5528_/S VGND VGND VPWR VPWR _5529_/A sky130_fd_sc_hd__mux2_2
XFILLER_132_121 VGND VGND VPWR VPWR sky130_fd_sc_hd__decap_3
XFILLER_133_644 VGND VGND VPWR VPWR sky130_fd_sc_hd__decap_3
X_8247_ _8733_/CLK _8247_/D fanout475/A VGND VGND VPWR VPWR _8247_/Q sky130_fd_sc_hd__dfrtp_2
X_5459_ _7778_/Q _4848_/A _5461_/S VGND VGND VPWR VPWR _5460_/A sky130_fd_sc_hd__mux2_2
XFILLER_120_327 VGND VGND VPWR VPWR sky130_fd_sc_hd__decap_3
XFILLER_132_165 VGND VGND VPWR VPWR sky130_fd_sc_hd__decap_3
XFILLER_133_688 VGND VGND VPWR VPWR sky130_fd_sc_hd__decap_3
XFILLER_99_591 VGND VGND VPWR VPWR sky130_fd_sc_hd__decap_3
X_8178_ _8751_/CLK _8178_/D wire618/X VGND VGND VPWR VPWR _8178_/Q sky130_fd_sc_hd__dfrtp_2
X_7129_ _7129_/A VGND VGND VPWR VPWR _8598_/D sky130_fd_sc_hd__buf_2
XFILLER_101_585 VGND VGND VPWR VPWR sky130_fd_sc_hd__decap_3
XFILLER_47_617 VGND VGND VPWR VPWR sky130_fd_sc_hd__decap_3
XFILLER_47_639 VGND VGND VPWR VPWR sky130_fd_sc_hd__fill_1
XFILLER_75_36 VGND VGND VPWR VPWR sky130_fd_sc_hd__decap_3
Xfanout276 _8050_/Q VGND VGND VPWR VPWR _6314_/C sky130_fd_sc_hd__clkdlybuf4s25_1
XFILLER_46_138 VGND VGND VPWR VPWR sky130_fd_sc_hd__fill_2
XFILLER_131_42 VGND VGND VPWR VPWR sky130_fd_sc_hd__decap_3
XFILLER_131_75 VGND VGND VPWR VPWR sky130_fd_sc_hd__decap_3
XFILLER_15_514 VGND VGND VPWR VPWR sky130_fd_sc_hd__decap_3
XFILLER_70_642 VGND VGND VPWR VPWR sky130_fd_sc_hd__fill_2
XFILLER_82_491 VGND VGND VPWR VPWR sky130_fd_sc_hd__decap_3
XFILLER_91_57 VGND VGND VPWR VPWR sky130_fd_sc_hd__decap_3
XTAP_TAPCELL_ROW_83_1448 VGND VPWR sky130_fd_sc_hd__tapvpwrvgnd_1
XTAP_TAPCELL_ROW_83_1459 VGND VPWR sky130_fd_sc_hd__tapvpwrvgnd_1
XFILLER_30_528 VGND VGND VPWR VPWR sky130_fd_sc_hd__decap_3
XFILLER_42_377 VGND VGND VPWR VPWR sky130_fd_sc_hd__decap_3
XFILLER_91_79 VGND VGND VPWR VPWR sky130_fd_sc_hd__decap_3
XFILLER_23_591 VGND VGND VPWR VPWR sky130_fd_sc_hd__decap_3
XFILLER_24_62 VGND VGND VPWR VPWR sky130_fd_sc_hd__decap_3
Xwire600 wire600/A VGND VGND VPWR VPWR wire600/X sky130_fd_sc_hd__clkbuf_4
XFILLER_11_753 VGND VGND VPWR VPWR sky130_fd_sc_hd__decap_3
XFILLER_128_427 VGND VGND VPWR VPWR sky130_fd_sc_hd__decap_3
XFILLER_7_724 VGND VGND VPWR VPWR sky130_fd_sc_hd__decap_3
XFILLER_10_274 VGND VGND VPWR VPWR sky130_fd_sc_hd__decap_3
XFILLER_11_797 VGND VGND VPWR VPWR sky130_fd_sc_hd__decap_3
XFILLER_7_735 VGND VGND VPWR VPWR sky130_fd_sc_hd__decap_3
XFILLER_7_768 VGND VGND VPWR VPWR sky130_fd_sc_hd__decap_3
XFILLER_109_685 VGND VGND VPWR VPWR sky130_fd_sc_hd__decap_3
XFILLER_6_256 VGND VGND VPWR VPWR sky130_fd_sc_hd__decap_3
XFILLER_124_622 VGND VGND VPWR VPWR sky130_fd_sc_hd__fill_1
XFILLER_40_83 VGND VGND VPWR VPWR sky130_fd_sc_hd__fill_1
XFILLER_40_94 VGND VGND VPWR VPWR sky130_fd_sc_hd__fill_1
Xclkbuf_leaf_70_CLK clkbuf_leaf_75_CLK/A VGND VGND VPWR VPWR _8777_/CLK sky130_fd_sc_hd__clkbuf_8
XFILLER_124_666 VGND VGND VPWR VPWR sky130_fd_sc_hd__decap_3
Xload_slew605 fanout604/X VGND VGND VPWR VPWR load_slew605/X sky130_fd_sc_hd__buf_4
XFILLER_2_473 VGND VGND VPWR VPWR sky130_fd_sc_hd__decap_3
Xload_slew616 fanout615/X VGND VGND VPWR VPWR load_slew616/X sky130_fd_sc_hd__buf_4
XFILLER_111_349 VGND VGND VPWR VPWR sky130_fd_sc_hd__decap_3
Xload_slew649 fanout648/X VGND VGND VPWR VPWR load_slew649/X sky130_fd_sc_hd__buf_4
XFILLER_1_33 VGND VGND VPWR VPWR sky130_fd_sc_hd__decap_3
XFILLER_93_745 VGND VGND VPWR VPWR sky130_fd_sc_hd__decap_3
XTAP_TAPCELL_ROW_125_2043 VGND VPWR sky130_fd_sc_hd__tapvpwrvgnd_1
XFILLER_1_66 VGND VGND VPWR VPWR sky130_fd_sc_hd__decap_3
XFILLER_1_99 VGND VGND VPWR VPWR sky130_fd_sc_hd__decap_3
XFILLER_37_149 VGND VGND VPWR VPWR sky130_fd_sc_hd__decap_3
XFILLER_80_406 VGND VGND VPWR VPWR sky130_fd_sc_hd__fill_1
XFILLER_18_363 VGND VGND VPWR VPWR sky130_fd_sc_hd__fill_1
XFILLER_33_311 VGND VGND VPWR VPWR sky130_fd_sc_hd__fill_2
XFILLER_92_277 VGND VGND VPWR VPWR sky130_fd_sc_hd__decap_3
XFILLER_45_193 VGND VGND VPWR VPWR sky130_fd_sc_hd__fill_1
XTAP_TAPCELL_ROW_16_520 VGND VPWR sky130_fd_sc_hd__tapvpwrvgnd_1
X_4830_ _4829_/X _4830_/A1 _4862_/S VGND VGND VPWR VPWR _4831_/A sky130_fd_sc_hd__mux2_2
XFILLER_33_366 VGND VGND VPWR VPWR sky130_fd_sc_hd__fill_2
XFILLER_61_686 VGND VGND VPWR VPWR sky130_fd_sc_hd__decap_3
X_4761_ _4761_/A VGND VGND VPWR VPWR _4761_/X sky130_fd_sc_hd__buf_1
X_3712_ _3712_/A VGND VGND VPWR VPWR _7267_/A sky130_fd_sc_hd__clkbuf_2
X_7480_ _7480_/A VGND VGND VPWR VPWR _8795_/D sky130_fd_sc_hd__buf_1
X_6500_ _6500_/A VGND VGND VPWR VPWR _8302_/D sky130_fd_sc_hd__buf_2
X_4692_ _8049_/Q VGND VGND VPWR VPWR _7004_/B sky130_fd_sc_hd__inv_2
XFILLER_119_449 VGND VGND VPWR VPWR sky130_fd_sc_hd__decap_3
X_6431_ _6431_/A VGND VGND VPWR VPWR _8270_/D sky130_fd_sc_hd__buf_2
X_6362_ _6362_/A VGND VGND VPWR VPWR _8237_/D sky130_fd_sc_hd__buf_2
XFILLER_115_611 VGND VGND VPWR VPWR sky130_fd_sc_hd__decap_3
XFILLER_127_482 VGND VGND VPWR VPWR sky130_fd_sc_hd__decap_3
XFILLER_6_790 VGND VGND VPWR VPWR sky130_fd_sc_hd__decap_3
Xclkbuf_leaf_61_CLK clkbuf_leaf_63_CLK/A VGND VGND VPWR VPWR _8518_/CLK sky130_fd_sc_hd__clkbuf_8
X_8101_ _8749_/CLK _8101_/D load_slew623/X VGND VGND VPWR VPWR _8101_/Q sky130_fd_sc_hd__dfrtp_2
X_5313_ _7709_/Q _4899_/X _5331_/S VGND VGND VPWR VPWR _5314_/A sky130_fd_sc_hd__mux2_2
X_6293_ _6293_/A VGND VGND VPWR VPWR _8205_/D sky130_fd_sc_hd__buf_6
XFILLER_102_327 VGND VGND VPWR VPWR sky130_fd_sc_hd__fill_1
XFILLER_130_625 VGND VGND VPWR VPWR sky130_fd_sc_hd__decap_3
XTAP_TAPCELL_ROW_54_1049 VGND VPWR sky130_fd_sc_hd__tapvpwrvgnd_1
X_8032_ _8771_/CLK _8032_/D load_slew596/X VGND VGND VPWR VPWR _8032_/Q sky130_fd_sc_hd__dfrtp_2
X_5244_ _5244_/A VGND VGND VPWR VPWR _7676_/D sky130_fd_sc_hd__buf_1
XFILLER_130_669 VGND VGND VPWR VPWR sky130_fd_sc_hd__decap_3
X_5175_ _5175_/A VGND VGND VPWR VPWR _7643_/D sky130_fd_sc_hd__buf_1
XFILLER_29_617 VGND VGND VPWR VPWR sky130_fd_sc_hd__decap_3
XFILLER_69_797 VGND VGND VPWR VPWR sky130_fd_sc_hd__decap_3
XFILLER_96_561 VGND VGND VPWR VPWR sky130_fd_sc_hd__decap_3
X_4126_ _7670_/Q _3921_/X _4622_/B1 _7589_/Q _4120_/A VGND VGND VPWR VPWR _4126_/X
+ sky130_fd_sc_hd__o221a_2
XFILLER_56_436 VGND VGND VPWR VPWR sky130_fd_sc_hd__decap_3
XFILLER_83_222 VGND VGND VPWR VPWR sky130_fd_sc_hd__fill_2
XFILLER_37_650 VGND VGND VPWR VPWR sky130_fd_sc_hd__decap_3
X_4057_ _8402_/Q _8483_/Q _8564_/Q _8645_/Q _4074_/S _4036_/A VGND VGND VPWR VPWR
+ _4058_/B sky130_fd_sc_hd__mux4_2
XFILLER_36_171 VGND VGND VPWR VPWR sky130_fd_sc_hd__decap_3
XFILLER_43_108 VGND VGND VPWR VPWR sky130_fd_sc_hd__decap_3
XFILLER_43_119 VGND VGND VPWR VPWR sky130_fd_sc_hd__fill_1
XFILLER_24_322 VGND VGND VPWR VPWR sky130_fd_sc_hd__decap_3
XFILLER_24_344 VGND VGND VPWR VPWR sky130_fd_sc_hd__fill_2
XFILLER_36_182 VGND VGND VPWR VPWR sky130_fd_sc_hd__decap_3
XFILLER_52_653 VGND VGND VPWR VPWR sky130_fd_sc_hd__fill_2
X_7816_ _8637_/CLK _7816_/D wire603/X VGND VGND VPWR VPWR _7816_/Q sky130_fd_sc_hd__dfrtp_2
XFILLER_12_517 VGND VGND VPWR VPWR sky130_fd_sc_hd__decap_3
XFILLER_24_377 VGND VGND VPWR VPWR sky130_fd_sc_hd__decap_3
X_8796_ _8796_/CLK _8796_/D wire707/X VGND VGND VPWR VPWR _8796_/Q sky130_fd_sc_hd__dfrtp_2
XFILLER_51_185 VGND VGND VPWR VPWR sky130_fd_sc_hd__decap_3
X_7747_ _8804_/CLK _7747_/D load_slew491/X VGND VGND VPWR VPWR _7747_/Q sky130_fd_sc_hd__dfrtp_2
X_4959_ _4959_/A VGND VGND VPWR VPWR _7560_/D sky130_fd_sc_hd__buf_1
X_7678_ _8743_/CLK _7678_/D wire519/X VGND VGND VPWR VPWR _7678_/Q sky130_fd_sc_hd__dfrtp_2
XFILLER_124_6 VGND VGND VPWR VPWR sky130_fd_sc_hd__decap_3
X_6629_ _4887_/X _8364_/Q _6633_/S VGND VGND VPWR VPWR _6630_/A sky130_fd_sc_hd__mux2_2
XFILLER_4_716 VGND VGND VPWR VPWR sky130_fd_sc_hd__decap_3
XFILLER_106_633 VGND VGND VPWR VPWR sky130_fd_sc_hd__decap_3
XFILLER_3_215 VGND VGND VPWR VPWR sky130_fd_sc_hd__decap_3
XFILLER_4_749 VGND VGND VPWR VPWR sky130_fd_sc_hd__decap_3
Xclkbuf_leaf_52_CLK clkbuf_leaf_52_CLK/A VGND VGND VPWR VPWR _8470_/CLK sky130_fd_sc_hd__clkbuf_8
XFILLER_105_121 VGND VGND VPWR VPWR sky130_fd_sc_hd__decap_3
XFILLER_10_53 VGND VGND VPWR VPWR sky130_fd_sc_hd__decap_3
XFILLER_133_441 VGND VGND VPWR VPWR sky130_fd_sc_hd__decap_3
XFILLER_133_452 VGND VGND VPWR VPWR sky130_fd_sc_hd__decap_3
XFILLER_10_97 VGND VGND VPWR VPWR sky130_fd_sc_hd__fill_1
XFILLER_126_53 VGND VGND VPWR VPWR sky130_fd_sc_hd__decap_3
XFILLER_133_485 VGND VGND VPWR VPWR sky130_fd_sc_hd__decap_3
XFILLER_121_669 VGND VGND VPWR VPWR sky130_fd_sc_hd__decap_3
XFILLER_126_97 VGND VGND VPWR VPWR sky130_fd_sc_hd__decap_3
XFILLER_86_57 VGND VGND VPWR VPWR sky130_fd_sc_hd__fill_2
XFILLER_86_79 VGND VGND VPWR VPWR sky130_fd_sc_hd__decap_3
XFILLER_87_550 VGND VGND VPWR VPWR sky130_fd_sc_hd__fill_1
XFILLER_87_561 VGND VGND VPWR VPWR sky130_fd_sc_hd__decap_3
XFILLER_101_371 VGND VGND VPWR VPWR sky130_fd_sc_hd__decap_3
XFILLER_101_393 VGND VGND VPWR VPWR sky130_fd_sc_hd__fill_2
XFILLER_19_127 VGND VGND VPWR VPWR sky130_fd_sc_hd__decap_3
XFILLER_19_51 VGND VGND VPWR VPWR sky130_fd_sc_hd__decap_3
XFILLER_74_200 VGND VGND VPWR VPWR sky130_fd_sc_hd__decap_3
XFILLER_75_723 VGND VGND VPWR VPWR sky130_fd_sc_hd__decap_3
XFILLER_19_84 VGND VGND VPWR VPWR sky130_fd_sc_hd__decap_3
XFILLER_90_704 VGND VGND VPWR VPWR sky130_fd_sc_hd__decap_3
XFILLER_15_311 VGND VGND VPWR VPWR sky130_fd_sc_hd__fill_1
XFILLER_27_160 VGND VGND VPWR VPWR sky130_fd_sc_hd__decap_3
XFILLER_28_683 VGND VGND VPWR VPWR sky130_fd_sc_hd__decap_3
XFILLER_34_119 VGND VGND VPWR VPWR sky130_fd_sc_hd__decap_3
XFILLER_74_299 VGND VGND VPWR VPWR sky130_fd_sc_hd__decap_3
XFILLER_42_141 VGND VGND VPWR VPWR sky130_fd_sc_hd__decap_3
XFILLER_129_703 VGND VGND VPWR VPWR sky130_fd_sc_hd__decap_3
XFILLER_70_483 VGND VGND VPWR VPWR sky130_fd_sc_hd__decap_3
XTAP_TAPCELL_ROW_41_865 VGND VPWR sky130_fd_sc_hd__tapvpwrvgnd_1
XFILLER_11_561 VGND VGND VPWR VPWR sky130_fd_sc_hd__decap_3
XFILLER_128_224 VGND VGND VPWR VPWR sky130_fd_sc_hd__decap_3
XFILLER_129_747 VGND VGND VPWR VPWR sky130_fd_sc_hd__decap_3
XTAP_TAPCELL_ROW_96_1639 VGND VPWR sky130_fd_sc_hd__tapvpwrvgnd_1
XFILLER_109_493 VGND VGND VPWR VPWR sky130_fd_sc_hd__fill_2
XFILLER_7_587 VGND VGND VPWR VPWR sky130_fd_sc_hd__decap_3
Xclkbuf_leaf_43_CLK clkload5/A VGND VGND VPWR VPWR _8801_/CLK sky130_fd_sc_hd__clkbuf_8
Xmax_cap229 _3805_/A VGND VGND VPWR VPWR _4551_/B1 sky130_fd_sc_hd__buf_6
XFILLER_124_430 VGND VGND VPWR VPWR sky130_fd_sc_hd__decap_3
XFILLER_111_102 VGND VGND VPWR VPWR sky130_fd_sc_hd__fill_1
XFILLER_124_474 VGND VGND VPWR VPWR sky130_fd_sc_hd__fill_2
XFILLER_3_771 VGND VGND VPWR VPWR sky130_fd_sc_hd__decap_3
Xload_slew402 _4035_/S VGND VGND VPWR VPWR _4098_/S0 sky130_fd_sc_hd__buf_4
Xload_slew446 _3887_/S VGND VGND VPWR VPWR _3778_/S sky130_fd_sc_hd__buf_4
Xload_slew435 _4327_/S VGND VGND VPWR VPWR _4247_/S sky130_fd_sc_hd__buf_4
XFILLER_66_701 VGND VGND VPWR VPWR sky130_fd_sc_hd__decap_3
XFILLER_78_561 VGND VGND VPWR VPWR sky130_fd_sc_hd__decap_3
XFILLER_97_369 VGND VGND VPWR VPWR sky130_fd_sc_hd__fill_2
XFILLER_18_3 VGND VGND VPWR VPWR sky130_fd_sc_hd__decap_3
XFILLER_66_734 VGND VGND VPWR VPWR sky130_fd_sc_hd__decap_3
XFILLER_65_233 VGND VGND VPWR VPWR sky130_fd_sc_hd__decap_3
XFILLER_93_564 VGND VGND VPWR VPWR sky130_fd_sc_hd__decap_3
XTAP_TAPCELL_ROW_49_976 VGND VPWR sky130_fd_sc_hd__tapvpwrvgnd_1
X_6980_ _6980_/A VGND VGND VPWR VPWR _8528_/D sky130_fd_sc_hd__buf_6
XFILLER_18_160 VGND VGND VPWR VPWR sky130_fd_sc_hd__decap_3
XFILLER_65_288 VGND VGND VPWR VPWR sky130_fd_sc_hd__fill_1
XFILLER_80_214 VGND VGND VPWR VPWR sky130_fd_sc_hd__fill_2
X_5931_ _5931_/A1 _5921_/X _4849_/X _5922_/X hold831/X VGND VGND VPWR VPWR _8021_/D
+ sky130_fd_sc_hd__a32o_2
XFILLER_80_247 VGND VGND VPWR VPWR sky130_fd_sc_hd__decap_3
XTAP_TAPCELL_ROW_105_1757 VGND VPWR sky130_fd_sc_hd__tapvpwrvgnd_1
XFILLER_33_152 VGND VGND VPWR VPWR sky130_fd_sc_hd__fill_1
XTAP_TAPCELL_ROW_105_1768 VGND VPWR sky130_fd_sc_hd__tapvpwrvgnd_1
X_8650_ _8725_/CLK _8650_/D fanout495/X VGND VGND VPWR VPWR _8650_/Q sky130_fd_sc_hd__dfrtp_2
X_5862_ _5867_/A1 _5853_/X _4965_/X _5865_/B1 hold797/X VGND VGND VPWR VPWR _7967_/D
+ sky130_fd_sc_hd__a32o_2
X_8581_ _8583_/CLK _8581_/D fanout619/X VGND VGND VPWR VPWR _8581_/Q sky130_fd_sc_hd__dfrtp_2
X_7601_ _8583_/CLK _7601_/D fanout622/X VGND VGND VPWR VPWR _7601_/Q sky130_fd_sc_hd__dfrtp_2
X_5793_ _7935_/Q _4829_/A _5805_/S VGND VGND VPWR VPWR _5794_/A sky130_fd_sc_hd__mux2_2
X_4813_ _4813_/A VGND VGND VPWR VPWR _7526_/D sky130_fd_sc_hd__buf_1
XFILLER_21_369 VGND VGND VPWR VPWR sky130_fd_sc_hd__decap_3
X_7532_ _8757_/CLK _7532_/D fanout715/X VGND VGND VPWR VPWR _7532_/Q sky130_fd_sc_hd__dfrtp_2
X_4744_ _4744_/A _4764_/B VGND VGND VPWR VPWR _4745_/A sky130_fd_sc_hd__and2_2
XFILLER_119_279 VGND VGND VPWR VPWR sky130_fd_sc_hd__fill_1
X_7463_ _7463_/A VGND VGND VPWR VPWR _8787_/D sky130_fd_sc_hd__buf_1
X_4675_ _8782_/Q _7557_/Q _4675_/S VGND VGND VPWR VPWR _4676_/B sky130_fd_sc_hd__mux2_2
XFILLER_134_238 VGND VGND VPWR VPWR sky130_fd_sc_hd__decap_3
Xclkbuf_leaf_34_CLK clkbuf_leaf_35_CLK/A VGND VGND VPWR VPWR _8768_/CLK sky130_fd_sc_hd__clkbuf_8
X_7394_ _7394_/A VGND VGND VPWR VPWR _8754_/D sky130_fd_sc_hd__buf_1
X_6414_ _6414_/A VGND VGND VPWR VPWR _8262_/D sky130_fd_sc_hd__buf_2
XPHY_EDGE_ROW_131_Right_131 VGND VGND VPWR VPWR sky130_fd_sc_hd__decap_3
X_6345_ _6345_/A VGND VGND VPWR VPWR _8229_/D sky130_fd_sc_hd__buf_2
XFILLER_130_400 VGND VGND VPWR VPWR sky130_fd_sc_hd__decap_3
X_6276_ _6276_/A VGND VGND VPWR VPWR _8197_/D sky130_fd_sc_hd__buf_6
XFILLER_103_658 VGND VGND VPWR VPWR sky130_fd_sc_hd__decap_3
XFILLER_130_433 VGND VGND VPWR VPWR sky130_fd_sc_hd__decap_3
XFILLER_88_347 VGND VGND VPWR VPWR sky130_fd_sc_hd__decap_3
XFILLER_88_358 VGND VGND VPWR VPWR sky130_fd_sc_hd__decap_3
X_8015_ _8672_/CLK _8015_/D load_slew687/X VGND VGND VPWR VPWR _8015_/Q sky130_fd_sc_hd__dfrtp_2
X_5227_ _5227_/A VGND VGND VPWR VPWR _7668_/D sky130_fd_sc_hd__buf_1
XFILLER_130_466 VGND VGND VPWR VPWR sky130_fd_sc_hd__decap_3
XFILLER_130_477 VGND VGND VPWR VPWR sky130_fd_sc_hd__decap_3
XFILLER_69_550 VGND VGND VPWR VPWR sky130_fd_sc_hd__decap_3
X_5158_ _4937_/X _7637_/Q _5158_/S VGND VGND VPWR VPWR _5159_/A sky130_fd_sc_hd__mux2_2
XFILLER_110_190 VGND VGND VPWR VPWR sky130_fd_sc_hd__decap_3
XFILLER_57_778 VGND VGND VPWR VPWR sky130_fd_sc_hd__decap_3
XFILLER_72_704 VGND VGND VPWR VPWR sky130_fd_sc_hd__fill_1
X_5089_ _4799_/X _7604_/Q _5095_/S VGND VGND VPWR VPWR _5090_/A sky130_fd_sc_hd__mux2_2
X_4109_ _8407_/Q _8488_/Q _8569_/Q _8650_/Q _4110_/S0 _4110_/S1 VGND VGND VPWR VPWR
+ _4109_/X sky130_fd_sc_hd__mux4_2
XFILLER_112_11 VGND VGND VPWR VPWR sky130_fd_sc_hd__fill_1
XFILLER_44_417 VGND VGND VPWR VPWR sky130_fd_sc_hd__decap_3
XFILLER_71_214 VGND VGND VPWR VPWR sky130_fd_sc_hd__fill_2
XFILLER_72_726 VGND VGND VPWR VPWR sky130_fd_sc_hd__decap_3
XTAP_TAPCELL_ROW_67_1229 VGND VPWR sky130_fd_sc_hd__tapvpwrvgnd_1
XFILLER_112_99 VGND VGND VPWR VPWR sky130_fd_sc_hd__decap_3
XFILLER_24_141 VGND VGND VPWR VPWR sky130_fd_sc_hd__decap_3
XFILLER_25_686 VGND VGND VPWR VPWR sky130_fd_sc_hd__decap_3
XFILLER_72_59 VGND VGND VPWR VPWR sky130_fd_sc_hd__decap_3
XFILLER_80_770 VGND VGND VPWR VPWR sky130_fd_sc_hd__fill_1
XTAP_TAPCELL_ROW_80_1407 VGND VPWR sky130_fd_sc_hd__tapvpwrvgnd_1
XTAP_TAPCELL_ROW_80_1418 VGND VPWR sky130_fd_sc_hd__tapvpwrvgnd_1
XFILLER_12_336 VGND VGND VPWR VPWR sky130_fd_sc_hd__decap_3
X_8779_ _8779_/CLK _8779_/D wire746/X VGND VGND VPWR VPWR _8779_/Q sky130_fd_sc_hd__dfrtp_2
XFILLER_40_656 VGND VGND VPWR VPWR sky130_fd_sc_hd__decap_3
XFILLER_40_667 VGND VGND VPWR VPWR sky130_fd_sc_hd__fill_2
XFILLER_40_678 VGND VGND VPWR VPWR sky130_fd_sc_hd__decap_3
XFILLER_21_30 VGND VGND VPWR VPWR sky130_fd_sc_hd__decap_3
XFILLER_21_63 VGND VGND VPWR VPWR sky130_fd_sc_hd__decap_3
Xclkbuf_leaf_25_CLK clkbuf_5_8__f_CLK/X VGND VGND VPWR VPWR _8560_/CLK sky130_fd_sc_hd__clkbuf_8
XFILLER_134_772 VGND VGND VPWR VPWR sky130_fd_sc_hd__decap_3
XFILLER_0_741 VGND VGND VPWR VPWR sky130_fd_sc_hd__decap_3
XFILLER_106_496 VGND VGND VPWR VPWR sky130_fd_sc_hd__fill_2
XFILLER_133_293 VGND VGND VPWR VPWR sky130_fd_sc_hd__decap_3
XTAP_TAPCELL_ROW_91_1569 VGND VPWR sky130_fd_sc_hd__tapvpwrvgnd_1
XFILLER_0_763 VGND VGND VPWR VPWR sky130_fd_sc_hd__decap_3
XFILLER_121_466 VGND VGND VPWR VPWR sky130_fd_sc_hd__decap_3
XFILLER_94_317 VGND VGND VPWR VPWR sky130_fd_sc_hd__decap_3
XTAP_TAPCELL_ROW_7_384 VGND VPWR sky130_fd_sc_hd__tapvpwrvgnd_1
XFILLER_0_785 VGND VGND VPWR VPWR sky130_fd_sc_hd__decap_3
XFILLER_102_680 VGND VGND VPWR VPWR sky130_fd_sc_hd__decap_3
XFILLER_87_391 VGND VGND VPWR VPWR sky130_fd_sc_hd__fill_1
XTAP_TAPCELL_ROW_7_395 VGND VPWR sky130_fd_sc_hd__tapvpwrvgnd_1
XFILLER_63_704 VGND VGND VPWR VPWR sky130_fd_sc_hd__decap_3
XFILLER_90_501 VGND VGND VPWR VPWR sky130_fd_sc_hd__decap_3
XTAP_TAPCELL_ROW_122_2002 VGND VPWR sky130_fd_sc_hd__tapvpwrvgnd_1
XTAP_TAPCELL_ROW_46_935 VGND VPWR sky130_fd_sc_hd__tapvpwrvgnd_1
XFILLER_28_491 VGND VGND VPWR VPWR sky130_fd_sc_hd__decap_3
XFILLER_15_152 VGND VGND VPWR VPWR sky130_fd_sc_hd__fill_2
XFILLER_90_589 VGND VGND VPWR VPWR sky130_fd_sc_hd__decap_3
XFILLER_15_196 VGND VGND VPWR VPWR sky130_fd_sc_hd__decap_3
XFILLER_31_612 VGND VGND VPWR VPWR sky130_fd_sc_hd__fill_1
XFILLER_129_500 VGND VGND VPWR VPWR sky130_fd_sc_hd__decap_3
XFILLER_129_511 VGND VGND VPWR VPWR sky130_fd_sc_hd__decap_3
XFILLER_30_144 VGND VGND VPWR VPWR sky130_fd_sc_hd__decap_3
XFILLER_62_70 VGND VGND VPWR VPWR sky130_fd_sc_hd__decap_3
XFILLER_129_544 VGND VGND VPWR VPWR sky130_fd_sc_hd__decap_3
XFILLER_7_21 VGND VGND VPWR VPWR sky130_fd_sc_hd__decap_3
XTAP_TAPCELL_ROW_100_1687 VGND VPWR sky130_fd_sc_hd__tapvpwrvgnd_1
XFILLER_11_380 VGND VGND VPWR VPWR sky130_fd_sc_hd__decap_3
XFILLER_7_54 VGND VGND VPWR VPWR sky130_fd_sc_hd__fill_2
XTAP_TAPCELL_ROW_100_1698 VGND VPWR sky130_fd_sc_hd__tapvpwrvgnd_1
XFILLER_116_227 VGND VGND VPWR VPWR sky130_fd_sc_hd__decap_3
XFILLER_129_588 VGND VGND VPWR VPWR sky130_fd_sc_hd__decap_3
XFILLER_7_87 VGND VGND VPWR VPWR sky130_fd_sc_hd__fill_2
XTAP_TAPCELL_ROW_133_2153 VGND VPWR sky130_fd_sc_hd__tapvpwrvgnd_1
Xclkbuf_leaf_16_CLK clkload4/A VGND VGND VPWR VPWR _8721_/CLK sky130_fd_sc_hd__clkbuf_8
X_4460_ _4460_/A _4460_/B VGND VGND VPWR VPWR _4460_/X sky130_fd_sc_hd__or2_2
XFILLER_125_750 VGND VGND VPWR VPWR sky130_fd_sc_hd__fill_1
X_4391_ _4386_/X _4387_/X _4388_/X _4390_/X VGND VGND VPWR VPWR _4391_/X sky130_fd_sc_hd__a22o_2
XFILLER_125_794 VGND VGND VPWR VPWR sky130_fd_sc_hd__decap_3
XFILLER_131_208 VGND VGND VPWR VPWR sky130_fd_sc_hd__decap_3
X_6130_ _6130_/A VGND VGND VPWR VPWR _8129_/D sky130_fd_sc_hd__buf_1
XFILLER_112_433 VGND VGND VPWR VPWR sky130_fd_sc_hd__fill_2
XFILLER_124_271 VGND VGND VPWR VPWR sky130_fd_sc_hd__fill_1
XFILLER_97_122 VGND VGND VPWR VPWR sky130_fd_sc_hd__fill_2
XFILLER_98_645 VGND VGND VPWR VPWR sky130_fd_sc_hd__decap_3
XTAP_TAPCELL_ROW_51_1008 VGND VPWR sky130_fd_sc_hd__tapvpwrvgnd_1
XFILLER_112_477 VGND VGND VPWR VPWR sky130_fd_sc_hd__decap_3
X_6061_ _6061_/A VGND VGND VPWR VPWR _8096_/D sky130_fd_sc_hd__buf_1
XFILLER_100_628 VGND VGND VPWR VPWR sky130_fd_sc_hd__decap_3
XFILLER_38_200 VGND VGND VPWR VPWR sky130_fd_sc_hd__decap_3
Xhold1007 _7551_/Q VGND VGND VPWR VPWR _4918_/A1 sky130_fd_sc_hd__dlygate4sd3_1
Xhold1018 _7630_/Q VGND VGND VPWR VPWR _5144_/A1 sky130_fd_sc_hd__dlygate4sd3_1
Xhold1029 _7546_/Q VGND VGND VPWR VPWR _4896_/A1 sky130_fd_sc_hd__dlygate4sd3_1
Xload_slew287 _4083_/C1 VGND VGND VPWR VPWR _3925_/A sky130_fd_sc_hd__buf_4
Xload_slew298 _4665_/C1 VGND VGND VPWR VPWR _4673_/S sky130_fd_sc_hd__buf_4
X_5012_ _5011_/X hold961/X _5028_/S VGND VGND VPWR VPWR _5013_/A sky130_fd_sc_hd__mux2_2
XFILLER_39_778 VGND VGND VPWR VPWR sky130_fd_sc_hd__decap_3
XFILLER_54_726 VGND VGND VPWR VPWR sky130_fd_sc_hd__decap_3
XFILLER_93_372 VGND VGND VPWR VPWR sky130_fd_sc_hd__decap_3
XFILLER_53_225 VGND VGND VPWR VPWR sky130_fd_sc_hd__decap_3
X_6963_ _4861_/X _8520_/Q _6979_/S VGND VGND VPWR VPWR _6964_/A sky130_fd_sc_hd__mux2_4
X_8702_ _8783_/CLK _8702_/D load_slew682/X VGND VGND VPWR VPWR _8702_/Q sky130_fd_sc_hd__dfrtp_2
X_6894_ _6894_/A VGND VGND VPWR VPWR _8487_/D sky130_fd_sc_hd__buf_6
X_5914_ _5919_/A1 _5919_/A2 _4791_/X _5919_/B1 hold891/X VGND VGND VPWR VPWR _8007_/D
+ sky130_fd_sc_hd__a32o_2
XTAP_TAPCELL_ROW_24_629 VGND VPWR sky130_fd_sc_hd__tapvpwrvgnd_1
X_8633_ _8639_/CLK _8633_/D fanout606/X VGND VGND VPWR VPWR _8633_/Q sky130_fd_sc_hd__dfrtp_2
X_5845_ _7960_/Q _4933_/A _5847_/S VGND VGND VPWR VPWR _5846_/A sky130_fd_sc_hd__mux2_2
XFILLER_22_645 VGND VGND VPWR VPWR sky130_fd_sc_hd__decap_3
XFILLER_22_678 VGND VGND VPWR VPWR sky130_fd_sc_hd__fill_2
XFILLER_42_29 VGND VGND VPWR VPWR sky130_fd_sc_hd__decap_3
XTAP_TAPCELL_ROW_62_1159 VGND VPWR sky130_fd_sc_hd__tapvpwrvgnd_1
XFILLER_22_689 VGND VGND VPWR VPWR sky130_fd_sc_hd__decap_3
X_8564_ _8645_/CLK _8564_/D load_slew503/X VGND VGND VPWR VPWR _8564_/Q sky130_fd_sc_hd__dfrtp_2
X_5776_ _7927_/Q _4795_/A _5784_/S VGND VGND VPWR VPWR _5777_/A sky130_fd_sc_hd__mux2_2
XFILLER_108_717 VGND VGND VPWR VPWR sky130_fd_sc_hd__decap_3
X_8495_ _8495_/CLK _8495_/D load_slew515/X VGND VGND VPWR VPWR _8495_/Q sky130_fd_sc_hd__dfrtp_2
X_7515_ _8586_/CLK _7515_/D load_slew538/X VGND VGND VPWR VPWR _7515_/Q sky130_fd_sc_hd__dfrtp_2
X_4727_ _4727_/A VGND VGND VPWR VPWR _4727_/X sky130_fd_sc_hd__buf_1
XFILLER_135_536 VGND VGND VPWR VPWR sky130_fd_sc_hd__fill_1
XTAP_TAPCELL_ROW_118_1948 VGND VPWR sky130_fd_sc_hd__tapvpwrvgnd_1
X_7446_ _7446_/A VGND VGND VPWR VPWR _8779_/D sky130_fd_sc_hd__buf_1
X_4658_ _8780_/Q _7555_/Q _4662_/S VGND VGND VPWR VPWR _4658_/X sky130_fd_sc_hd__mux2_2
Xhold830 _8628_/Q VGND VGND VPWR VPWR hold830/X sky130_fd_sc_hd__dlygate4sd3_1
XFILLER_89_612 VGND VGND VPWR VPWR sky130_fd_sc_hd__decap_3
XFILLER_89_623 VGND VGND VPWR VPWR sky130_fd_sc_hd__fill_1
Xhold841 _8034_/Q VGND VGND VPWR VPWR hold841/X sky130_fd_sc_hd__dlygate4sd3_1
Xhold852 _8627_/Q VGND VGND VPWR VPWR hold852/X sky130_fd_sc_hd__dlygate4sd3_1
Xhold863 _8659_/Q VGND VGND VPWR VPWR hold863/X sky130_fd_sc_hd__dlygate4sd3_1
X_7377_ _7377_/A VGND VGND VPWR VPWR _8746_/D sky130_fd_sc_hd__buf_1
X_4589_ _8126_/Q _8207_/Q _8288_/Q _8369_/Q _4579_/S _4621_/A VGND VGND VPWR VPWR
+ _4589_/X sky130_fd_sc_hd__mux4_2
XFILLER_115_293 VGND VGND VPWR VPWR sky130_fd_sc_hd__fill_1
XFILLER_89_656 VGND VGND VPWR VPWR sky130_fd_sc_hd__decap_3
Xhold874 _7982_/Q VGND VGND VPWR VPWR hold874/X sky130_fd_sc_hd__dlygate4sd3_1
Xhold885 _8695_/Q VGND VGND VPWR VPWR hold885/X sky130_fd_sc_hd__dlygate4sd3_1
Xhold896 _8679_/Q VGND VGND VPWR VPWR hold896/X sky130_fd_sc_hd__dlygate4sd3_1
X_6328_ _6328_/A VGND VGND VPWR VPWR _8221_/D sky130_fd_sc_hd__buf_2
XFILLER_130_230 VGND VGND VPWR VPWR sky130_fd_sc_hd__decap_3
XFILLER_131_753 VGND VGND VPWR VPWR sky130_fd_sc_hd__decap_3
X_6259_ _6259_/A VGND VGND VPWR VPWR _8189_/D sky130_fd_sc_hd__buf_6
XFILLER_130_296 VGND VGND VPWR VPWR sky130_fd_sc_hd__decap_3
XFILLER_131_797 VGND VGND VPWR VPWR sky130_fd_sc_hd__decap_3
XFILLER_123_32 VGND VGND VPWR VPWR sky130_fd_sc_hd__fill_1
XFILLER_29_222 VGND VGND VPWR VPWR sky130_fd_sc_hd__fill_2
XTAP_TAPCELL_ROW_4_343 VGND VPWR sky130_fd_sc_hd__tapvpwrvgnd_1
XTAP_TAPCELL_ROW_4_354 VGND VPWR sky130_fd_sc_hd__tapvpwrvgnd_1
XFILLER_29_266 VGND VGND VPWR VPWR sky130_fd_sc_hd__decap_3
XFILLER_45_737 VGND VGND VPWR VPWR sky130_fd_sc_hd__fill_1
XFILLER_83_14 VGND VGND VPWR VPWR sky130_fd_sc_hd__decap_3
XFILLER_123_87 VGND VGND VPWR VPWR sky130_fd_sc_hd__decap_3
XFILLER_29_299 VGND VGND VPWR VPWR sky130_fd_sc_hd__decap_3
XPHY_EDGE_ROW_103_Left_239 VGND VGND VPWR VPWR sky130_fd_sc_hd__decap_3
XFILLER_16_41 VGND VGND VPWR VPWR sky130_fd_sc_hd__decap_3
XFILLER_72_589 VGND VGND VPWR VPWR sky130_fd_sc_hd__fill_2
XFILLER_16_74 VGND VGND VPWR VPWR sky130_fd_sc_hd__decap_3
XFILLER_16_85 VGND VGND VPWR VPWR sky130_fd_sc_hd__decap_3
XFILLER_53_781 VGND VGND VPWR VPWR sky130_fd_sc_hd__decap_3
XPHY_EDGE_ROW_11_Right_11 VGND VGND VPWR VPWR sky130_fd_sc_hd__decap_3
XFILLER_12_133 VGND VGND VPWR VPWR sky130_fd_sc_hd__decap_3
XFILLER_12_144 VGND VGND VPWR VPWR sky130_fd_sc_hd__decap_3
XFILLER_13_656 VGND VGND VPWR VPWR sky130_fd_sc_hd__decap_3
XFILLER_40_464 VGND VGND VPWR VPWR sky130_fd_sc_hd__decap_3
XFILLER_9_638 VGND VGND VPWR VPWR sky130_fd_sc_hd__decap_3
Xclkbuf_5_3__f_CLK clkbuf_4_1_0_CLK/X VGND VGND VPWR VPWR clkload0/A sky130_fd_sc_hd__clkbuf_16
XFILLER_32_62 VGND VGND VPWR VPWR sky130_fd_sc_hd__decap_3
XFILLER_32_73 VGND VGND VPWR VPWR sky130_fd_sc_hd__decap_3
XFILLER_126_514 VGND VGND VPWR VPWR sky130_fd_sc_hd__decap_3
XFILLER_5_800 VGND VGND VPWR VPWR sky130_fd_sc_hd__decap_3
XFILLER_4_321 VGND VGND VPWR VPWR sky130_fd_sc_hd__decap_3
XPHY_EDGE_ROW_112_Left_248 VGND VGND VPWR VPWR sky130_fd_sc_hd__decap_3
XFILLER_107_772 VGND VGND VPWR VPWR sky130_fd_sc_hd__decap_3
XFILLER_4_365 VGND VGND VPWR VPWR sky130_fd_sc_hd__decap_3
XFILLER_4_398 VGND VGND VPWR VPWR sky130_fd_sc_hd__fill_2
XPHY_EDGE_ROW_20_Right_20 VGND VGND VPWR VPWR sky130_fd_sc_hd__decap_3
XFILLER_79_166 VGND VGND VPWR VPWR sky130_fd_sc_hd__fill_2
XFILLER_121_263 VGND VGND VPWR VPWR sky130_fd_sc_hd__decap_3
XFILLER_67_328 VGND VGND VPWR VPWR sky130_fd_sc_hd__decap_3
XFILLER_79_188 VGND VGND VPWR VPWR sky130_fd_sc_hd__fill_2
XFILLER_95_648 VGND VGND VPWR VPWR sky130_fd_sc_hd__decap_3
XFILLER_121_296 VGND VGND VPWR VPWR sky130_fd_sc_hd__fill_2
XFILLER_48_542 VGND VGND VPWR VPWR sky130_fd_sc_hd__decap_3
XFILLER_57_70 VGND VGND VPWR VPWR sky130_fd_sc_hd__decap_3
XFILLER_94_136 VGND VGND VPWR VPWR sky130_fd_sc_hd__decap_3
XPHY_EDGE_ROW_121_Left_257 VGND VGND VPWR VPWR sky130_fd_sc_hd__decap_3
XFILLER_35_247 VGND VGND VPWR VPWR sky130_fd_sc_hd__decap_3
Xclkbuf_leaf_5_CLK clkbuf_leaf_8_CLK/A VGND VGND VPWR VPWR _8725_/CLK sky130_fd_sc_hd__clkbuf_8
XFILLER_51_729 VGND VGND VPWR VPWR sky130_fd_sc_hd__decap_3
X_3960_ _4591_/S _3956_/X _3958_/X _3959_/X VGND VGND VPWR VPWR _3960_/X sky130_fd_sc_hd__a22o_2
XFILLER_16_483 VGND VGND VPWR VPWR sky130_fd_sc_hd__decap_3
XFILLER_73_80 VGND VGND VPWR VPWR sky130_fd_sc_hd__fill_1
XTAP_TAPCELL_ROW_102_1716 VGND VPWR sky130_fd_sc_hd__tapvpwrvgnd_1
XTAP_TAPCELL_ROW_102_1727 VGND VPWR sky130_fd_sc_hd__tapvpwrvgnd_1
XFILLER_43_291 VGND VGND VPWR VPWR sky130_fd_sc_hd__decap_3
X_3891_ _7648_/Q _4682_/A2 _3889_/X _7567_/Q _4682_/C1 VGND VGND VPWR VPWR _3891_/X
+ sky130_fd_sc_hd__o221a_2
XFILLER_31_475 VGND VGND VPWR VPWR sky130_fd_sc_hd__decap_3
XFILLER_31_486 VGND VGND VPWR VPWR sky130_fd_sc_hd__decap_3
X_5630_ _5630_/A VGND VGND VPWR VPWR _7858_/D sky130_fd_sc_hd__buf_1
X_5561_ _5561_/A VGND VGND VPWR VPWR _7825_/D sky130_fd_sc_hd__buf_1
XFILLER_117_503 VGND VGND VPWR VPWR sky130_fd_sc_hd__fill_1
XFILLER_8_660 VGND VGND VPWR VPWR sky130_fd_sc_hd__decap_3
XPHY_EDGE_ROW_130_Left_266 VGND VGND VPWR VPWR sky130_fd_sc_hd__decap_3
X_8280_ _8685_/CLK _8280_/D wire574/X VGND VGND VPWR VPWR _8280_/Q sky130_fd_sc_hd__dfrtp_2
X_7300_ _8710_/Q _4980_/A _7302_/S VGND VGND VPWR VPWR _7301_/A sky130_fd_sc_hd__mux2_2
X_5492_ _5492_/A VGND VGND VPWR VPWR _7793_/D sky130_fd_sc_hd__buf_1
X_4512_ _7785_/Q _7866_/Q _7947_/Q _8028_/Q _3716_/A _3705_/C VGND VGND VPWR VPWR
+ _4512_/X sky130_fd_sc_hd__mux4_2
XFILLER_117_558 VGND VGND VPWR VPWR sky130_fd_sc_hd__fill_2
XFILLER_8_693 VGND VGND VPWR VPWR sky130_fd_sc_hd__decap_3
X_7231_ _7270_/A VGND VGND VPWR VPWR _7231_/X sky130_fd_sc_hd__clkbuf_1
XFILLER_132_528 VGND VGND VPWR VPWR sky130_fd_sc_hd__decap_3
X_4443_ _8021_/Q _3816_/X _3817_/X _7940_/Q VGND VGND VPWR VPWR _4443_/X sky130_fd_sc_hd__o22a_2
XFILLER_125_591 VGND VGND VPWR VPWR sky130_fd_sc_hd__decap_3
XFILLER_132_539 VGND VGND VPWR VPWR sky130_fd_sc_hd__decap_3
Xfanout606 fanout611/X VGND VGND VPWR VPWR fanout606/X sky130_fd_sc_hd__clkdlybuf4s25_1
X_7162_ _4917_/X _8614_/Q _7172_/S VGND VGND VPWR VPWR _7163_/A sky130_fd_sc_hd__mux2_2
X_4374_ _7935_/Q _4424_/A2 _4373_/X _4415_/A _4444_/A1 VGND VGND VPWR VPWR _4374_/X
+ sky130_fd_sc_hd__o221a_2
XFILLER_112_241 VGND VGND VPWR VPWR sky130_fd_sc_hd__decap_3
XFILLER_58_306 VGND VGND VPWR VPWR sky130_fd_sc_hd__fill_2
XFILLER_86_604 VGND VGND VPWR VPWR sky130_fd_sc_hd__decap_3
XTAP_TAPCELL_ROW_113_1878 VGND VPWR sky130_fd_sc_hd__tapvpwrvgnd_1
Xfanout617 fanout619/X VGND VGND VPWR VPWR wire618/A sky130_fd_sc_hd__clkdlybuf4s25_1
Xfanout639 fanout643/X VGND VGND VPWR VPWR fanout639/X sky130_fd_sc_hd__clkdlybuf4s25_1
X_7093_ _4777_/X hold928/X _7109_/S VGND VGND VPWR VPWR _7094_/A sky130_fd_sc_hd__mux2_1
X_6113_ _6113_/A VGND VGND VPWR VPWR _8121_/D sky130_fd_sc_hd__buf_1
XFILLER_112_285 VGND VGND VPWR VPWR sky130_fd_sc_hd__decap_3
XFILLER_98_486 VGND VGND VPWR VPWR sky130_fd_sc_hd__fill_2
X_6044_ _6044_/A VGND VGND VPWR VPWR _8088_/D sky130_fd_sc_hd__buf_1
XFILLER_100_436 VGND VGND VPWR VPWR sky130_fd_sc_hd__fill_2
XFILLER_37_29 VGND VGND VPWR VPWR sky130_fd_sc_hd__decap_3
XFILLER_39_564 VGND VGND VPWR VPWR sky130_fd_sc_hd__decap_3
XFILLER_85_169 VGND VGND VPWR VPWR sky130_fd_sc_hd__fill_2
XFILLER_94_681 VGND VGND VPWR VPWR sky130_fd_sc_hd__decap_3
XTAP_TAPCELL_ROW_1_302 VGND VPWR sky130_fd_sc_hd__tapvpwrvgnd_1
XTAP_TAPCELL_ROW_1_313 VGND VPWR sky130_fd_sc_hd__tapvpwrvgnd_1
X_7995_ _8410_/CLK _7995_/D load_slew524/X VGND VGND VPWR VPWR _7995_/Q sky130_fd_sc_hd__dfrtp_2
XFILLER_54_589 VGND VGND VPWR VPWR sky130_fd_sc_hd__decap_3
X_6946_ _7248_/A2 _8512_/Q _6958_/S VGND VGND VPWR VPWR _6947_/A sky130_fd_sc_hd__mux2_4
XFILLER_41_228 VGND VGND VPWR VPWR sky130_fd_sc_hd__fill_2
XFILLER_53_28 VGND VGND VPWR VPWR sky130_fd_sc_hd__decap_3
XFILLER_34_291 VGND VGND VPWR VPWR sky130_fd_sc_hd__decap_3
X_6877_ _5031_/X _8479_/Q _6895_/S VGND VGND VPWR VPWR _6878_/A sky130_fd_sc_hd__mux2_4
XFILLER_22_486 VGND VGND VPWR VPWR sky130_fd_sc_hd__decap_3
X_8616_ _8697_/CLK _8616_/D fanout732/X VGND VGND VPWR VPWR _8616_/Q sky130_fd_sc_hd__dfrtp_2
X_5828_ _5849_/S VGND VGND VPWR VPWR _5847_/S sky130_fd_sc_hd__buf_2
XFILLER_10_637 VGND VGND VPWR VPWR sky130_fd_sc_hd__decap_3
XFILLER_10_648 VGND VGND VPWR VPWR sky130_fd_sc_hd__decap_3
X_8547_ _8547_/CLK _8547_/D fanout650/X VGND VGND VPWR VPWR _8547_/Q sky130_fd_sc_hd__dfrtp_2
X_5759_ _7919_/Q _4761_/A _5763_/S VGND VGND VPWR VPWR _5760_/A sky130_fd_sc_hd__mux2_2
XFILLER_135_300 VGND VGND VPWR VPWR sky130_fd_sc_hd__decap_3
XFILLER_6_619 VGND VGND VPWR VPWR sky130_fd_sc_hd__decap_3
XFILLER_118_21 VGND VGND VPWR VPWR sky130_fd_sc_hd__fill_1
X_8478_ _8647_/CLK _8478_/D fanout534/X VGND VGND VPWR VPWR _8478_/Q sky130_fd_sc_hd__dfrtp_2
XFILLER_118_65 VGND VGND VPWR VPWR sky130_fd_sc_hd__decap_3
XTAP_TAPCELL_ROW_75_1339 VGND VPWR sky130_fd_sc_hd__tapvpwrvgnd_1
XTAP_TAPCELL_ROW_9_413 VGND VPWR sky130_fd_sc_hd__tapvpwrvgnd_1
XTAP_TAPCELL_ROW_9_424 VGND VPWR sky130_fd_sc_hd__tapvpwrvgnd_1
X_7429_ _7429_/A VGND VGND VPWR VPWR _8771_/D sky130_fd_sc_hd__buf_1
XFILLER_104_742 VGND VGND VPWR VPWR sky130_fd_sc_hd__fill_2
XFILLER_135_399 VGND VGND VPWR VPWR sky130_fd_sc_hd__decap_3
XFILLER_78_47 VGND VGND VPWR VPWR sky130_fd_sc_hd__decap_3
XFILLER_131_550 VGND VGND VPWR VPWR sky130_fd_sc_hd__decap_3
XFILLER_131_561 VGND VGND VPWR VPWR sky130_fd_sc_hd__decap_3
XFILLER_77_604 VGND VGND VPWR VPWR sky130_fd_sc_hd__fill_2
XFILLER_89_464 VGND VGND VPWR VPWR sky130_fd_sc_hd__decap_3
XFILLER_131_594 VGND VGND VPWR VPWR sky130_fd_sc_hd__decap_3
XFILLER_134_53 VGND VGND VPWR VPWR sky130_fd_sc_hd__decap_3
XFILLER_49_317 VGND VGND VPWR VPWR sky130_fd_sc_hd__decap_3
XFILLER_76_103 VGND VGND VPWR VPWR sky130_fd_sc_hd__decap_3
XFILLER_76_136 VGND VGND VPWR VPWR sky130_fd_sc_hd__decap_3
XFILLER_94_24 VGND VGND VPWR VPWR sky130_fd_sc_hd__decap_3
XFILLER_134_97 VGND VGND VPWR VPWR sky130_fd_sc_hd__decap_3
XFILLER_18_704 VGND VGND VPWR VPWR sky130_fd_sc_hd__fill_2
XFILLER_57_350 VGND VGND VPWR VPWR sky130_fd_sc_hd__fill_1
XFILLER_57_361 VGND VGND VPWR VPWR sky130_fd_sc_hd__fill_2
XFILLER_64_309 VGND VGND VPWR VPWR sky130_fd_sc_hd__decap_3
XFILLER_91_106 VGND VGND VPWR VPWR sky130_fd_sc_hd__decap_3
XFILLER_17_225 VGND VGND VPWR VPWR sky130_fd_sc_hd__decap_3
XFILLER_18_748 VGND VGND VPWR VPWR sky130_fd_sc_hd__decap_3
XFILLER_27_51 VGND VGND VPWR VPWR sky130_fd_sc_hd__decap_3
XFILLER_91_139 VGND VGND VPWR VPWR sky130_fd_sc_hd__decap_3
XFILLER_27_84 VGND VGND VPWR VPWR sky130_fd_sc_hd__decap_3
XFILLER_33_729 VGND VGND VPWR VPWR sky130_fd_sc_hd__fill_2
XFILLER_26_792 VGND VGND VPWR VPWR sky130_fd_sc_hd__fill_1
XFILLER_45_589 VGND VGND VPWR VPWR sky130_fd_sc_hd__decap_3
XFILLER_60_515 VGND VGND VPWR VPWR sky130_fd_sc_hd__decap_3
XFILLER_72_375 VGND VGND VPWR VPWR sky130_fd_sc_hd__decap_3
XFILLER_13_420 VGND VGND VPWR VPWR sky130_fd_sc_hd__decap_3
XFILLER_60_559 VGND VGND VPWR VPWR sky130_fd_sc_hd__fill_1
XFILLER_13_486 VGND VGND VPWR VPWR sky130_fd_sc_hd__fill_1
XFILLER_9_479 VGND VGND VPWR VPWR sky130_fd_sc_hd__decap_3
XFILLER_5_641 VGND VGND VPWR VPWR sky130_fd_sc_hd__decap_3
XTAP_TAPCELL_ROW_130_2112 VGND VPWR sky130_fd_sc_hd__tapvpwrvgnd_1
XFILLER_126_399 VGND VGND VPWR VPWR sky130_fd_sc_hd__decap_3
XFILLER_5_685 VGND VGND VPWR VPWR sky130_fd_sc_hd__decap_3
XFILLER_4_195 VGND VGND VPWR VPWR sky130_fd_sc_hd__fill_1
XFILLER_4_44 VGND VGND VPWR VPWR sky130_fd_sc_hd__decap_3
XFILLER_4_77 VGND VGND VPWR VPWR sky130_fd_sc_hd__decap_3
XFILLER_4_88 VGND VGND VPWR VPWR sky130_fd_sc_hd__decap_3
XFILLER_67_125 VGND VGND VPWR VPWR sky130_fd_sc_hd__decap_3
XFILLER_95_467 VGND VGND VPWR VPWR sky130_fd_sc_hd__decap_3
X_4090_ _8081_/Q _8162_/Q _8243_/Q _8324_/Q _4090_/S0 _4091_/S1 VGND VGND VPWR VPWR
+ _4090_/X sky130_fd_sc_hd__mux4_2
XFILLER_67_169 VGND VGND VPWR VPWR sky130_fd_sc_hd__fill_1
XTAP_TAPCELL_ROW_128_2085 VGND VPWR sky130_fd_sc_hd__tapvpwrvgnd_1
XFILLER_48_394 VGND VGND VPWR VPWR sky130_fd_sc_hd__decap_3
XFILLER_63_331 VGND VGND VPWR VPWR sky130_fd_sc_hd__decap_3
XFILLER_91_673 VGND VGND VPWR VPWR sky130_fd_sc_hd__decap_3
X_6800_ _6800_/A VGND VGND VPWR VPWR _8443_/D sky130_fd_sc_hd__buf_2
XFILLER_23_228 VGND VGND VPWR VPWR sky130_fd_sc_hd__decap_3
XFILLER_51_515 VGND VGND VPWR VPWR sky130_fd_sc_hd__decap_3
Xclkbuf_4_15_0_CLK clkbuf_0_CLK/X VGND VGND VPWR VPWR clkbuf_4_15_0_CLK/X sky130_fd_sc_hd__clkbuf_8
X_7780_ _8766_/CLK _7780_/D wire574/A VGND VGND VPWR VPWR _7780_/Q sky130_fd_sc_hd__dfrtp_2
X_4992_ _4992_/A VGND VGND VPWR VPWR _7568_/D sky130_fd_sc_hd__buf_1
XFILLER_32_751 VGND VGND VPWR VPWR sky130_fd_sc_hd__fill_2
XTAP_TAPCELL_ROW_34_768 VGND VPWR sky130_fd_sc_hd__tapvpwrvgnd_1
X_3943_ _8392_/Q _8473_/Q _8554_/Q _8635_/Q _3973_/S _3943_/S1 VGND VGND VPWR VPWR
+ _3943_/X sky130_fd_sc_hd__mux4_2
X_6731_ _6731_/A VGND VGND VPWR VPWR _8410_/D sky130_fd_sc_hd__buf_2
X_3874_ _8062_/Q _8143_/Q _8224_/Q _8305_/Q _3868_/S _3869_/A VGND VGND VPWR VPWR
+ _3875_/B sky130_fd_sc_hd__mux4_2
X_6662_ _6830_/S VGND VGND VPWR VPWR _6681_/S sky130_fd_sc_hd__buf_2
XTAP_TAPCELL_ROW_14_492 VGND VPWR sky130_fd_sc_hd__tapvpwrvgnd_1
X_8401_ _8569_/CLK _8401_/D load_slew494/X VGND VGND VPWR VPWR _8401_/Q sky130_fd_sc_hd__dfrtp_2
X_5613_ _5613_/A VGND VGND VPWR VPWR _7850_/D sky130_fd_sc_hd__buf_1
XFILLER_117_311 VGND VGND VPWR VPWR sky130_fd_sc_hd__fill_1
X_8332_ _8737_/CLK _8332_/D load_slew511/X VGND VGND VPWR VPWR _8332_/Q sky130_fd_sc_hd__dfrtp_2
X_6593_ _6656_/S VGND VGND VPWR VPWR _6612_/S sky130_fd_sc_hd__buf_6
XFILLER_129_193 VGND VGND VPWR VPWR sky130_fd_sc_hd__decap_3
XTAP_TAPCELL_ROW_115_1907 VGND VPWR sky130_fd_sc_hd__tapvpwrvgnd_1
X_5544_ _5544_/A VGND VGND VPWR VPWR _7817_/D sky130_fd_sc_hd__buf_1
X_8263_ _8749_/CLK _8263_/D fanout624/X VGND VGND VPWR VPWR _8263_/Q sky130_fd_sc_hd__dfrtp_2
X_5475_ _5475_/A VGND VGND VPWR VPWR _7785_/D sky130_fd_sc_hd__buf_1
XFILLER_132_325 VGND VGND VPWR VPWR sky130_fd_sc_hd__decap_3
XFILLER_99_740 VGND VGND VPWR VPWR sky130_fd_sc_hd__decap_3
X_8194_ _8597_/CLK _8194_/D fanout705/X VGND VGND VPWR VPWR _8194_/Q sky130_fd_sc_hd__dfrtp_2
X_7214_ _7202_/X _4723_/X _7204_/X _7205_/X hold779/X VGND VGND VPWR VPWR _8649_/D
+ sky130_fd_sc_hd__a32o_2
X_4426_ _8759_/Q _7534_/Q _4446_/S VGND VGND VPWR VPWR _4426_/X sky130_fd_sc_hd__mux2_2
XFILLER_132_358 VGND VGND VPWR VPWR sky130_fd_sc_hd__decap_3
Xfanout403 fanout414/X VGND VGND VPWR VPWR _4074_/S sky130_fd_sc_hd__clkdlybuf4s25_1
Xfanout414 _8044_/Q VGND VGND VPWR VPWR fanout414/X sky130_fd_sc_hd__clkdlybuf4s25_1
X_7145_ _4883_/X _8606_/Q _7151_/S VGND VGND VPWR VPWR _7146_/A sky130_fd_sc_hd__mux2_2
XFILLER_100_200 VGND VGND VPWR VPWR sky130_fd_sc_hd__fill_1
XFILLER_101_701 VGND VGND VPWR VPWR sky130_fd_sc_hd__decap_3
XFILLER_113_561 VGND VGND VPWR VPWR sky130_fd_sc_hd__decap_3
XFILLER_86_412 VGND VGND VPWR VPWR sky130_fd_sc_hd__decap_3
Xfanout425 fanout433/X VGND VGND VPWR VPWR _4494_/S sky130_fd_sc_hd__clkdlybuf4s25_1
Xfanout436 fanout443/X VGND VGND VPWR VPWR _4302_/S sky130_fd_sc_hd__clkdlybuf4s25_1
Xfanout447 _3845_/S VGND VGND VPWR VPWR _3838_/S0 sky130_fd_sc_hd__clkdlybuf4s25_1
X_4357_ _8348_/Q _3767_/A _3817_/A _8267_/Q _4525_/S VGND VGND VPWR VPWR _4357_/X
+ sky130_fd_sc_hd__o221a_2
XFILLER_100_233 VGND VGND VPWR VPWR sky130_fd_sc_hd__decap_3
XFILLER_58_136 VGND VGND VPWR VPWR sky130_fd_sc_hd__decap_3
XFILLER_59_659 VGND VGND VPWR VPWR sky130_fd_sc_hd__fill_2
XFILLER_86_445 VGND VGND VPWR VPWR sky130_fd_sc_hd__fill_2
XTAP_TAPCELL_ROW_70_1269 VGND VPWR sky130_fd_sc_hd__tapvpwrvgnd_1
X_7076_ _4745_/X hold943/X _7088_/S VGND VGND VPWR VPWR _7077_/A sky130_fd_sc_hd__mux2_1
X_4288_ _4285_/X _4286_/X _4287_/X _4684_/B2 _4684_/C1 VGND VGND VPWR VPWR _4288_/X
+ sky130_fd_sc_hd__a221o_2
XFILLER_104_45 VGND VGND VPWR VPWR sky130_fd_sc_hd__decap_3
XFILLER_39_350 VGND VGND VPWR VPWR sky130_fd_sc_hd__fill_2
XFILLER_46_309 VGND VGND VPWR VPWR sky130_fd_sc_hd__decap_3
X_6027_ _6027_/A VGND VGND VPWR VPWR _8080_/D sky130_fd_sc_hd__buf_2
XFILLER_27_534 VGND VGND VPWR VPWR sky130_fd_sc_hd__decap_3
XFILLER_67_692 VGND VGND VPWR VPWR sky130_fd_sc_hd__fill_2
XFILLER_54_342 VGND VGND VPWR VPWR sky130_fd_sc_hd__fill_1
XFILLER_120_22 VGND VGND VPWR VPWR sky130_fd_sc_hd__fill_2
XFILLER_15_729 VGND VGND VPWR VPWR sky130_fd_sc_hd__fill_1
XFILLER_42_515 VGND VGND VPWR VPWR sky130_fd_sc_hd__decap_3
XFILLER_54_386 VGND VGND VPWR VPWR sky130_fd_sc_hd__fill_1
XFILLER_81_161 VGND VGND VPWR VPWR sky130_fd_sc_hd__fill_1
XFILLER_81_172 VGND VGND VPWR VPWR sky130_fd_sc_hd__decap_3
X_7978_ _8637_/CLK _7978_/D wire603/X VGND VGND VPWR VPWR _7978_/Q sky130_fd_sc_hd__dfrtp_2
X_6929_ _4795_/X _8504_/Q _6937_/S VGND VGND VPWR VPWR _6930_/A sky130_fd_sc_hd__mux2_4
XFILLER_22_261 VGND VGND VPWR VPWR sky130_fd_sc_hd__decap_3
XFILLER_23_773 VGND VGND VPWR VPWR sky130_fd_sc_hd__decap_3
XFILLER_13_42 VGND VGND VPWR VPWR sky130_fd_sc_hd__decap_3
XFILLER_50_592 VGND VGND VPWR VPWR sky130_fd_sc_hd__decap_3
XFILLER_10_467 VGND VGND VPWR VPWR sky130_fd_sc_hd__decap_3
XFILLER_127_108 VGND VGND VPWR VPWR sky130_fd_sc_hd__decap_3
XFILLER_127_119 VGND VGND VPWR VPWR sky130_fd_sc_hd__decap_3
XFILLER_129_42 VGND VGND VPWR VPWR sky130_fd_sc_hd__decap_3
XFILLER_13_75 VGND VGND VPWR VPWR sky130_fd_sc_hd__decap_3
XFILLER_108_322 VGND VGND VPWR VPWR sky130_fd_sc_hd__decap_3
XFILLER_129_75 VGND VGND VPWR VPWR sky130_fd_sc_hd__decap_3
XFILLER_89_13 VGND VGND VPWR VPWR sky130_fd_sc_hd__fill_1
XFILLER_135_141 VGND VGND VPWR VPWR sky130_fd_sc_hd__decap_3
XFILLER_89_46 VGND VGND VPWR VPWR sky130_fd_sc_hd__decap_3
XFILLER_89_57 VGND VGND VPWR VPWR sky130_fd_sc_hd__fill_1
XFILLER_2_622 VGND VGND VPWR VPWR sky130_fd_sc_hd__decap_3
XFILLER_2_666 VGND VGND VPWR VPWR sky130_fd_sc_hd__decap_3
XFILLER_2_699 VGND VGND VPWR VPWR sky130_fd_sc_hd__fill_1
XFILLER_49_125 VGND VGND VPWR VPWR sky130_fd_sc_hd__decap_3
XTAP_TAPCELL_ROW_88_1519 VGND VPWR sky130_fd_sc_hd__tapvpwrvgnd_1
XFILLER_57_180 VGND VGND VPWR VPWR sky130_fd_sc_hd__fill_2
XFILLER_58_681 VGND VGND VPWR VPWR sky130_fd_sc_hd__decap_3
XFILLER_64_139 VGND VGND VPWR VPWR sky130_fd_sc_hd__fill_1
XFILLER_18_545 VGND VGND VPWR VPWR sky130_fd_sc_hd__fill_2
XFILLER_18_578 VGND VGND VPWR VPWR sky130_fd_sc_hd__fill_1
XFILLER_18_589 VGND VGND VPWR VPWR sky130_fd_sc_hd__decap_3
XFILLER_60_312 VGND VGND VPWR VPWR sky130_fd_sc_hd__decap_3
XFILLER_73_673 VGND VGND VPWR VPWR sky130_fd_sc_hd__decap_3
XTAP_TAPCELL_ROW_31_727 VGND VPWR sky130_fd_sc_hd__tapvpwrvgnd_1
XFILLER_118_119 VGND VGND VPWR VPWR sky130_fd_sc_hd__fill_2
XFILLER_9_265 VGND VGND VPWR VPWR sky130_fd_sc_hd__decap_3
XTAP_TAPCELL_ROW_11_440 VGND VPWR sky130_fd_sc_hd__tapvpwrvgnd_1
XFILLER_127_620 VGND VGND VPWR VPWR sky130_fd_sc_hd__decap_3
XFILLER_127_642 VGND VGND VPWR VPWR sky130_fd_sc_hd__decap_3
XTAP_TAPCELL_ROW_11_451 VGND VPWR sky130_fd_sc_hd__tapvpwrvgnd_1
Xclkload13 _7669_/CLK VGND VGND VPWR VPWR clkload13/Y sky130_fd_sc_hd__inv_6
Xclkload24 _8586_/CLK VGND VGND VPWR VPWR clkload24/X sky130_fd_sc_hd__clkbuf_8
Xclkload35 _8161_/CLK VGND VGND VPWR VPWR clkload35/Y sky130_fd_sc_hd__inv_6
XFILLER_126_141 VGND VGND VPWR VPWR sky130_fd_sc_hd__decap_3
Xclkload46 _8753_/CLK VGND VGND VPWR VPWR clkload46/X sky130_fd_sc_hd__clkbuf_4
Xclkload57 _8790_/CLK VGND VGND VPWR VPWR clkload57/Y sky130_fd_sc_hd__bufinv_16
Xclkload68 _8678_/CLK VGND VGND VPWR VPWR clkload68/Y sky130_fd_sc_hd__bufinv_16
XFILLER_127_697 VGND VGND VPWR VPWR sky130_fd_sc_hd__decap_3
Xclkload79 _8530_/CLK VGND VGND VPWR VPWR clkload79/Y sky130_fd_sc_hd__clkinv_2
X_5260_ _7684_/Q _4795_/X _5268_/S VGND VGND VPWR VPWR _5261_/A sky130_fd_sc_hd__mux2_2
XFILLER_114_358 VGND VGND VPWR VPWR sky130_fd_sc_hd__decap_3
X_4211_ _4151_/A _4209_/X _4210_/X VGND VGND VPWR VPWR _4211_/X sky130_fd_sc_hd__o21a_2
XTAP_TAPCELL_ROW_110_1826 VGND VPWR sky130_fd_sc_hd__tapvpwrvgnd_1
XTAP_TAPCELL_ROW_110_1837 VGND VPWR sky130_fd_sc_hd__tapvpwrvgnd_1
XTAP_TAPCELL_ROW_56_1080 VGND VPWR sky130_fd_sc_hd__tapvpwrvgnd_1
X_5191_ _7651_/Q _4999_/X _5205_/S VGND VGND VPWR VPWR _5192_/A sky130_fd_sc_hd__mux2_2
XFILLER_110_542 VGND VGND VPWR VPWR sky130_fd_sc_hd__fill_2
XFILLER_96_754 VGND VGND VPWR VPWR sky130_fd_sc_hd__fill_2
X_4142_ _7671_/Q _3799_/X _4424_/A2 _7590_/Q _3871_/X VGND VGND VPWR VPWR _4142_/X
+ sky130_fd_sc_hd__o221a_2
XFILLER_110_564 VGND VGND VPWR VPWR sky130_fd_sc_hd__decap_3
XFILLER_49_670 VGND VGND VPWR VPWR sky130_fd_sc_hd__fill_2
XFILLER_95_275 VGND VGND VPWR VPWR sky130_fd_sc_hd__decap_3
X_4073_ _3760_/X _4068_/X _4072_/X VGND VGND VPWR VPWR _4073_/X sky130_fd_sc_hd__a21o_2
XFILLER_110_586 VGND VGND VPWR VPWR sky130_fd_sc_hd__fill_2
XTAP_TAPCELL_ROW_39_838 VGND VPWR sky130_fd_sc_hd__tapvpwrvgnd_1
X_7901_ _8470_/CLK _7901_/D load_slew589/X VGND VGND VPWR VPWR _7901_/Q sky130_fd_sc_hd__dfrtp_2
XFILLER_48_191 VGND VGND VPWR VPWR sky130_fd_sc_hd__decap_3
XFILLER_91_481 VGND VGND VPWR VPWR sky130_fd_sc_hd__decap_3
XTAP_TAPCELL_ROW_108_1799 VGND VPWR sky130_fd_sc_hd__tapvpwrvgnd_1
XTAP_TAPCELL_ROW_19_562 VGND VPWR sky130_fd_sc_hd__tapvpwrvgnd_1
X_7832_ _8730_/CLK _7832_/D load_slew484/X VGND VGND VPWR VPWR _7832_/Q sky130_fd_sc_hd__dfrtp_2
XFILLER_51_334 VGND VGND VPWR VPWR sky130_fd_sc_hd__fill_2
XFILLER_63_183 VGND VGND VPWR VPWR sky130_fd_sc_hd__fill_2
X_7763_ _8745_/CLK _7763_/D wire618/X VGND VGND VPWR VPWR _7763_/Q sky130_fd_sc_hd__dfrtp_2
X_4975_ _4975_/A VGND VGND VPWR VPWR _7564_/D sky130_fd_sc_hd__buf_1
XFILLER_20_710 VGND VGND VPWR VPWR sky130_fd_sc_hd__decap_3
X_3926_ _8714_/Q _8795_/Q _7570_/Q _7651_/Q _3957_/S _3993_/A VGND VGND VPWR VPWR
+ _3926_/X sky130_fd_sc_hd__mux4_2
X_6714_ _6714_/A VGND VGND VPWR VPWR _8402_/D sky130_fd_sc_hd__buf_2
XTAP_TAPCELL_ROW_121_1988 VGND VPWR sky130_fd_sc_hd__tapvpwrvgnd_1
X_7694_ _8758_/CLK _7694_/D load_slew712/X VGND VGND VPWR VPWR _7694_/Q sky130_fd_sc_hd__dfrtp_2
XFILLER_50_29 VGND VGND VPWR VPWR sky130_fd_sc_hd__decap_3
X_3857_ _3862_/A _3857_/B VGND VGND VPWR VPWR _3857_/X sky130_fd_sc_hd__or2_2
Xclkload7 clkload7/A VGND VGND VPWR VPWR clkload7/X sky130_fd_sc_hd__clkbuf_8
X_6645_ _6645_/A VGND VGND VPWR VPWR _8371_/D sky130_fd_sc_hd__buf_2
X_3788_ _7722_/Q _7803_/Q _7884_/Q _7965_/Q _3824_/S _3825_/A VGND VGND VPWR VPWR
+ _3788_/X sky130_fd_sc_hd__mux4_2
X_6576_ _6576_/A VGND VGND VPWR VPWR _8338_/D sky130_fd_sc_hd__buf_2
XFILLER_118_664 VGND VGND VPWR VPWR sky130_fd_sc_hd__decap_3
XFILLER_119_9 VGND VGND VPWR VPWR sky130_fd_sc_hd__decap_3
X_8315_ _8801_/CLK _8315_/D load_slew608/X VGND VGND VPWR VPWR _8315_/Q sky130_fd_sc_hd__dfrtp_2
X_5527_ _5527_/A VGND VGND VPWR VPWR _7809_/D sky130_fd_sc_hd__buf_1
XFILLER_132_100 VGND VGND VPWR VPWR sky130_fd_sc_hd__decap_3
XFILLER_133_612 VGND VGND VPWR VPWR sky130_fd_sc_hd__decap_3
XFILLER_133_623 VGND VGND VPWR VPWR sky130_fd_sc_hd__decap_3
X_8246_ _8493_/CLK _8246_/D fanout475/A VGND VGND VPWR VPWR _8246_/Q sky130_fd_sc_hd__dfrtp_2
XFILLER_105_369 VGND VGND VPWR VPWR sky130_fd_sc_hd__fill_2
XFILLER_132_133 VGND VGND VPWR VPWR sky130_fd_sc_hd__decap_3
XFILLER_132_144 VGND VGND VPWR VPWR sky130_fd_sc_hd__decap_3
XFILLER_133_656 VGND VGND VPWR VPWR sky130_fd_sc_hd__decap_3
XFILLER_1_9 VGND VGND VPWR VPWR sky130_fd_sc_hd__decap_3
XFILLER_59_49 VGND VGND VPWR VPWR sky130_fd_sc_hd__fill_1
X_5458_ _5458_/A VGND VGND VPWR VPWR _7777_/D sky130_fd_sc_hd__buf_1
XFILLER_132_177 VGND VGND VPWR VPWR sky130_fd_sc_hd__decap_3
XFILLER_99_570 VGND VGND VPWR VPWR sky130_fd_sc_hd__fill_1
X_8177_ _8427_/CLK _8177_/D wire631/A VGND VGND VPWR VPWR _8177_/Q sky130_fd_sc_hd__dfrtp_2
X_5389_ _5389_/A VGND VGND VPWR VPWR _7744_/D sky130_fd_sc_hd__buf_1
X_4409_ _8353_/Q _3806_/X _4065_/X _8272_/Q _3791_/A VGND VGND VPWR VPWR _4409_/X
+ sky130_fd_sc_hd__o221a_2
XFILLER_101_531 VGND VGND VPWR VPWR sky130_fd_sc_hd__fill_1
XFILLER_113_391 VGND VGND VPWR VPWR sky130_fd_sc_hd__fill_1
XFILLER_115_44 VGND VGND VPWR VPWR sky130_fd_sc_hd__fill_1
XFILLER_120_339 VGND VGND VPWR VPWR sky130_fd_sc_hd__decap_3
X_7128_ _4849_/X _8598_/Q _7130_/S VGND VGND VPWR VPWR _7129_/A sky130_fd_sc_hd__mux2_2
XFILLER_101_564 VGND VGND VPWR VPWR sky130_fd_sc_hd__decap_3
XFILLER_115_66 VGND VGND VPWR VPWR sky130_fd_sc_hd__decap_3
XFILLER_19_309 VGND VGND VPWR VPWR sky130_fd_sc_hd__decap_3
XFILLER_74_415 VGND VGND VPWR VPWR sky130_fd_sc_hd__decap_3
Xfanout277 _7004_/A VGND VGND VPWR VPWR _6314_/A sky130_fd_sc_hd__clkdlybuf4s25_1
Xfanout288 _4526_/S VGND VGND VPWR VPWR _4000_/A sky130_fd_sc_hd__clkdlybuf4s25_1
Xfanout299 _8047_/Q VGND VGND VPWR VPWR fanout299/X sky130_fd_sc_hd__clkdlybuf4s25_1
X_7059_ _4711_/X _8565_/Q _7067_/S VGND VGND VPWR VPWR _7060_/A sky130_fd_sc_hd__mux2_2
XFILLER_86_297 VGND VGND VPWR VPWR sky130_fd_sc_hd__fill_2
XFILLER_131_21 VGND VGND VPWR VPWR sky130_fd_sc_hd__decap_3
XFILLER_27_331 VGND VGND VPWR VPWR sky130_fd_sc_hd__fill_1
XFILLER_43_802 VGND VGND VPWR VPWR sky130_fd_sc_hd__fill_2
XFILLER_131_54 VGND VGND VPWR VPWR sky130_fd_sc_hd__fill_2
XFILLER_54_161 VGND VGND VPWR VPWR sky130_fd_sc_hd__fill_2
XFILLER_70_610 VGND VGND VPWR VPWR sky130_fd_sc_hd__decap_3
XFILLER_131_87 VGND VGND VPWR VPWR sky130_fd_sc_hd__decap_3
XFILLER_15_559 VGND VGND VPWR VPWR sky130_fd_sc_hd__fill_1
XTAP_TAPCELL_ROW_83_1449 VGND VPWR sky130_fd_sc_hd__tapvpwrvgnd_1
XFILLER_24_41 VGND VGND VPWR VPWR sky130_fd_sc_hd__decap_3
XFILLER_42_389 VGND VGND VPWR VPWR sky130_fd_sc_hd__fill_1
XFILLER_91_69 VGND VGND VPWR VPWR sky130_fd_sc_hd__decap_3
XFILLER_11_721 VGND VGND VPWR VPWR sky130_fd_sc_hd__decap_3
XFILLER_11_732 VGND VGND VPWR VPWR sky130_fd_sc_hd__decap_3
XFILLER_23_570 VGND VGND VPWR VPWR sky130_fd_sc_hd__decap_3
XFILLER_24_74 VGND VGND VPWR VPWR sky130_fd_sc_hd__decap_3
XFILLER_10_253 VGND VGND VPWR VPWR sky130_fd_sc_hd__decap_3
XFILLER_11_765 VGND VGND VPWR VPWR sky130_fd_sc_hd__decap_3
XFILLER_128_417 VGND VGND VPWR VPWR sky130_fd_sc_hd__decap_3
XFILLER_7_703 VGND VGND VPWR VPWR sky130_fd_sc_hd__decap_3
XFILLER_109_620 VGND VGND VPWR VPWR sky130_fd_sc_hd__decap_3
XFILLER_10_286 VGND VGND VPWR VPWR sky130_fd_sc_hd__fill_2
XFILLER_128_439 VGND VGND VPWR VPWR sky130_fd_sc_hd__decap_3
XFILLER_7_747 VGND VGND VPWR VPWR sky130_fd_sc_hd__decap_3
XFILLER_108_141 VGND VGND VPWR VPWR sky130_fd_sc_hd__decap_3
XTAP_TAPCELL_ROW_98_1670 VGND VPWR sky130_fd_sc_hd__tapvpwrvgnd_1
XFILLER_109_697 VGND VGND VPWR VPWR sky130_fd_sc_hd__decap_3
XFILLER_123_144 VGND VGND VPWR VPWR sky130_fd_sc_hd__decap_3
XFILLER_2_463 VGND VGND VPWR VPWR sky130_fd_sc_hd__decap_3
XFILLER_34_9 VGND VGND VPWR VPWR sky130_fd_sc_hd__fill_1
XFILLER_97_529 VGND VGND VPWR VPWR sky130_fd_sc_hd__fill_2
Xload_slew628 fanout627/X VGND VGND VPWR VPWR load_slew628/X sky130_fd_sc_hd__buf_4
XFILLER_1_12 VGND VGND VPWR VPWR sky130_fd_sc_hd__decap_3
XFILLER_38_607 VGND VGND VPWR VPWR sky130_fd_sc_hd__decap_3
XFILLER_1_45 VGND VGND VPWR VPWR sky130_fd_sc_hd__decap_3
XFILLER_37_117 VGND VGND VPWR VPWR sky130_fd_sc_hd__decap_3
XFILLER_92_212 VGND VGND VPWR VPWR sky130_fd_sc_hd__decap_3
XFILLER_93_757 VGND VGND VPWR VPWR sky130_fd_sc_hd__decap_3
XFILLER_1_78 VGND VGND VPWR VPWR sky130_fd_sc_hd__decap_3
XFILLER_46_640 VGND VGND VPWR VPWR sky130_fd_sc_hd__decap_3
XFILLER_92_256 VGND VGND VPWR VPWR sky130_fd_sc_hd__decap_3
XTAP_TAPCELL_ROW_125_2044 VGND VPWR sky130_fd_sc_hd__tapvpwrvgnd_1
XFILLER_61_610 VGND VGND VPWR VPWR sky130_fd_sc_hd__decap_3
XFILLER_65_81 VGND VGND VPWR VPWR sky130_fd_sc_hd__fill_2
XFILLER_65_92 VGND VGND VPWR VPWR sky130_fd_sc_hd__fill_2
XFILLER_33_334 VGND VGND VPWR VPWR sky130_fd_sc_hd__fill_2
XTAP_TAPCELL_ROW_16_510 VGND VPWR sky130_fd_sc_hd__tapvpwrvgnd_1
XTAP_TAPCELL_ROW_16_521 VGND VPWR sky130_fd_sc_hd__tapvpwrvgnd_1
XFILLER_14_581 VGND VGND VPWR VPWR sky130_fd_sc_hd__decap_3
XFILLER_33_389 VGND VGND VPWR VPWR sky130_fd_sc_hd__decap_3
X_4760_ _4760_/A _4776_/B VGND VGND VPWR VPWR _4761_/A sky130_fd_sc_hd__and2_2
XPHY_EDGE_ROW_112_Right_112 VGND VGND VPWR VPWR sky130_fd_sc_hd__decap_3
X_3711_ _8051_/Q _3712_/A _6658_/B VGND VGND VPWR VPWR _5962_/C sky130_fd_sc_hd__and3_2
X_4691_ _4691_/A VGND VGND VPWR VPWR _4691_/X sky130_fd_sc_hd__buf_1
X_6430_ _4833_/X _8270_/Q _6440_/S VGND VGND VPWR VPWR _6431_/A sky130_fd_sc_hd__mux2_2
XFILLER_127_461 VGND VGND VPWR VPWR sky130_fd_sc_hd__decap_3
X_6361_ _5036_/X _8237_/Q _6377_/S VGND VGND VPWR VPWR _6362_/A sky130_fd_sc_hd__mux2_2
XFILLER_114_111 VGND VGND VPWR VPWR sky130_fd_sc_hd__decap_3
XFILLER_127_494 VGND VGND VPWR VPWR sky130_fd_sc_hd__decap_3
XPHY_EDGE_ROW_49_Right_49 VGND VGND VPWR VPWR sky130_fd_sc_hd__decap_3
X_8100_ _8748_/CLK _8100_/D fanout639/X VGND VGND VPWR VPWR _8100_/Q sky130_fd_sc_hd__dfrtp_2
X_5312_ _5333_/S VGND VGND VPWR VPWR _5331_/S sky130_fd_sc_hd__buf_2
XFILLER_114_144 VGND VGND VPWR VPWR sky130_fd_sc_hd__decap_3
XFILLER_5_290 VGND VGND VPWR VPWR sky130_fd_sc_hd__decap_3
X_6292_ _4899_/X _8205_/Q _6310_/S VGND VGND VPWR VPWR _6293_/A sky130_fd_sc_hd__mux2_4
XFILLER_114_166 VGND VGND VPWR VPWR sky130_fd_sc_hd__decap_3
XFILLER_130_604 VGND VGND VPWR VPWR sky130_fd_sc_hd__decap_3
XFILLER_88_518 VGND VGND VPWR VPWR sky130_fd_sc_hd__decap_3
X_8031_ _8689_/CLK _8031_/D wire552/A VGND VGND VPWR VPWR _8031_/Q sky130_fd_sc_hd__dfrtp_2
X_5243_ _7676_/Q _4761_/X _5247_/S VGND VGND VPWR VPWR _5244_/A sky130_fd_sc_hd__mux2_2
XFILLER_130_637 VGND VGND VPWR VPWR sky130_fd_sc_hd__decap_3
XFILLER_130_648 VGND VGND VPWR VPWR sky130_fd_sc_hd__decap_3
XFILLER_69_732 VGND VGND VPWR VPWR sky130_fd_sc_hd__fill_1
X_5174_ _5174_/A0 _4965_/X _5184_/S VGND VGND VPWR VPWR _5175_/A sky130_fd_sc_hd__mux2_2
XFILLER_29_629 VGND VGND VPWR VPWR sky130_fd_sc_hd__decap_3
XFILLER_96_573 VGND VGND VPWR VPWR sky130_fd_sc_hd__decap_3
X_4125_ _4125_/A _4125_/B VGND VGND VPWR VPWR _4125_/X sky130_fd_sc_hd__or2_2
XFILLER_83_201 VGND VGND VPWR VPWR sky130_fd_sc_hd__decap_3
XFILLER_84_746 VGND VGND VPWR VPWR sky130_fd_sc_hd__decap_3
XFILLER_84_757 VGND VGND VPWR VPWR sky130_fd_sc_hd__decap_3
XFILLER_25_802 VGND VGND VPWR VPWR sky130_fd_sc_hd__fill_2
XFILLER_83_234 VGND VGND VPWR VPWR sky130_fd_sc_hd__decap_3
XPHY_EDGE_ROW_58_Right_58 VGND VGND VPWR VPWR sky130_fd_sc_hd__decap_3
X_4056_ _8078_/Q _8159_/Q _8240_/Q _8321_/Q _4035_/S _4036_/A VGND VGND VPWR VPWR
+ _4056_/X sky130_fd_sc_hd__mux4_2
XFILLER_37_662 VGND VGND VPWR VPWR sky130_fd_sc_hd__fill_1
XFILLER_37_673 VGND VGND VPWR VPWR sky130_fd_sc_hd__decap_3
XTAP_TAPCELL_ROW_69_1260 VGND VPWR sky130_fd_sc_hd__tapvpwrvgnd_1
X_7815_ _8800_/CLK _7815_/D load_slew593/X VGND VGND VPWR VPWR _7815_/Q sky130_fd_sc_hd__dfrtp_2
XFILLER_101_57 VGND VGND VPWR VPWR sky130_fd_sc_hd__decap_3
XFILLER_51_131 VGND VGND VPWR VPWR sky130_fd_sc_hd__decap_3
XFILLER_51_164 VGND VGND VPWR VPWR sky130_fd_sc_hd__decap_3
XFILLER_52_676 VGND VGND VPWR VPWR sky130_fd_sc_hd__decap_3
X_8795_ _8795_/CLK _8795_/D fanout607/A VGND VGND VPWR VPWR _8795_/Q sky130_fd_sc_hd__dfrtp_2
XFILLER_12_529 VGND VGND VPWR VPWR sky130_fd_sc_hd__decap_3
XFILLER_51_197 VGND VGND VPWR VPWR sky130_fd_sc_hd__decap_3
XFILLER_61_28 VGND VGND VPWR VPWR sky130_fd_sc_hd__decap_3
X_7746_ _8483_/CLK _7746_/D fanout504/X VGND VGND VPWR VPWR _7746_/Q sky130_fd_sc_hd__dfrtp_2
X_4958_ _4957_/X _7560_/Q _4986_/S VGND VGND VPWR VPWR _4959_/A sky130_fd_sc_hd__mux2_2
X_3909_ _7731_/Q _7812_/Q _3983_/S VGND VGND VPWR VPWR _3910_/B sky130_fd_sc_hd__mux2_2
X_7677_ _8586_/CLK _7677_/D fanout537/X VGND VGND VPWR VPWR _7677_/Q sky130_fd_sc_hd__dfrtp_2
X_4889_ _4889_/A VGND VGND VPWR VPWR _7544_/D sky130_fd_sc_hd__buf_1
X_6628_ _6628_/A VGND VGND VPWR VPWR _8363_/D sky130_fd_sc_hd__buf_2
XFILLER_117_6 VGND VGND VPWR VPWR sky130_fd_sc_hd__decap_3
XPHY_EDGE_ROW_67_Right_67 VGND VGND VPWR VPWR sky130_fd_sc_hd__decap_3
XFILLER_106_623 VGND VGND VPWR VPWR sky130_fd_sc_hd__fill_2
XFILLER_10_21 VGND VGND VPWR VPWR sky130_fd_sc_hd__decap_3
XFILLER_4_728 VGND VGND VPWR VPWR sky130_fd_sc_hd__decap_3
X_6559_ _6559_/A VGND VGND VPWR VPWR _8330_/D sky130_fd_sc_hd__buf_2
XFILLER_106_645 VGND VGND VPWR VPWR sky130_fd_sc_hd__decap_3
XFILLER_106_667 VGND VGND VPWR VPWR sky130_fd_sc_hd__decap_3
XFILLER_10_32 VGND VGND VPWR VPWR sky130_fd_sc_hd__decap_3
XFILLER_126_21 VGND VGND VPWR VPWR sky130_fd_sc_hd__decap_3
XFILLER_133_420 VGND VGND VPWR VPWR sky130_fd_sc_hd__decap_3
XFILLER_10_65 VGND VGND VPWR VPWR sky130_fd_sc_hd__decap_3
XFILLER_120_103 VGND VGND VPWR VPWR sky130_fd_sc_hd__decap_3
XFILLER_126_32 VGND VGND VPWR VPWR sky130_fd_sc_hd__decap_3
XFILLER_133_464 VGND VGND VPWR VPWR sky130_fd_sc_hd__decap_3
X_8229_ _8796_/CLK _8229_/D fanout609/X VGND VGND VPWR VPWR _8229_/Q sky130_fd_sc_hd__dfrtp_2
XFILLER_126_65 VGND VGND VPWR VPWR sky130_fd_sc_hd__decap_3
XFILLER_133_497 VGND VGND VPWR VPWR sky130_fd_sc_hd__decap_3
XFILLER_86_25 VGND VGND VPWR VPWR sky130_fd_sc_hd__decap_3
XFILLER_86_47 VGND VGND VPWR VPWR sky130_fd_sc_hd__decap_3
XFILLER_120_147 VGND VGND VPWR VPWR sky130_fd_sc_hd__decap_3
XFILLER_19_30 VGND VGND VPWR VPWR sky130_fd_sc_hd__decap_3
XFILLER_47_404 VGND VGND VPWR VPWR sky130_fd_sc_hd__decap_3
XFILLER_59_242 VGND VGND VPWR VPWR sky130_fd_sc_hd__decap_3
XFILLER_19_63 VGND VGND VPWR VPWR sky130_fd_sc_hd__decap_3
XFILLER_59_275 VGND VGND VPWR VPWR sky130_fd_sc_hd__decap_3
XPHY_EDGE_ROW_76_Right_76 VGND VGND VPWR VPWR sky130_fd_sc_hd__decap_3
XFILLER_19_139 VGND VGND VPWR VPWR sky130_fd_sc_hd__fill_1
XFILLER_74_256 VGND VGND VPWR VPWR sky130_fd_sc_hd__fill_1
XFILLER_75_779 VGND VGND VPWR VPWR sky130_fd_sc_hd__decap_3
XFILLER_16_802 VGND VGND VPWR VPWR sky130_fd_sc_hd__fill_2
XFILLER_28_662 VGND VGND VPWR VPWR sky130_fd_sc_hd__decap_3
XFILLER_27_172 VGND VGND VPWR VPWR sky130_fd_sc_hd__fill_2
XFILLER_35_40 VGND VGND VPWR VPWR sky130_fd_sc_hd__decap_3
XFILLER_43_654 VGND VGND VPWR VPWR sky130_fd_sc_hd__decap_3
XFILLER_35_84 VGND VGND VPWR VPWR sky130_fd_sc_hd__decap_3
XFILLER_43_676 VGND VGND VPWR VPWR sky130_fd_sc_hd__decap_3
XFILLER_42_164 VGND VGND VPWR VPWR sky130_fd_sc_hd__decap_3
XFILLER_42_197 VGND VGND VPWR VPWR sky130_fd_sc_hd__decap_3
XFILLER_70_473 VGND VGND VPWR VPWR sky130_fd_sc_hd__decap_3
XFILLER_70_495 VGND VGND VPWR VPWR sky130_fd_sc_hd__decap_3
XFILLER_128_203 VGND VGND VPWR VPWR sky130_fd_sc_hd__decap_3
XFILLER_129_715 VGND VGND VPWR VPWR sky130_fd_sc_hd__decap_3
XFILLER_7_500 VGND VGND VPWR VPWR sky130_fd_sc_hd__decap_3
XTAP_TAPCELL_ROW_41_866 VGND VPWR sky130_fd_sc_hd__tapvpwrvgnd_1
XFILLER_128_236 VGND VGND VPWR VPWR sky130_fd_sc_hd__decap_3
XFILLER_129_759 VGND VGND VPWR VPWR sky130_fd_sc_hd__decap_3
XFILLER_51_72 VGND VGND VPWR VPWR sky130_fd_sc_hd__fill_1
XFILLER_7_511 VGND VGND VPWR VPWR sky130_fd_sc_hd__decap_3
XPHY_EDGE_ROW_85_Right_85 VGND VGND VPWR VPWR sky130_fd_sc_hd__decap_3
XFILLER_116_409 VGND VGND VPWR VPWR sky130_fd_sc_hd__fill_2
XFILLER_11_595 VGND VGND VPWR VPWR sky130_fd_sc_hd__decap_3
XFILLER_51_94 VGND VGND VPWR VPWR sky130_fd_sc_hd__decap_3
XTAP_TAPCELL_ROW_21_590 VGND VPWR sky130_fd_sc_hd__tapvpwrvgnd_1
Xmax_cap208 _7179_/X VGND VGND VPWR VPWR _7187_/B1 sky130_fd_sc_hd__buf_2
XFILLER_7_599 VGND VGND VPWR VPWR sky130_fd_sc_hd__decap_3
XFILLER_124_442 VGND VGND VPWR VPWR sky130_fd_sc_hd__decap_3
XFILLER_3_750 VGND VGND VPWR VPWR sky130_fd_sc_hd__decap_3
XFILLER_111_125 VGND VGND VPWR VPWR sky130_fd_sc_hd__decap_3
XFILLER_124_497 VGND VGND VPWR VPWR sky130_fd_sc_hd__decap_3
XFILLER_32_6 VGND VGND VPWR VPWR sky130_fd_sc_hd__fill_1
XFILLER_3_783 VGND VGND VPWR VPWR sky130_fd_sc_hd__fill_1
XFILLER_3_794 VGND VGND VPWR VPWR sky130_fd_sc_hd__decap_3
XFILLER_97_337 VGND VGND VPWR VPWR sky130_fd_sc_hd__decap_3
XFILLER_111_169 VGND VGND VPWR VPWR sky130_fd_sc_hd__decap_3
XFILLER_66_713 VGND VGND VPWR VPWR sky130_fd_sc_hd__decap_3
XPHY_EDGE_ROW_94_Right_94 VGND VGND VPWR VPWR sky130_fd_sc_hd__decap_3
Xload_slew469 _4579_/S VGND VGND VPWR VPWR _4620_/S sky130_fd_sc_hd__buf_2
Xload_slew458 _4441_/S VGND VGND VPWR VPWR _4435_/S sky130_fd_sc_hd__buf_2
XFILLER_66_746 VGND VGND VPWR VPWR sky130_fd_sc_hd__decap_3
XFILLER_66_757 VGND VGND VPWR VPWR sky130_fd_sc_hd__decap_3
XFILLER_34_610 VGND VGND VPWR VPWR sky130_fd_sc_hd__decap_3
XFILLER_46_470 VGND VGND VPWR VPWR sky130_fd_sc_hd__decap_3
XTAP_TAPCELL_ROW_49_977 VGND VPWR sky130_fd_sc_hd__tapvpwrvgnd_1
X_5930_ _5920_/X _5932_/A2 _4845_/X _5932_/B1 hold826/X VGND VGND VPWR VPWR _8020_/D
+ sky130_fd_sc_hd__a32o_2
XFILLER_18_194 VGND VGND VPWR VPWR sky130_fd_sc_hd__fill_2
XFILLER_34_643 VGND VGND VPWR VPWR sky130_fd_sc_hd__fill_1
XFILLER_80_237 VGND VGND VPWR VPWR sky130_fd_sc_hd__decap_3
XFILLER_33_131 VGND VGND VPWR VPWR sky130_fd_sc_hd__decap_3
XFILLER_33_142 VGND VGND VPWR VPWR sky130_fd_sc_hd__fill_1
XFILLER_61_462 VGND VGND VPWR VPWR sky130_fd_sc_hd__decap_3
XFILLER_80_259 VGND VGND VPWR VPWR sky130_fd_sc_hd__decap_3
XTAP_TAPCELL_ROW_105_1758 VGND VPWR sky130_fd_sc_hd__tapvpwrvgnd_1
XTAP_TAPCELL_ROW_105_1769 VGND VPWR sky130_fd_sc_hd__tapvpwrvgnd_1
X_7600_ _8744_/CLK _7600_/D fanout627/X VGND VGND VPWR VPWR _7600_/Q sky130_fd_sc_hd__dfrtp_2
X_5861_ _5852_/X _5867_/A2 _4961_/X _5865_/B1 hold827/X VGND VGND VPWR VPWR _7966_/D
+ sky130_fd_sc_hd__a32o_2
XFILLER_21_304 VGND VGND VPWR VPWR sky130_fd_sc_hd__fill_2
XFILLER_21_326 VGND VGND VPWR VPWR sky130_fd_sc_hd__decap_3
XFILLER_21_337 VGND VGND VPWR VPWR sky130_fd_sc_hd__decap_3
XFILLER_33_186 VGND VGND VPWR VPWR sky130_fd_sc_hd__decap_3
X_8580_ _8746_/CLK _8580_/D load_slew621/X VGND VGND VPWR VPWR _8580_/Q sky130_fd_sc_hd__dfrtp_2
X_5792_ _5792_/A VGND VGND VPWR VPWR _7934_/D sky130_fd_sc_hd__buf_1
X_4812_ _4811_/X _7526_/Q _4820_/S VGND VGND VPWR VPWR _4813_/A sky130_fd_sc_hd__mux2_2
XTAP_TAPCELL_ROW_64_1190 VGND VPWR sky130_fd_sc_hd__tapvpwrvgnd_1
X_7531_ _8760_/CLK _7531_/D load_slew718/X VGND VGND VPWR VPWR _7531_/Q sky130_fd_sc_hd__dfrtp_2
X_4743_ _4743_/A VGND VGND VPWR VPWR _7509_/D sky130_fd_sc_hd__buf_1
XFILLER_119_225 VGND VGND VPWR VPWR sky130_fd_sc_hd__decap_3
X_7462_ _4965_/X _8787_/Q _7474_/S VGND VGND VPWR VPWR _7463_/A sky130_fd_sc_hd__mux2_2
XFILLER_135_707 VGND VGND VPWR VPWR sky130_fd_sc_hd__decap_3
X_6413_ _4799_/X hold968/X _6419_/S VGND VGND VPWR VPWR _6414_/A sky130_fd_sc_hd__mux2_1
X_4674_ _4674_/A VGND VGND VPWR VPWR _4674_/X sky130_fd_sc_hd__buf_1
XFILLER_128_781 VGND VGND VPWR VPWR sky130_fd_sc_hd__decap_3
XFILLER_134_206 VGND VGND VPWR VPWR sky130_fd_sc_hd__decap_3
XFILLER_135_729 VGND VGND VPWR VPWR sky130_fd_sc_hd__decap_3
X_7393_ _8754_/Q _4823_/A _7407_/S VGND VGND VPWR VPWR _7394_/A sky130_fd_sc_hd__mux2_2
XFILLER_115_442 VGND VGND VPWR VPWR sky130_fd_sc_hd__decap_3
XFILLER_1_709 VGND VGND VPWR VPWR sky130_fd_sc_hd__decap_3
X_6344_ _5003_/X hold939/X _6356_/S VGND VGND VPWR VPWR _6345_/A sky130_fd_sc_hd__mux2_1
XFILLER_103_626 VGND VGND VPWR VPWR sky130_fd_sc_hd__decap_3
XFILLER_115_475 VGND VGND VPWR VPWR sky130_fd_sc_hd__decap_3
XFILLER_88_315 VGND VGND VPWR VPWR sky130_fd_sc_hd__fill_2
X_6275_ _4866_/X _8197_/Q _6289_/S VGND VGND VPWR VPWR _6276_/A sky130_fd_sc_hd__mux2_4
XFILLER_130_445 VGND VGND VPWR VPWR sky130_fd_sc_hd__decap_3
X_8014_ _8274_/CLK _8014_/D load_slew696/X VGND VGND VPWR VPWR _8014_/Q sky130_fd_sc_hd__dfrtp_2
X_5226_ _7668_/Q _4727_/X _5226_/S VGND VGND VPWR VPWR _5227_/A sky130_fd_sc_hd__mux2_2
XFILLER_130_489 VGND VGND VPWR VPWR sky130_fd_sc_hd__decap_3
XFILLER_29_415 VGND VGND VPWR VPWR sky130_fd_sc_hd__decap_3
XFILLER_84_521 VGND VGND VPWR VPWR sky130_fd_sc_hd__decap_3
X_5157_ _5157_/A VGND VGND VPWR VPWR _7636_/D sky130_fd_sc_hd__buf_1
XFILLER_56_223 VGND VGND VPWR VPWR sky130_fd_sc_hd__decap_3
XFILLER_56_245 VGND VGND VPWR VPWR sky130_fd_sc_hd__decap_3
XPHY_EDGE_ROW_16_Left_152 VGND VGND VPWR VPWR sky130_fd_sc_hd__decap_3
X_5088_ _5088_/A VGND VGND VPWR VPWR _7603_/D sky130_fd_sc_hd__buf_1
X_4108_ _4106_/X _4107_/X _4514_/S VGND VGND VPWR VPWR _4108_/X sky130_fd_sc_hd__mux2_2
X_4039_ _8076_/Q _8157_/Q _8238_/Q _8319_/Q _4471_/S _4039_/S1 VGND VGND VPWR VPWR
+ _4040_/B sky130_fd_sc_hd__mux4_2
XFILLER_112_56 VGND VGND VPWR VPWR sky130_fd_sc_hd__decap_3
XFILLER_25_643 VGND VGND VPWR VPWR sky130_fd_sc_hd__decap_3
XFILLER_71_248 VGND VGND VPWR VPWR sky130_fd_sc_hd__decap_3
XFILLER_25_676 VGND VGND VPWR VPWR sky130_fd_sc_hd__fill_1
XFILLER_52_451 VGND VGND VPWR VPWR sky130_fd_sc_hd__fill_1
XFILLER_72_27 VGND VGND VPWR VPWR sky130_fd_sc_hd__fill_1
XFILLER_80_760 VGND VGND VPWR VPWR sky130_fd_sc_hd__fill_1
XTAP_TAPCELL_ROW_80_1408 VGND VPWR sky130_fd_sc_hd__tapvpwrvgnd_1
XFILLER_25_698 VGND VGND VPWR VPWR sky130_fd_sc_hd__decap_3
XTAP_TAPCELL_ROW_80_1419 VGND VPWR sky130_fd_sc_hd__tapvpwrvgnd_1
X_8778_ _8778_/CLK _8778_/D fanout730/X VGND VGND VPWR VPWR _8778_/Q sky130_fd_sc_hd__dfrtp_2
XFILLER_24_197 VGND VGND VPWR VPWR sky130_fd_sc_hd__decap_3
X_7729_ _8387_/CLK _7729_/D fanout654/X VGND VGND VPWR VPWR _7729_/Q sky130_fd_sc_hd__dfrtp_2
XPHY_EDGE_ROW_25_Left_161 VGND VGND VPWR VPWR sky130_fd_sc_hd__decap_3
XFILLER_115_3 VGND VGND VPWR VPWR sky130_fd_sc_hd__decap_3
XFILLER_119_781 VGND VGND VPWR VPWR sky130_fd_sc_hd__decap_3
XFILLER_125_228 VGND VGND VPWR VPWR sky130_fd_sc_hd__decap_3
XFILLER_21_42 VGND VGND VPWR VPWR sky130_fd_sc_hd__decap_3
XFILLER_106_442 VGND VGND VPWR VPWR sky130_fd_sc_hd__decap_3
XFILLER_134_740 VGND VGND VPWR VPWR sky130_fd_sc_hd__decap_3
XFILLER_21_75 VGND VGND VPWR VPWR sky130_fd_sc_hd__decap_3
XFILLER_133_261 VGND VGND VPWR VPWR sky130_fd_sc_hd__decap_3
XFILLER_134_784 VGND VGND VPWR VPWR sky130_fd_sc_hd__decap_3
XFILLER_79_315 VGND VGND VPWR VPWR sky130_fd_sc_hd__fill_1
XFILLER_121_423 VGND VGND VPWR VPWR sky130_fd_sc_hd__decap_3
XFILLER_79_337 VGND VGND VPWR VPWR sky130_fd_sc_hd__decap_3
XFILLER_0_753 VGND VGND VPWR VPWR sky130_fd_sc_hd__decap_3
XFILLER_121_445 VGND VGND VPWR VPWR sky130_fd_sc_hd__decap_3
XFILLER_121_478 VGND VGND VPWR VPWR sky130_fd_sc_hd__decap_3
XPHY_EDGE_ROW_34_Left_170 VGND VGND VPWR VPWR sky130_fd_sc_hd__decap_3
XFILLER_0_775 VGND VGND VPWR VPWR sky130_fd_sc_hd__decap_3
XFILLER_0_797 VGND VGND VPWR VPWR sky130_fd_sc_hd__decap_3
XTAP_TAPCELL_ROW_7_385 VGND VPWR sky130_fd_sc_hd__tapvpwrvgnd_1
XTAP_TAPCELL_ROW_7_396 VGND VPWR sky130_fd_sc_hd__tapvpwrvgnd_1
XFILLER_101_191 VGND VGND VPWR VPWR sky130_fd_sc_hd__decap_3
XFILLER_75_554 VGND VGND VPWR VPWR sky130_fd_sc_hd__fill_2
XFILLER_46_50 VGND VGND VPWR VPWR sky130_fd_sc_hd__decap_3
XFILLER_47_267 VGND VGND VPWR VPWR sky130_fd_sc_hd__fill_2
XFILLER_47_278 VGND VGND VPWR VPWR sky130_fd_sc_hd__fill_2
XTAP_TAPCELL_ROW_122_2003 VGND VPWR sky130_fd_sc_hd__tapvpwrvgnd_1
XFILLER_16_610 VGND VGND VPWR VPWR sky130_fd_sc_hd__decap_3
XFILLER_28_470 VGND VGND VPWR VPWR sky130_fd_sc_hd__decap_3
XFILLER_46_83 VGND VGND VPWR VPWR sky130_fd_sc_hd__fill_1
XFILLER_46_94 VGND VGND VPWR VPWR sky130_fd_sc_hd__decap_3
XTAP_TAPCELL_ROW_46_936 VGND VPWR sky130_fd_sc_hd__tapvpwrvgnd_1
XFILLER_16_654 VGND VGND VPWR VPWR sky130_fd_sc_hd__decap_3
XFILLER_71_771 VGND VGND VPWR VPWR sky130_fd_sc_hd__fill_2
XFILLER_90_568 VGND VGND VPWR VPWR sky130_fd_sc_hd__decap_3
XTAP_TAPCELL_ROW_26_660 VGND VPWR sky130_fd_sc_hd__tapvpwrvgnd_1
XFILLER_62_82 VGND VGND VPWR VPWR sky130_fd_sc_hd__fill_2
XFILLER_129_523 VGND VGND VPWR VPWR sky130_fd_sc_hd__decap_3
XFILLER_30_156 VGND VGND VPWR VPWR sky130_fd_sc_hd__decap_3
XFILLER_129_556 VGND VGND VPWR VPWR sky130_fd_sc_hd__decap_3
XFILLER_129_567 VGND VGND VPWR VPWR sky130_fd_sc_hd__decap_3
XFILLER_7_33 VGND VGND VPWR VPWR sky130_fd_sc_hd__decap_3
XTAP_TAPCELL_ROW_100_1688 VGND VPWR sky130_fd_sc_hd__tapvpwrvgnd_1
XTAP_TAPCELL_ROW_100_1699 VGND VPWR sky130_fd_sc_hd__tapvpwrvgnd_1
XFILLER_7_66 VGND VGND VPWR VPWR sky130_fd_sc_hd__decap_3
XFILLER_7_396 VGND VGND VPWR VPWR sky130_fd_sc_hd__fill_1
XTAP_TAPCELL_ROW_133_2154 VGND VPWR sky130_fd_sc_hd__tapvpwrvgnd_1
X_4390_ _7693_/Q _4634_/A2 _4389_/X _4442_/A _4682_/C1 VGND VGND VPWR VPWR _4390_/X
+ sky130_fd_sc_hd__o221a_2
XFILLER_112_401 VGND VGND VPWR VPWR sky130_fd_sc_hd__decap_3
XFILLER_98_635 VGND VGND VPWR VPWR sky130_fd_sc_hd__decap_3
XFILLER_98_657 VGND VGND VPWR VPWR sky130_fd_sc_hd__fill_2
XFILLER_112_456 VGND VGND VPWR VPWR sky130_fd_sc_hd__decap_3
XFILLER_30_3 VGND VGND VPWR VPWR sky130_fd_sc_hd__decap_3
XFILLER_97_145 VGND VGND VPWR VPWR sky130_fd_sc_hd__decap_3
XFILLER_98_679 VGND VGND VPWR VPWR sky130_fd_sc_hd__decap_3
XTAP_TAPCELL_ROW_51_1009 VGND VPWR sky130_fd_sc_hd__tapvpwrvgnd_1
X_6060_ _8096_/Q _4781_/A _6074_/S VGND VGND VPWR VPWR _6061_/A sky130_fd_sc_hd__mux2_2
XFILLER_66_510 VGND VGND VPWR VPWR sky130_fd_sc_hd__decap_3
Xhold1008 _7533_/Q VGND VGND VPWR VPWR _4842_/A1 sky130_fd_sc_hd__dlygate4sd3_1
Xhold1019 _7504_/Q VGND VGND VPWR VPWR _4720_/A1 sky130_fd_sc_hd__dlygate4sd3_1
X_5011_ _5011_/A VGND VGND VPWR VPWR _5011_/X sky130_fd_sc_hd__buf_1
XFILLER_39_757 VGND VGND VPWR VPWR sky130_fd_sc_hd__decap_3
XFILLER_93_340 VGND VGND VPWR VPWR sky130_fd_sc_hd__decap_3
XFILLER_54_738 VGND VGND VPWR VPWR sky130_fd_sc_hd__decap_3
XFILLER_66_576 VGND VGND VPWR VPWR sky130_fd_sc_hd__decap_3
XFILLER_19_470 VGND VGND VPWR VPWR sky130_fd_sc_hd__fill_2
XFILLER_53_215 VGND VGND VPWR VPWR sky130_fd_sc_hd__fill_1
X_6962_ _6962_/A VGND VGND VPWR VPWR _8519_/D sky130_fd_sc_hd__buf_6
XFILLER_81_579 VGND VGND VPWR VPWR sky130_fd_sc_hd__decap_3
X_8701_ _8701_/CLK _8701_/D fanout652/X VGND VGND VPWR VPWR _8701_/Q sky130_fd_sc_hd__dfrtp_2
X_6893_ _4723_/X _8487_/Q _6895_/S VGND VGND VPWR VPWR _6894_/A sky130_fd_sc_hd__mux2_4
X_5913_ _5919_/A1 _5919_/A2 _4787_/X _5919_/B1 hold769/X VGND VGND VPWR VPWR _8006_/D
+ sky130_fd_sc_hd__a32o_2
XFILLER_21_101 VGND VGND VPWR VPWR sky130_fd_sc_hd__decap_3
XFILLER_62_771 VGND VGND VPWR VPWR sky130_fd_sc_hd__decap_3
X_8632_ _8794_/CLK _8632_/D fanout580/X VGND VGND VPWR VPWR _8632_/Q sky130_fd_sc_hd__dfrtp_2
X_5844_ _5844_/A VGND VGND VPWR VPWR _7959_/D sky130_fd_sc_hd__buf_1
X_8563_ _8725_/CLK _8563_/D fanout493/X VGND VGND VPWR VPWR _8563_/Q sky130_fd_sc_hd__dfrtp_2
X_7514_ _8736_/CLK _7514_/D fanout481/X VGND VGND VPWR VPWR _7514_/Q sky130_fd_sc_hd__dfrtp_2
X_5775_ _5775_/A VGND VGND VPWR VPWR _7926_/D sky130_fd_sc_hd__buf_1
X_8494_ _8737_/CLK _8494_/D wire519/X VGND VGND VPWR VPWR _8494_/Q sky130_fd_sc_hd__dfrtp_2
X_4726_ _4726_/A _4726_/B VGND VGND VPWR VPWR _4727_/A sky130_fd_sc_hd__and2_2
XFILLER_135_526 VGND VGND VPWR VPWR sky130_fd_sc_hd__decap_3
XTAP_TAPCELL_ROW_118_1938 VGND VPWR sky130_fd_sc_hd__tapvpwrvgnd_1
XTAP_TAPCELL_ROW_118_1949 VGND VPWR sky130_fd_sc_hd__tapvpwrvgnd_1
X_7445_ _8779_/Q _4928_/A _7449_/S VGND VGND VPWR VPWR _7446_/A sky130_fd_sc_hd__mux2_2
X_4657_ _4569_/A _4655_/X _4656_/X VGND VGND VPWR VPWR _4657_/X sky130_fd_sc_hd__o21a_2
XFILLER_135_548 VGND VGND VPWR VPWR sky130_fd_sc_hd__fill_1
Xhold820 _7991_/Q VGND VGND VPWR VPWR hold820/X sky130_fd_sc_hd__dlygate4sd3_1
Xinput80 wdata[7] VGND VGND VPWR VPWR _4976_/A sky130_fd_sc_hd__clkdlybuf4s25_1
X_7376_ _8746_/Q _4790_/A _7386_/S VGND VGND VPWR VPWR _7377_/A sky130_fd_sc_hd__mux2_2
XFILLER_107_23 VGND VGND VPWR VPWR sky130_fd_sc_hd__decap_3
XTAP_TAPCELL_ROW_77_1370 VGND VPWR sky130_fd_sc_hd__tapvpwrvgnd_1
Xhold831 _8021_/Q VGND VGND VPWR VPWR hold831/X sky130_fd_sc_hd__dlygate4sd3_1
Xhold842 _8035_/Q VGND VGND VPWR VPWR hold842/X sky130_fd_sc_hd__dlygate4sd3_1
Xhold853 _8658_/Q VGND VGND VPWR VPWR hold853/X sky130_fd_sc_hd__dlygate4sd3_1
Xhold864 _8671_/Q VGND VGND VPWR VPWR hold864/X sky130_fd_sc_hd__dlygate4sd3_1
X_6327_ _4969_/X hold926/X _6335_/S VGND VGND VPWR VPWR _6328_/A sky130_fd_sc_hd__mux2_1
X_4588_ _8450_/Q _8531_/Q _8612_/Q _8693_/Q _4579_/S _4621_/A VGND VGND VPWR VPWR
+ _4588_/X sky130_fd_sc_hd__mux4_2
XFILLER_131_721 VGND VGND VPWR VPWR sky130_fd_sc_hd__decap_3
XFILLER_131_732 VGND VGND VPWR VPWR sky130_fd_sc_hd__decap_3
Xhold875 _8652_/Q VGND VGND VPWR VPWR hold875/X sky130_fd_sc_hd__dlygate4sd3_1
Xhold886 _8621_/Q VGND VGND VPWR VPWR hold886/X sky130_fd_sc_hd__dlygate4sd3_1
Xhold897 _8641_/Q VGND VGND VPWR VPWR hold897/X sky130_fd_sc_hd__dlygate4sd3_1
XFILLER_107_78 VGND VGND VPWR VPWR sky130_fd_sc_hd__decap_3
XFILLER_130_242 VGND VGND VPWR VPWR sky130_fd_sc_hd__decap_3
XFILLER_130_253 VGND VGND VPWR VPWR sky130_fd_sc_hd__decap_3
XFILLER_131_765 VGND VGND VPWR VPWR sky130_fd_sc_hd__decap_3
X_6258_ _4833_/X _8189_/Q _6268_/S VGND VGND VPWR VPWR _6259_/A sky130_fd_sc_hd__mux2_4
XFILLER_69_370 VGND VGND VPWR VPWR sky130_fd_sc_hd__fill_2
XFILLER_69_381 VGND VGND VPWR VPWR sky130_fd_sc_hd__decap_3
X_6189_ _5036_/X _8156_/Q _6205_/S VGND VGND VPWR VPWR _6190_/A sky130_fd_sc_hd__mux2_4
X_5209_ _5209_/A VGND VGND VPWR VPWR _7659_/D sky130_fd_sc_hd__buf_1
XFILLER_123_11 VGND VGND VPWR VPWR sky130_fd_sc_hd__decap_3
XTAP_TAPCELL_ROW_4_344 VGND VPWR sky130_fd_sc_hd__tapvpwrvgnd_1
XTAP_TAPCELL_ROW_4_355 VGND VPWR sky130_fd_sc_hd__tapvpwrvgnd_1
XFILLER_123_55 VGND VGND VPWR VPWR sky130_fd_sc_hd__fill_1
XFILLER_29_278 VGND VGND VPWR VPWR sky130_fd_sc_hd__fill_2
XFILLER_45_705 VGND VGND VPWR VPWR sky130_fd_sc_hd__decap_3
XFILLER_123_99 VGND VGND VPWR VPWR sky130_fd_sc_hd__fill_1
XFILLER_44_215 VGND VGND VPWR VPWR sky130_fd_sc_hd__fill_2
XFILLER_16_53 VGND VGND VPWR VPWR sky130_fd_sc_hd__decap_3
XFILLER_60_719 VGND VGND VPWR VPWR sky130_fd_sc_hd__decap_3
XFILLER_13_646 VGND VGND VPWR VPWR sky130_fd_sc_hd__fill_1
XFILLER_40_443 VGND VGND VPWR VPWR sky130_fd_sc_hd__decap_3
XFILLER_9_606 VGND VGND VPWR VPWR sky130_fd_sc_hd__decap_3
XFILLER_9_617 VGND VGND VPWR VPWR sky130_fd_sc_hd__decap_3
XFILLER_13_679 VGND VGND VPWR VPWR sky130_fd_sc_hd__decap_3
XFILLER_126_526 VGND VGND VPWR VPWR sky130_fd_sc_hd__decap_3
XFILLER_122_732 VGND VGND VPWR VPWR sky130_fd_sc_hd__decap_3
XFILLER_134_592 VGND VGND VPWR VPWR sky130_fd_sc_hd__decap_3
XFILLER_95_605 VGND VGND VPWR VPWR sky130_fd_sc_hd__decap_3
XFILLER_0_561 VGND VGND VPWR VPWR sky130_fd_sc_hd__decap_3
XFILLER_48_510 VGND VGND VPWR VPWR sky130_fd_sc_hd__fill_2
XFILLER_94_115 VGND VGND VPWR VPWR sky130_fd_sc_hd__decap_3
XFILLER_95_627 VGND VGND VPWR VPWR sky130_fd_sc_hd__decap_3
XFILLER_48_521 VGND VGND VPWR VPWR sky130_fd_sc_hd__fill_2
XFILLER_57_60 VGND VGND VPWR VPWR sky130_fd_sc_hd__fill_1
XFILLER_94_148 VGND VGND VPWR VPWR sky130_fd_sc_hd__fill_1
XFILLER_36_727 VGND VGND VPWR VPWR sky130_fd_sc_hd__decap_3
XFILLER_57_82 VGND VGND VPWR VPWR sky130_fd_sc_hd__decap_3
XFILLER_75_373 VGND VGND VPWR VPWR sky130_fd_sc_hd__decap_3
XFILLER_35_237 VGND VGND VPWR VPWR sky130_fd_sc_hd__fill_1
XFILLER_90_321 VGND VGND VPWR VPWR sky130_fd_sc_hd__fill_2
XFILLER_16_440 VGND VGND VPWR VPWR sky130_fd_sc_hd__fill_2
XFILLER_35_259 VGND VGND VPWR VPWR sky130_fd_sc_hd__decap_3
XFILLER_44_760 VGND VGND VPWR VPWR sky130_fd_sc_hd__decap_3
XFILLER_90_365 VGND VGND VPWR VPWR sky130_fd_sc_hd__decap_3
XFILLER_44_782 VGND VGND VPWR VPWR sky130_fd_sc_hd__fill_1
XFILLER_50_207 VGND VGND VPWR VPWR sky130_fd_sc_hd__decap_3
XTAP_TAPCELL_ROW_102_1717 VGND VPWR sky130_fd_sc_hd__tapvpwrvgnd_1
XFILLER_43_281 VGND VGND VPWR VPWR sky130_fd_sc_hd__fill_1
XFILLER_71_590 VGND VGND VPWR VPWR sky130_fd_sc_hd__decap_3
X_3890_ _3890_/A VGND VGND VPWR VPWR _3890_/X sky130_fd_sc_hd__clkbuf_2
XFILLER_129_320 VGND VGND VPWR VPWR sky130_fd_sc_hd__decap_3
XFILLER_31_498 VGND VGND VPWR VPWR sky130_fd_sc_hd__decap_3
XFILLER_78_3 VGND VGND VPWR VPWR sky130_fd_sc_hd__decap_3
X_5560_ _7825_/Q _4707_/A _5570_/S VGND VGND VPWR VPWR _5561_/A sky130_fd_sc_hd__mux2_2
XFILLER_117_526 VGND VGND VPWR VPWR sky130_fd_sc_hd__fill_1
XFILLER_8_672 VGND VGND VPWR VPWR sky130_fd_sc_hd__decap_3
X_5491_ _7793_/Q _4912_/A _5503_/S VGND VGND VPWR VPWR _5492_/A sky130_fd_sc_hd__mux2_2
X_4511_ _4522_/S _4506_/X _4508_/X _4510_/X VGND VGND VPWR VPWR _4511_/X sky130_fd_sc_hd__a22o_2
XFILLER_117_548 VGND VGND VPWR VPWR sky130_fd_sc_hd__fill_2
X_7230_ _7269_/A VGND VGND VPWR VPWR _7230_/X sky130_fd_sc_hd__clkbuf_1
X_4442_ _4442_/A _4442_/B VGND VGND VPWR VPWR _4442_/X sky130_fd_sc_hd__or2_2
XFILLER_104_209 VGND VGND VPWR VPWR sky130_fd_sc_hd__decap_3
XFILLER_132_507 VGND VGND VPWR VPWR sky130_fd_sc_hd__decap_3
X_7161_ _7161_/A VGND VGND VPWR VPWR _8613_/D sky130_fd_sc_hd__buf_2
X_4373_ _7773_/Q _7854_/Q _4402_/S VGND VGND VPWR VPWR _4373_/X sky130_fd_sc_hd__mux2_2
XFILLER_112_220 VGND VGND VPWR VPWR sky130_fd_sc_hd__decap_3
XFILLER_98_454 VGND VGND VPWR VPWR sky130_fd_sc_hd__fill_1
XTAP_TAPCELL_ROW_113_1868 VGND VPWR sky130_fd_sc_hd__tapvpwrvgnd_1
XTAP_TAPCELL_ROW_113_1879 VGND VPWR sky130_fd_sc_hd__tapvpwrvgnd_1
Xfanout607 fanout607/A VGND VGND VPWR VPWR fanout607/X sky130_fd_sc_hd__clkdlybuf4s25_1
Xfanout629 fanout634/X VGND VGND VPWR VPWR fanout629/X sky130_fd_sc_hd__clkdlybuf4s25_1
X_7092_ _7092_/A VGND VGND VPWR VPWR _8580_/D sky130_fd_sc_hd__buf_2
X_6112_ _8121_/Q _4886_/A _6116_/S VGND VGND VPWR VPWR _6113_/A sky130_fd_sc_hd__mux2_2
XFILLER_112_253 VGND VGND VPWR VPWR sky130_fd_sc_hd__decap_3
XFILLER_58_329 VGND VGND VPWR VPWR sky130_fd_sc_hd__fill_1
XFILLER_85_104 VGND VGND VPWR VPWR sky130_fd_sc_hd__decap_3
X_6043_ _8088_/Q _4748_/A _6053_/S VGND VGND VPWR VPWR _6044_/A sky130_fd_sc_hd__mux2_2
XFILLER_112_297 VGND VGND VPWR VPWR sky130_fd_sc_hd__decap_3
XFILLER_66_362 VGND VGND VPWR VPWR sky130_fd_sc_hd__fill_2
XTAP_TAPCELL_ROW_1_303 VGND VPWR sky130_fd_sc_hd__tapvpwrvgnd_1
XFILLER_26_215 VGND VGND VPWR VPWR sky130_fd_sc_hd__decap_3
XFILLER_81_332 VGND VGND VPWR VPWR sky130_fd_sc_hd__decap_3
X_7994_ _8657_/CLK _7994_/D load_slew513/X VGND VGND VPWR VPWR _7994_/Q sky130_fd_sc_hd__dfrtp_2
XFILLER_54_557 VGND VGND VPWR VPWR sky130_fd_sc_hd__fill_1
XFILLER_54_579 VGND VGND VPWR VPWR sky130_fd_sc_hd__decap_3
X_6945_ _6945_/A VGND VGND VPWR VPWR _8511_/D sky130_fd_sc_hd__buf_6
XFILLER_50_730 VGND VGND VPWR VPWR sky130_fd_sc_hd__decap_3
X_6876_ _7002_/S VGND VGND VPWR VPWR _6895_/S sky130_fd_sc_hd__buf_6
XFILLER_10_616 VGND VGND VPWR VPWR sky130_fd_sc_hd__decap_3
XFILLER_22_454 VGND VGND VPWR VPWR sky130_fd_sc_hd__decap_3
X_8615_ _8693_/CLK _8615_/D fanout744/X VGND VGND VPWR VPWR _8615_/Q sky130_fd_sc_hd__dfrtp_2
X_5827_ _5827_/A VGND VGND VPWR VPWR _7951_/D sky130_fd_sc_hd__buf_1
X_8546_ _8627_/CLK _8546_/D load_slew671/X VGND VGND VPWR VPWR _8546_/Q sky130_fd_sc_hd__dfrtp_2
X_5758_ _5758_/A VGND VGND VPWR VPWR _7918_/D sky130_fd_sc_hd__buf_1
XFILLER_108_526 VGND VGND VPWR VPWR sky130_fd_sc_hd__decap_3
XFILLER_135_312 VGND VGND VPWR VPWR sky130_fd_sc_hd__decap_3
X_8477_ _8477_/CLK _8477_/D fanout607/A VGND VGND VPWR VPWR _8477_/Q sky130_fd_sc_hd__dfrtp_2
X_4709_ _4709_/A VGND VGND VPWR VPWR _7501_/D sky130_fd_sc_hd__buf_1
XFILLER_135_345 VGND VGND VPWR VPWR sky130_fd_sc_hd__decap_3
X_7428_ _8771_/Q _4894_/A _7428_/S VGND VGND VPWR VPWR _7429_/A sky130_fd_sc_hd__mux2_2
X_5689_ _5689_/A VGND VGND VPWR VPWR _7885_/D sky130_fd_sc_hd__buf_1
XTAP_TAPCELL_ROW_9_414 VGND VPWR sky130_fd_sc_hd__tapvpwrvgnd_1
XTAP_TAPCELL_ROW_9_425 VGND VPWR sky130_fd_sc_hd__tapvpwrvgnd_1
XFILLER_116_592 VGND VGND VPWR VPWR sky130_fd_sc_hd__fill_2
XFILLER_123_529 VGND VGND VPWR VPWR sky130_fd_sc_hd__decap_3
X_7359_ _8738_/Q _4756_/A _7365_/S VGND VGND VPWR VPWR _7360_/A sky130_fd_sc_hd__mux2_2
XFILLER_103_220 VGND VGND VPWR VPWR sky130_fd_sc_hd__decap_3
XFILLER_103_231 VGND VGND VPWR VPWR sky130_fd_sc_hd__fill_2
XFILLER_131_573 VGND VGND VPWR VPWR sky130_fd_sc_hd__decap_3
XFILLER_134_21 VGND VGND VPWR VPWR sky130_fd_sc_hd__decap_3
XFILLER_134_32 VGND VGND VPWR VPWR sky130_fd_sc_hd__decap_3
XFILLER_49_307 VGND VGND VPWR VPWR sky130_fd_sc_hd__decap_3
XFILLER_49_329 VGND VGND VPWR VPWR sky130_fd_sc_hd__decap_3
XFILLER_89_476 VGND VGND VPWR VPWR sky130_fd_sc_hd__fill_1
XFILLER_103_297 VGND VGND VPWR VPWR sky130_fd_sc_hd__decap_3
XFILLER_134_65 VGND VGND VPWR VPWR sky130_fd_sc_hd__decap_3
XFILLER_92_608 VGND VGND VPWR VPWR sky130_fd_sc_hd__decap_3
XFILLER_18_727 VGND VGND VPWR VPWR sky130_fd_sc_hd__decap_3
XFILLER_94_58 VGND VGND VPWR VPWR sky130_fd_sc_hd__decap_3
XFILLER_18_738 VGND VGND VPWR VPWR sky130_fd_sc_hd__fill_1
XFILLER_27_30 VGND VGND VPWR VPWR sky130_fd_sc_hd__decap_3
XFILLER_27_63 VGND VGND VPWR VPWR sky130_fd_sc_hd__decap_3
XFILLER_84_170 VGND VGND VPWR VPWR sky130_fd_sc_hd__decap_3
XFILLER_72_354 VGND VGND VPWR VPWR sky130_fd_sc_hd__decap_3
XFILLER_72_365 VGND VGND VPWR VPWR sky130_fd_sc_hd__decap_3
XFILLER_26_760 VGND VGND VPWR VPWR sky130_fd_sc_hd__decap_3
XFILLER_13_432 VGND VGND VPWR VPWR sky130_fd_sc_hd__decap_3
XFILLER_25_281 VGND VGND VPWR VPWR sky130_fd_sc_hd__decap_3
XFILLER_41_741 VGND VGND VPWR VPWR sky130_fd_sc_hd__decap_3
XFILLER_43_40 VGND VGND VPWR VPWR sky130_fd_sc_hd__decap_3
XFILLER_41_785 VGND VGND VPWR VPWR sky130_fd_sc_hd__decap_3
XFILLER_9_447 VGND VGND VPWR VPWR sky130_fd_sc_hd__fill_1
XFILLER_126_301 VGND VGND VPWR VPWR sky130_fd_sc_hd__decap_3
XFILLER_5_620 VGND VGND VPWR VPWR sky130_fd_sc_hd__decap_3
XFILLER_5_653 VGND VGND VPWR VPWR sky130_fd_sc_hd__decap_3
XTAP_TAPCELL_ROW_130_2113 VGND VPWR sky130_fd_sc_hd__tapvpwrvgnd_1
XFILLER_107_570 VGND VGND VPWR VPWR sky130_fd_sc_hd__decap_3
XFILLER_4_12 VGND VGND VPWR VPWR sky130_fd_sc_hd__decap_3
XFILLER_5_697 VGND VGND VPWR VPWR sky130_fd_sc_hd__decap_3
XFILLER_122_551 VGND VGND VPWR VPWR sky130_fd_sc_hd__decap_3
XFILLER_4_56 VGND VGND VPWR VPWR sky130_fd_sc_hd__decap_3
XFILLER_122_584 VGND VGND VPWR VPWR sky130_fd_sc_hd__decap_3
XFILLER_68_81 VGND VGND VPWR VPWR sky130_fd_sc_hd__decap_3
XFILLER_110_735 VGND VGND VPWR VPWR sky130_fd_sc_hd__decap_3
XFILLER_110_757 VGND VGND VPWR VPWR sky130_fd_sc_hd__decap_3
XFILLER_67_137 VGND VGND VPWR VPWR sky130_fd_sc_hd__fill_1
XFILLER_95_446 VGND VGND VPWR VPWR sky130_fd_sc_hd__fill_2
XFILLER_82_107 VGND VGND VPWR VPWR sky130_fd_sc_hd__decap_3
XFILLER_95_479 VGND VGND VPWR VPWR sky130_fd_sc_hd__decap_3
XTAP_TAPCELL_ROW_128_2086 VGND VPWR sky130_fd_sc_hd__tapvpwrvgnd_1
XFILLER_36_557 VGND VGND VPWR VPWR sky130_fd_sc_hd__decap_3
XFILLER_63_354 VGND VGND VPWR VPWR sky130_fd_sc_hd__decap_3
XFILLER_91_641 VGND VGND VPWR VPWR sky130_fd_sc_hd__decap_3
XFILLER_91_663 VGND VGND VPWR VPWR sky130_fd_sc_hd__decap_3
XFILLER_90_173 VGND VGND VPWR VPWR sky130_fd_sc_hd__decap_3
XFILLER_91_685 VGND VGND VPWR VPWR sky130_fd_sc_hd__decap_3
X_6730_ _8410_/Q _4739_/A _6744_/S VGND VGND VPWR VPWR _6731_/A sky130_fd_sc_hd__mux2_2
X_4991_ _4989_/X _7568_/Q _5028_/S VGND VGND VPWR VPWR _4992_/A sky130_fd_sc_hd__mux2_2
XFILLER_51_549 VGND VGND VPWR VPWR sky130_fd_sc_hd__fill_2
XFILLER_90_195 VGND VGND VPWR VPWR sky130_fd_sc_hd__fill_1
X_3942_ _3931_/X _3935_/X _3941_/X _3925_/A VGND VGND VPWR VPWR _3942_/X sky130_fd_sc_hd__o22a_2
XFILLER_31_251 VGND VGND VPWR VPWR sky130_fd_sc_hd__decap_3
XTAP_TAPCELL_ROW_34_769 VGND VPWR sky130_fd_sc_hd__tapvpwrvgnd_1
X_3873_ _3875_/A _3867_/X _3869_/X _3872_/X VGND VGND VPWR VPWR _3873_/X sky130_fd_sc_hd__a22o_2
X_6661_ _6661_/A VGND VGND VPWR VPWR _6830_/S sky130_fd_sc_hd__clkbuf_2
XFILLER_31_284 VGND VGND VPWR VPWR sky130_fd_sc_hd__decap_3
XFILLER_31_295 VGND VGND VPWR VPWR sky130_fd_sc_hd__decap_3
XTAP_TAPCELL_ROW_14_482 VGND VPWR sky130_fd_sc_hd__tapvpwrvgnd_1
X_8400_ _8400_/CLK _8400_/D wire555/X VGND VGND VPWR VPWR _8400_/Q sky130_fd_sc_hd__dfrtp_2
X_6592_ _6592_/A VGND VGND VPWR VPWR _8346_/D sky130_fd_sc_hd__buf_2
X_5612_ _7850_/Q _4811_/A _5612_/S VGND VGND VPWR VPWR _5613_/A sky130_fd_sc_hd__mux2_2
XFILLER_129_161 VGND VGND VPWR VPWR sky130_fd_sc_hd__decap_3
XTAP_TAPCELL_ROW_14_493 VGND VPWR sky130_fd_sc_hd__tapvpwrvgnd_1
X_8331_ _8493_/CLK _8331_/D fanout475/A VGND VGND VPWR VPWR _8331_/Q sky130_fd_sc_hd__dfrtp_2
X_5543_ _7817_/Q _5015_/A _5549_/S VGND VGND VPWR VPWR _5544_/A sky130_fd_sc_hd__mux2_2
XFILLER_129_172 VGND VGND VPWR VPWR sky130_fd_sc_hd__decap_3
XTAP_TAPCELL_ROW_115_1908 VGND VPWR sky130_fd_sc_hd__tapvpwrvgnd_1
XFILLER_132_304 VGND VGND VPWR VPWR sky130_fd_sc_hd__decap_3
X_8262_ _8748_/CLK _8262_/D fanout542/X VGND VGND VPWR VPWR _8262_/Q sky130_fd_sc_hd__dfrtp_2
X_5474_ _7785_/Q _4878_/A _5482_/S VGND VGND VPWR VPWR _5475_/A sky130_fd_sc_hd__mux2_2
XFILLER_117_389 VGND VGND VPWR VPWR sky130_fd_sc_hd__decap_3
XFILLER_132_315 VGND VGND VPWR VPWR sky130_fd_sc_hd__decap_3
XFILLER_132_337 VGND VGND VPWR VPWR sky130_fd_sc_hd__decap_3
X_8193_ _8760_/CLK _8193_/D fanout717/X VGND VGND VPWR VPWR _8193_/Q sky130_fd_sc_hd__dfrtp_2
X_7213_ _7213_/A1 _4719_/X _7216_/A3 _7216_/B1 hold909/X VGND VGND VPWR VPWR _8648_/D
+ sky130_fd_sc_hd__a32o_2
X_4425_ _8678_/Q _3969_/X _4424_/X VGND VGND VPWR VPWR _4425_/X sky130_fd_sc_hd__o21a_2
X_7144_ _7144_/A VGND VGND VPWR VPWR _8605_/D sky130_fd_sc_hd__buf_2
X_4356_ _8105_/Q _8186_/Q _4441_/S VGND VGND VPWR VPWR _4356_/X sky130_fd_sc_hd__mux2_2
XFILLER_101_713 VGND VGND VPWR VPWR sky130_fd_sc_hd__decap_3
XFILLER_48_29 VGND VGND VPWR VPWR sky130_fd_sc_hd__decap_3
XFILLER_98_251 VGND VGND VPWR VPWR sky130_fd_sc_hd__fill_1
Xfanout415 _4471_/S VGND VGND VPWR VPWR _3716_/A sky130_fd_sc_hd__clkdlybuf4s25_1
XFILLER_101_735 VGND VGND VPWR VPWR sky130_fd_sc_hd__decap_3
Xfanout459 _4449_/S VGND VGND VPWR VPWR _4454_/S sky130_fd_sc_hd__clkdlybuf4s25_1
X_7075_ _7075_/A VGND VGND VPWR VPWR _8572_/D sky130_fd_sc_hd__buf_2
X_4287_ _8423_/Q _8504_/Q _8585_/Q _8666_/Q _4320_/S _4681_/A VGND VGND VPWR VPWR
+ _4287_/X sky130_fd_sc_hd__mux4_2
XFILLER_100_267 VGND VGND VPWR VPWR sky130_fd_sc_hd__decap_3
XFILLER_101_779 VGND VGND VPWR VPWR sky130_fd_sc_hd__decap_3
X_6026_ _8080_/Q _4714_/A _6032_/S VGND VGND VPWR VPWR _6027_/A sky130_fd_sc_hd__mux2_2
XFILLER_100_278 VGND VGND VPWR VPWR sky130_fd_sc_hd__decap_3
XFILLER_27_513 VGND VGND VPWR VPWR sky130_fd_sc_hd__decap_3
XFILLER_54_321 VGND VGND VPWR VPWR sky130_fd_sc_hd__decap_3
XFILLER_27_546 VGND VGND VPWR VPWR sky130_fd_sc_hd__fill_1
XFILLER_27_557 VGND VGND VPWR VPWR sky130_fd_sc_hd__decap_3
XFILLER_27_568 VGND VGND VPWR VPWR sky130_fd_sc_hd__decap_3
XFILLER_82_663 VGND VGND VPWR VPWR sky130_fd_sc_hd__fill_1
XPHY_EDGE_ROW_126_Right_126 VGND VGND VPWR VPWR sky130_fd_sc_hd__decap_3
X_7977_ _8800_/CLK _7977_/D load_slew593/X VGND VGND VPWR VPWR _7977_/Q sky130_fd_sc_hd__dfrtp_2
XTAP_TAPCELL_ROW_85_1480 VGND VPWR sky130_fd_sc_hd__tapvpwrvgnd_1
X_6928_ _6928_/A VGND VGND VPWR VPWR _8503_/D sky130_fd_sc_hd__buf_6
XFILLER_120_78 VGND VGND VPWR VPWR sky130_fd_sc_hd__decap_3
XFILLER_22_240 VGND VGND VPWR VPWR sky130_fd_sc_hd__decap_3
XFILLER_23_785 VGND VGND VPWR VPWR sky130_fd_sc_hd__decap_3
X_6859_ _6859_/A VGND VGND VPWR VPWR _8470_/D sky130_fd_sc_hd__buf_6
XFILLER_13_21 VGND VGND VPWR VPWR sky130_fd_sc_hd__decap_3
XFILLER_22_295 VGND VGND VPWR VPWR sky130_fd_sc_hd__decap_3
XFILLER_109_802 VGND VGND VPWR VPWR sky130_fd_sc_hd__fill_2
XFILLER_129_21 VGND VGND VPWR VPWR sky130_fd_sc_hd__decap_3
XFILLER_13_54 VGND VGND VPWR VPWR sky130_fd_sc_hd__fill_2
XFILLER_108_312 VGND VGND VPWR VPWR sky130_fd_sc_hd__fill_2
XFILLER_129_54 VGND VGND VPWR VPWR sky130_fd_sc_hd__fill_2
XFILLER_13_87 VGND VGND VPWR VPWR sky130_fd_sc_hd__decap_3
X_8529_ _8772_/CLK _8529_/D fanout719/X VGND VGND VPWR VPWR _8529_/Q sky130_fd_sc_hd__dfrtp_2
XFILLER_129_87 VGND VGND VPWR VPWR sky130_fd_sc_hd__decap_3
XFILLER_135_131 VGND VGND VPWR VPWR sky130_fd_sc_hd__decap_3
XFILLER_135_153 VGND VGND VPWR VPWR sky130_fd_sc_hd__decap_3
XFILLER_123_337 VGND VGND VPWR VPWR sky130_fd_sc_hd__decap_3
XFILLER_135_175 VGND VGND VPWR VPWR sky130_fd_sc_hd__decap_3
XFILLER_2_601 VGND VGND VPWR VPWR sky130_fd_sc_hd__decap_3
XFILLER_104_540 VGND VGND VPWR VPWR sky130_fd_sc_hd__fill_1
XFILLER_1_111 VGND VGND VPWR VPWR sky130_fd_sc_hd__fill_1
XFILLER_1_122 VGND VGND VPWR VPWR sky130_fd_sc_hd__decap_3
XFILLER_2_634 VGND VGND VPWR VPWR sky130_fd_sc_hd__decap_3
XFILLER_2_645 VGND VGND VPWR VPWR sky130_fd_sc_hd__decap_3
XFILLER_8_3 VGND VGND VPWR VPWR sky130_fd_sc_hd__decap_3
XFILLER_2_678 VGND VGND VPWR VPWR sky130_fd_sc_hd__decap_3
XFILLER_77_402 VGND VGND VPWR VPWR sky130_fd_sc_hd__decap_3
XFILLER_89_262 VGND VGND VPWR VPWR sky130_fd_sc_hd__decap_3
XPHY_EDGE_ROW_8_Left_144 VGND VGND VPWR VPWR sky130_fd_sc_hd__decap_3
XFILLER_104_595 VGND VGND VPWR VPWR sky130_fd_sc_hd__fill_1
XFILLER_49_137 VGND VGND VPWR VPWR sky130_fd_sc_hd__decap_3
XFILLER_77_446 VGND VGND VPWR VPWR sky130_fd_sc_hd__fill_2
XFILLER_89_284 VGND VGND VPWR VPWR sky130_fd_sc_hd__decap_3
XFILLER_92_405 VGND VGND VPWR VPWR sky130_fd_sc_hd__decap_3
XFILLER_18_513 VGND VGND VPWR VPWR sky130_fd_sc_hd__decap_3
XFILLER_38_73 VGND VGND VPWR VPWR sky130_fd_sc_hd__decap_3
XFILLER_64_118 VGND VGND VPWR VPWR sky130_fd_sc_hd__decap_3
XFILLER_92_427 VGND VGND VPWR VPWR sky130_fd_sc_hd__decap_3
XFILLER_72_162 VGND VGND VPWR VPWR sky130_fd_sc_hd__decap_3
XFILLER_54_72 VGND VGND VPWR VPWR sky130_fd_sc_hd__decap_3
XFILLER_72_184 VGND VGND VPWR VPWR sky130_fd_sc_hd__fill_1
XFILLER_9_211 VGND VGND VPWR VPWR sky130_fd_sc_hd__decap_3
XFILLER_9_222 VGND VGND VPWR VPWR sky130_fd_sc_hd__fill_2
XTAP_TAPCELL_ROW_31_728 VGND VPWR sky130_fd_sc_hd__tapvpwrvgnd_1
XFILLER_9_277 VGND VGND VPWR VPWR sky130_fd_sc_hd__decap_3
XTAP_TAPCELL_ROW_11_441 VGND VPWR sky130_fd_sc_hd__tapvpwrvgnd_1
XFILLER_9_288 VGND VGND VPWR VPWR sky130_fd_sc_hd__decap_3
XTAP_TAPCELL_ROW_11_452 VGND VPWR sky130_fd_sc_hd__tapvpwrvgnd_1
Xclkload14 _8328_/CLK VGND VGND VPWR VPWR clkload14/Y sky130_fd_sc_hd__clkinv_2
Xclkload25 _8335_/CLK VGND VGND VPWR VPWR clkload25/X sky130_fd_sc_hd__clkbuf_4
XFILLER_127_654 VGND VGND VPWR VPWR sky130_fd_sc_hd__decap_3
XFILLER_127_676 VGND VGND VPWR VPWR sky130_fd_sc_hd__decap_3
Xclkload36 _8721_/CLK VGND VGND VPWR VPWR clkload36/X sky130_fd_sc_hd__clkbuf_8
Xclkload47 _8668_/CLK VGND VGND VPWR VPWR clkload47/X sky130_fd_sc_hd__clkbuf_8
Xclkload58 _8709_/CLK VGND VGND VPWR VPWR clkload58/X sky130_fd_sc_hd__clkbuf_4
Xclkload69 _8597_/CLK VGND VGND VPWR VPWR clkload69/Y sky130_fd_sc_hd__bufinv_16
XFILLER_126_197 VGND VGND VPWR VPWR sky130_fd_sc_hd__fill_2
X_4210_ _8001_/Q _3811_/X _3817_/X _7920_/Q _4300_/A1 VGND VGND VPWR VPWR _4210_/X
+ sky130_fd_sc_hd__o221a_2
XFILLER_96_722 VGND VGND VPWR VPWR sky130_fd_sc_hd__decap_3
XTAP_TAPCELL_ROW_110_1827 VGND VPWR sky130_fd_sc_hd__tapvpwrvgnd_1
XTAP_TAPCELL_ROW_110_1838 VGND VPWR sky130_fd_sc_hd__tapvpwrvgnd_1
XTAP_TAPCELL_ROW_56_1070 VGND VPWR sky130_fd_sc_hd__tapvpwrvgnd_1
XTAP_TAPCELL_ROW_56_1081 VGND VPWR sky130_fd_sc_hd__tapvpwrvgnd_1
X_5190_ _5190_/A VGND VGND VPWR VPWR _7650_/D sky130_fd_sc_hd__buf_1
XFILLER_122_392 VGND VGND VPWR VPWR sky130_fd_sc_hd__decap_3
X_4141_ _4141_/A _4141_/B VGND VGND VPWR VPWR _4141_/X sky130_fd_sc_hd__or2_2
X_4072_ _4104_/B2 _4069_/X _4071_/X wire280/A VGND VGND VPWR VPWR _4072_/X sky130_fd_sc_hd__o211a_2
XFILLER_48_170 VGND VGND VPWR VPWR sky130_fd_sc_hd__decap_3
XFILLER_49_682 VGND VGND VPWR VPWR sky130_fd_sc_hd__decap_3
XFILLER_83_438 VGND VGND VPWR VPWR sky130_fd_sc_hd__decap_3
XTAP_TAPCELL_ROW_39_839 VGND VPWR sky130_fd_sc_hd__tapvpwrvgnd_1
X_7900_ _8477_/CLK _7900_/D fanout606/X VGND VGND VPWR VPWR _7900_/Q sky130_fd_sc_hd__dfrtp_2
XFILLER_36_343 VGND VGND VPWR VPWR sky130_fd_sc_hd__fill_2
XFILLER_36_365 VGND VGND VPWR VPWR sky130_fd_sc_hd__decap_3
XFILLER_64_696 VGND VGND VPWR VPWR sky130_fd_sc_hd__decap_3
XTAP_TAPCELL_ROW_19_552 VGND VPWR sky130_fd_sc_hd__tapvpwrvgnd_1
XTAP_TAPCELL_ROW_19_563 VGND VPWR sky130_fd_sc_hd__tapvpwrvgnd_1
X_7831_ _8657_/CLK _7831_/D load_slew513/X VGND VGND VPWR VPWR _7831_/Q sky130_fd_sc_hd__dfrtp_2
XFILLER_51_346 VGND VGND VPWR VPWR sky130_fd_sc_hd__decap_3
XFILLER_91_493 VGND VGND VPWR VPWR sky130_fd_sc_hd__decap_3
X_7762_ _8744_/CLK _7762_/D fanout625/X VGND VGND VPWR VPWR _7762_/Q sky130_fd_sc_hd__dfrtp_2
X_4974_ _4973_/X _7564_/Q _4986_/S VGND VGND VPWR VPWR _4975_/A sky130_fd_sc_hd__mux2_2
X_3925_ _3925_/A _3925_/B VGND VGND VPWR VPWR _3925_/X sky130_fd_sc_hd__or2_2
X_7693_ _8679_/CLK _7693_/D wire701/A VGND VGND VPWR VPWR _7693_/Q sky130_fd_sc_hd__dfrtp_2
X_6713_ _8402_/Q _4706_/A _6723_/S VGND VGND VPWR VPWR _6714_/A sky130_fd_sc_hd__mux2_2
XFILLER_32_582 VGND VGND VPWR VPWR sky130_fd_sc_hd__decap_3
XTAP_TAPCELL_ROW_121_1989 VGND VPWR sky130_fd_sc_hd__tapvpwrvgnd_1
X_6644_ _4917_/X _8371_/Q _6654_/S VGND VGND VPWR VPWR _6645_/A sky130_fd_sc_hd__mux2_2
XFILLER_109_109 VGND VGND VPWR VPWR sky130_fd_sc_hd__decap_3
XFILLER_20_755 VGND VGND VPWR VPWR sky130_fd_sc_hd__fill_1
X_3856_ _8709_/Q _8790_/Q _3861_/S VGND VGND VPWR VPWR _3857_/B sky130_fd_sc_hd__mux2_2
Xclkload8 clkload8/A VGND VGND VPWR VPWR clkload8/X sky130_fd_sc_hd__clkbuf_8
X_3787_ _7641_/Q _4286_/A2 _3785_/X _7560_/Q _3839_/S VGND VGND VPWR VPWR _3787_/X
+ sky130_fd_sc_hd__o221a_2
X_6575_ _4777_/X _8338_/Q _6591_/S VGND VGND VPWR VPWR _6576_/A sky130_fd_sc_hd__mux2_2
XFILLER_118_676 VGND VGND VPWR VPWR sky130_fd_sc_hd__decap_3
X_8314_ _8719_/CLK _8314_/D load_slew584/X VGND VGND VPWR VPWR _8314_/Q sky130_fd_sc_hd__dfrtp_2
X_5526_ _7809_/Q _4981_/A _5528_/S VGND VGND VPWR VPWR _5527_/A sky130_fd_sc_hd__mux2_2
XFILLER_132_112 VGND VGND VPWR VPWR sky130_fd_sc_hd__decap_3
XFILLER_133_635 VGND VGND VPWR VPWR sky130_fd_sc_hd__decap_3
X_8245_ _8569_/CLK _8245_/D load_slew494/X VGND VGND VPWR VPWR _8245_/Q sky130_fd_sc_hd__dfrtp_2
X_5457_ _7777_/Q _4844_/A _5461_/S VGND VGND VPWR VPWR _5458_/A sky130_fd_sc_hd__mux2_2
XFILLER_105_348 VGND VGND VPWR VPWR sky130_fd_sc_hd__decap_3
XFILLER_133_668 VGND VGND VPWR VPWR sky130_fd_sc_hd__decap_3
X_4408_ _8110_/Q _8191_/Q _4414_/S VGND VGND VPWR VPWR _4408_/X sky130_fd_sc_hd__mux2_2
XFILLER_115_12 VGND VGND VPWR VPWR sky130_fd_sc_hd__decap_3
XFILLER_120_318 VGND VGND VPWR VPWR sky130_fd_sc_hd__decap_3
XFILLER_132_156 VGND VGND VPWR VPWR sky130_fd_sc_hd__decap_3
XFILLER_133_679 VGND VGND VPWR VPWR sky130_fd_sc_hd__decap_3
XFILLER_59_402 VGND VGND VPWR VPWR sky130_fd_sc_hd__fill_1
XFILLER_99_582 VGND VGND VPWR VPWR sky130_fd_sc_hd__decap_3
X_8176_ _8742_/CLK _8176_/D load_slew616/X VGND VGND VPWR VPWR _8176_/Q sky130_fd_sc_hd__dfrtp_2
X_5388_ _7744_/Q _4706_/A _5398_/S VGND VGND VPWR VPWR _5389_/A sky130_fd_sc_hd__mux2_2
XFILLER_132_189 VGND VGND VPWR VPWR sky130_fd_sc_hd__decap_3
XFILLER_86_232 VGND VGND VPWR VPWR sky130_fd_sc_hd__decap_3
X_7127_ _7127_/A VGND VGND VPWR VPWR _8597_/D sky130_fd_sc_hd__buf_2
X_4339_ _4368_/A _4339_/B VGND VGND VPWR VPWR _4339_/X sky130_fd_sc_hd__or2_2
XFILLER_101_576 VGND VGND VPWR VPWR sky130_fd_sc_hd__decap_3
Xfanout278 _8048_/Q VGND VGND VPWR VPWR _7004_/A sky130_fd_sc_hd__clkdlybuf4s25_1
Xfanout289 _8047_/Q VGND VGND VPWR VPWR fanout289/X sky130_fd_sc_hd__clkdlybuf4s25_1
X_7058_ _7058_/A VGND VGND VPWR VPWR _8564_/D sky130_fd_sc_hd__buf_2
XFILLER_74_427 VGND VGND VPWR VPWR sky130_fd_sc_hd__fill_1
X_6009_ _8072_/Q _5022_/A _6011_/S VGND VGND VPWR VPWR _6010_/A sky130_fd_sc_hd__mux2_2
XFILLER_131_33 VGND VGND VPWR VPWR sky130_fd_sc_hd__decap_3
XFILLER_131_66 VGND VGND VPWR VPWR sky130_fd_sc_hd__decap_3
XFILLER_15_505 VGND VGND VPWR VPWR sky130_fd_sc_hd__decap_3
XFILLER_82_460 VGND VGND VPWR VPWR sky130_fd_sc_hd__decap_3
XFILLER_131_99 VGND VGND VPWR VPWR sky130_fd_sc_hd__decap_3
XFILLER_91_26 VGND VGND VPWR VPWR sky130_fd_sc_hd__decap_3
XFILLER_70_677 VGND VGND VPWR VPWR sky130_fd_sc_hd__fill_1
XFILLER_23_582 VGND VGND VPWR VPWR sky130_fd_sc_hd__decap_3
XFILLER_24_53 VGND VGND VPWR VPWR sky130_fd_sc_hd__decap_3
XFILLER_11_744 VGND VGND VPWR VPWR sky130_fd_sc_hd__decap_3
XFILLER_7_715 VGND VGND VPWR VPWR sky130_fd_sc_hd__decap_3
XFILLER_109_610 VGND VGND VPWR VPWR sky130_fd_sc_hd__decap_3
XFILLER_10_265 VGND VGND VPWR VPWR sky130_fd_sc_hd__fill_1
XFILLER_11_777 VGND VGND VPWR VPWR sky130_fd_sc_hd__decap_3
XFILLER_11_788 VGND VGND VPWR VPWR sky130_fd_sc_hd__decap_3
XFILLER_7_759 VGND VGND VPWR VPWR sky130_fd_sc_hd__decap_3
Xwire657 wire657/A VGND VGND VPWR VPWR wire657/X sky130_fd_sc_hd__clkbuf_4
XFILLER_109_654 VGND VGND VPWR VPWR sky130_fd_sc_hd__decap_3
XFILLER_109_676 VGND VGND VPWR VPWR sky130_fd_sc_hd__decap_3
XFILLER_6_236 VGND VGND VPWR VPWR sky130_fd_sc_hd__decap_3
XTAP_TAPCELL_ROW_98_1660 VGND VPWR sky130_fd_sc_hd__tapvpwrvgnd_1
XTAP_TAPCELL_ROW_98_1671 VGND VPWR sky130_fd_sc_hd__tapvpwrvgnd_1
XFILLER_108_153 VGND VGND VPWR VPWR sky130_fd_sc_hd__decap_3
XFILLER_97_508 VGND VGND VPWR VPWR sky130_fd_sc_hd__decap_3
XFILLER_111_307 VGND VGND VPWR VPWR sky130_fd_sc_hd__fill_1
XFILLER_123_167 VGND VGND VPWR VPWR sky130_fd_sc_hd__fill_1
XFILLER_123_178 VGND VGND VPWR VPWR sky130_fd_sc_hd__decap_3
Xclkbuf_4_14_0_CLK clkbuf_0_CLK/X VGND VGND VPWR VPWR clkbuf_4_14_0_CLK/X sky130_fd_sc_hd__clkbuf_8
XFILLER_132_690 VGND VGND VPWR VPWR sky130_fd_sc_hd__decap_3
XFILLER_78_755 VGND VGND VPWR VPWR sky130_fd_sc_hd__fill_1
XFILLER_27_9 VGND VGND VPWR VPWR sky130_fd_sc_hd__decap_3
XFILLER_78_766 VGND VGND VPWR VPWR sky130_fd_sc_hd__decap_3
XFILLER_1_24 VGND VGND VPWR VPWR sky130_fd_sc_hd__decap_3
XFILLER_1_57 VGND VGND VPWR VPWR sky130_fd_sc_hd__decap_3
XTAP_TAPCELL_ROW_125_2045 VGND VPWR sky130_fd_sc_hd__tapvpwrvgnd_1
XFILLER_18_365 VGND VGND VPWR VPWR sky130_fd_sc_hd__decap_3
XFILLER_45_140 VGND VGND VPWR VPWR sky130_fd_sc_hd__decap_3
XFILLER_92_268 VGND VGND VPWR VPWR sky130_fd_sc_hd__decap_3
XFILLER_45_184 VGND VGND VPWR VPWR sky130_fd_sc_hd__decap_3
XFILLER_46_696 VGND VGND VPWR VPWR sky130_fd_sc_hd__decap_3
XFILLER_61_655 VGND VGND VPWR VPWR sky130_fd_sc_hd__decap_3
XTAP_TAPCELL_ROW_16_511 VGND VPWR sky130_fd_sc_hd__tapvpwrvgnd_1
XTAP_TAPCELL_ROW_16_522 VGND VPWR sky130_fd_sc_hd__tapvpwrvgnd_1
XFILLER_61_666 VGND VGND VPWR VPWR sky130_fd_sc_hd__fill_2
X_3710_ _8052_/Q _3723_/B VGND VGND VPWR VPWR _6658_/B sky130_fd_sc_hd__nor2b_2
X_4690_ _4690_/A _4726_/B VGND VGND VPWR VPWR _4691_/A sky130_fd_sc_hd__and2_2
XFILLER_119_429 VGND VGND VPWR VPWR sky130_fd_sc_hd__fill_2
XFILLER_60_3 VGND VGND VPWR VPWR sky130_fd_sc_hd__fill_1
XTAP_TAPCELL_ROW_58_1110 VGND VPWR sky130_fd_sc_hd__tapvpwrvgnd_1
X_6360_ _6360_/A VGND VGND VPWR VPWR _8236_/D sky130_fd_sc_hd__buf_2
XFILLER_115_635 VGND VGND VPWR VPWR sky130_fd_sc_hd__decap_3
XFILLER_127_473 VGND VGND VPWR VPWR sky130_fd_sc_hd__decap_3
XFILLER_6_781 VGND VGND VPWR VPWR sky130_fd_sc_hd__decap_3
X_5311_ _5311_/A VGND VGND VPWR VPWR _7708_/D sky130_fd_sc_hd__buf_1
X_8030_ _8769_/CLK _8030_/D wire552/X VGND VGND VPWR VPWR _8030_/Q sky130_fd_sc_hd__dfrtp_2
X_6291_ _6312_/S VGND VGND VPWR VPWR _6310_/S sky130_fd_sc_hd__buf_6
XFILLER_102_318 VGND VGND VPWR VPWR sky130_fd_sc_hd__decap_3
XFILLER_130_616 VGND VGND VPWR VPWR sky130_fd_sc_hd__decap_3
X_5242_ _5242_/A VGND VGND VPWR VPWR _7675_/D sky130_fd_sc_hd__buf_1
XFILLER_69_722 VGND VGND VPWR VPWR sky130_fd_sc_hd__fill_2
X_5173_ _5173_/A VGND VGND VPWR VPWR _7642_/D sky130_fd_sc_hd__buf_1
XFILLER_110_351 VGND VGND VPWR VPWR sky130_fd_sc_hd__decap_3
XFILLER_29_608 VGND VGND VPWR VPWR sky130_fd_sc_hd__decap_3
X_4124_ _8733_/Q _7508_/Q _4124_/S VGND VGND VPWR VPWR _4125_/B sky130_fd_sc_hd__mux2_2
XFILLER_110_362 VGND VGND VPWR VPWR sky130_fd_sc_hd__fill_2
XFILLER_83_213 VGND VGND VPWR VPWR sky130_fd_sc_hd__decap_3
Xinput1 nRST VGND VGND VPWR VPWR input1/X sky130_fd_sc_hd__buf_1
XFILLER_49_490 VGND VGND VPWR VPWR sky130_fd_sc_hd__fill_2
XFILLER_84_769 VGND VGND VPWR VPWR sky130_fd_sc_hd__decap_3
X_4055_ _4117_/A _4055_/B VGND VGND VPWR VPWR _4055_/X sky130_fd_sc_hd__or2_2
XFILLER_37_685 VGND VGND VPWR VPWR sky130_fd_sc_hd__decap_3
XFILLER_52_611 VGND VGND VPWR VPWR sky130_fd_sc_hd__decap_3
XFILLER_71_408 VGND VGND VPWR VPWR sky130_fd_sc_hd__fill_1
XFILLER_83_279 VGND VGND VPWR VPWR sky130_fd_sc_hd__fill_1
XTAP_TAPCELL_ROW_69_1261 VGND VPWR sky130_fd_sc_hd__tapvpwrvgnd_1
XFILLER_101_25 VGND VGND VPWR VPWR sky130_fd_sc_hd__decap_3
XFILLER_64_482 VGND VGND VPWR VPWR sky130_fd_sc_hd__decap_3
XFILLER_91_290 VGND VGND VPWR VPWR sky130_fd_sc_hd__decap_3
X_7814_ _8477_/CLK _7814_/D load_slew605/X VGND VGND VPWR VPWR _7814_/Q sky130_fd_sc_hd__dfrtp_2
XFILLER_12_508 VGND VGND VPWR VPWR sky130_fd_sc_hd__decap_3
XFILLER_24_368 VGND VGND VPWR VPWR sky130_fd_sc_hd__decap_3
X_8794_ _8794_/CLK _8794_/D load_slew584/X VGND VGND VPWR VPWR _8794_/Q sky130_fd_sc_hd__dfrtp_2
X_7745_ _8727_/CLK _7745_/D load_slew533/X VGND VGND VPWR VPWR _7745_/Q sky130_fd_sc_hd__dfrtp_2
X_4957_ _4957_/A VGND VGND VPWR VPWR _4957_/X sky130_fd_sc_hd__buf_1
XFILLER_131_9 VGND VGND VPWR VPWR sky130_fd_sc_hd__decap_3
X_3908_ _8632_/Q _3768_/X _3907_/X VGND VGND VPWR VPWR _3908_/X sky130_fd_sc_hd__o21a_2
X_7676_ _8736_/CLK _7676_/D fanout479/A VGND VGND VPWR VPWR _7676_/Q sky130_fd_sc_hd__dfrtp_2
X_4888_ _4887_/X _4888_/A1 _4896_/S VGND VGND VPWR VPWR _4889_/A sky130_fd_sc_hd__mux2_2
XFILLER_20_563 VGND VGND VPWR VPWR sky130_fd_sc_hd__fill_2
X_3839_ _3837_/X _3838_/X _3839_/S VGND VGND VPWR VPWR _3839_/X sky130_fd_sc_hd__mux2_2
X_6627_ _4883_/X _8363_/Q _6633_/S VGND VGND VPWR VPWR _6628_/A sky130_fd_sc_hd__mux2_2
XFILLER_4_707 VGND VGND VPWR VPWR sky130_fd_sc_hd__decap_3
XPHY_EDGE_ROW_89_Left_225 VGND VGND VPWR VPWR sky130_fd_sc_hd__decap_3
X_6558_ _4745_/X _8330_/Q _6570_/S VGND VGND VPWR VPWR _6559_/A sky130_fd_sc_hd__mux2_2
XFILLER_106_657 VGND VGND VPWR VPWR sky130_fd_sc_hd__decap_3
XFILLER_10_44 VGND VGND VPWR VPWR sky130_fd_sc_hd__decap_3
XFILLER_133_432 VGND VGND VPWR VPWR sky130_fd_sc_hd__decap_3
XFILLER_3_228 VGND VGND VPWR VPWR sky130_fd_sc_hd__decap_3
X_6489_ _4945_/X _8297_/Q _6507_/S VGND VGND VPWR VPWR _6490_/A sky130_fd_sc_hd__mux2_2
X_5509_ _5677_/S VGND VGND VPWR VPWR _5528_/S sky130_fd_sc_hd__buf_2
XFILLER_10_77 VGND VGND VPWR VPWR sky130_fd_sc_hd__decap_3
XFILLER_10_88 VGND VGND VPWR VPWR sky130_fd_sc_hd__decap_3
XFILLER_126_44 VGND VGND VPWR VPWR sky130_fd_sc_hd__decap_3
XFILLER_133_476 VGND VGND VPWR VPWR sky130_fd_sc_hd__decap_3
X_8228_ _8795_/CLK _8228_/D load_slew608/X VGND VGND VPWR VPWR _8228_/Q sky130_fd_sc_hd__dfrtp_2
XFILLER_126_77 VGND VGND VPWR VPWR sky130_fd_sc_hd__decap_3
XFILLER_126_88 VGND VGND VPWR VPWR sky130_fd_sc_hd__decap_3
XTAP_TAPCELL_ROW_93_1590 VGND VPWR sky130_fd_sc_hd__tapvpwrvgnd_1
X_8159_ _8649_/CLK _8159_/D fanout506/X VGND VGND VPWR VPWR _8159_/Q sky130_fd_sc_hd__dfrtp_2
XFILLER_59_254 VGND VGND VPWR VPWR sky130_fd_sc_hd__decap_3
XFILLER_75_703 VGND VGND VPWR VPWR sky130_fd_sc_hd__decap_3
XFILLER_19_42 VGND VGND VPWR VPWR sky130_fd_sc_hd__decap_3
XFILLER_59_287 VGND VGND VPWR VPWR sky130_fd_sc_hd__fill_1
XFILLER_19_75 VGND VGND VPWR VPWR sky130_fd_sc_hd__decap_3
XFILLER_47_449 VGND VGND VPWR VPWR sky130_fd_sc_hd__fill_2
XFILLER_74_246 VGND VGND VPWR VPWR sky130_fd_sc_hd__decap_3
XPHY_EDGE_ROW_98_Left_234 VGND VGND VPWR VPWR sky130_fd_sc_hd__decap_3
XFILLER_27_151 VGND VGND VPWR VPWR sky130_fd_sc_hd__decap_3
XFILLER_42_110 VGND VGND VPWR VPWR sky130_fd_sc_hd__decap_3
XFILLER_55_493 VGND VGND VPWR VPWR sky130_fd_sc_hd__decap_3
XFILLER_30_305 VGND VGND VPWR VPWR sky130_fd_sc_hd__decap_3
XFILLER_30_327 VGND VGND VPWR VPWR sky130_fd_sc_hd__decap_3
XFILLER_42_187 VGND VGND VPWR VPWR sky130_fd_sc_hd__decap_3
XFILLER_129_727 VGND VGND VPWR VPWR sky130_fd_sc_hd__fill_1
XTAP_TAPCELL_ROW_41_867 VGND VPWR sky130_fd_sc_hd__tapvpwrvgnd_1
XFILLER_128_215 VGND VGND VPWR VPWR sky130_fd_sc_hd__decap_3
XFILLER_129_738 VGND VGND VPWR VPWR sky130_fd_sc_hd__decap_3
XFILLER_51_40 VGND VGND VPWR VPWR sky130_fd_sc_hd__decap_3
XFILLER_7_523 VGND VGND VPWR VPWR sky130_fd_sc_hd__decap_3
XFILLER_128_248 VGND VGND VPWR VPWR sky130_fd_sc_hd__decap_3
XFILLER_128_259 VGND VGND VPWR VPWR sky130_fd_sc_hd__fill_1
XFILLER_7_567 VGND VGND VPWR VPWR sky130_fd_sc_hd__fill_2
XTAP_TAPCELL_ROW_21_580 VGND VPWR sky130_fd_sc_hd__tapvpwrvgnd_1
XTAP_TAPCELL_ROW_21_591 VGND VPWR sky130_fd_sc_hd__tapvpwrvgnd_1
Xwire454 wire454/A VGND VGND VPWR VPWR _3845_/S sky130_fd_sc_hd__clkbuf_4
Xwire476 wire476/A VGND VGND VPWR VPWR wire476/X sky130_fd_sc_hd__clkbuf_4
XFILLER_124_410 VGND VGND VPWR VPWR sky130_fd_sc_hd__fill_1
XFILLER_7_578 VGND VGND VPWR VPWR sky130_fd_sc_hd__decap_3
XFILLER_124_421 VGND VGND VPWR VPWR sky130_fd_sc_hd__decap_3
XFILLER_112_605 VGND VGND VPWR VPWR sky130_fd_sc_hd__fill_1
XFILLER_3_762 VGND VGND VPWR VPWR sky130_fd_sc_hd__decap_3
Xload_slew404 _4074_/S VGND VGND VPWR VPWR _4110_/S0 sky130_fd_sc_hd__buf_4
XFILLER_2_261 VGND VGND VPWR VPWR sky130_fd_sc_hd__fill_2
XFILLER_97_349 VGND VGND VPWR VPWR sky130_fd_sc_hd__decap_3
XTAP_TAPCELL_ROW_53_1040 VGND VPWR sky130_fd_sc_hd__tapvpwrvgnd_1
Xload_slew437 _4266_/S VGND VGND VPWR VPWR _4260_/S sky130_fd_sc_hd__clkbuf_2
Xload_slew426 _4494_/S VGND VGND VPWR VPWR _3906_/S sky130_fd_sc_hd__clkbuf_4
XFILLER_111_137 VGND VGND VPWR VPWR sky130_fd_sc_hd__fill_1
XFILLER_111_159 VGND VGND VPWR VPWR sky130_fd_sc_hd__decap_3
XFILLER_25_6 VGND VGND VPWR VPWR sky130_fd_sc_hd__decap_3
Xclkbuf_leaf_120_CLK clkbuf_5_16__f_CLK/X VGND VGND VPWR VPWR _8749_/CLK sky130_fd_sc_hd__clkbuf_8
Xload_slew448 _3838_/S0 VGND VGND VPWR VPWR _3868_/S sky130_fd_sc_hd__buf_2
XFILLER_38_427 VGND VGND VPWR VPWR sky130_fd_sc_hd__fill_2
XFILLER_66_725 VGND VGND VPWR VPWR sky130_fd_sc_hd__decap_3
XFILLER_93_533 VGND VGND VPWR VPWR sky130_fd_sc_hd__decap_3
XTAP_TAPCELL_ROW_49_978 VGND VPWR sky130_fd_sc_hd__tapvpwrvgnd_1
X_5860_ _5867_/A1 _5853_/X _4957_/X _5865_/B1 hold766/X VGND VGND VPWR VPWR _7965_/D
+ sky130_fd_sc_hd__a32o_2
XFILLER_73_290 VGND VGND VPWR VPWR sky130_fd_sc_hd__decap_3
XTAP_TAPCELL_ROW_105_1759 VGND VPWR sky130_fd_sc_hd__tapvpwrvgnd_1
X_4811_ _4811_/A VGND VGND VPWR VPWR _4811_/X sky130_fd_sc_hd__buf_1
XFILLER_33_165 VGND VGND VPWR VPWR sky130_fd_sc_hd__decap_3
XFILLER_34_688 VGND VGND VPWR VPWR sky130_fd_sc_hd__decap_3
XFILLER_61_474 VGND VGND VPWR VPWR sky130_fd_sc_hd__decap_3
X_5791_ _7934_/Q _4824_/A _5805_/S VGND VGND VPWR VPWR _5792_/A sky130_fd_sc_hd__mux2_2
XFILLER_21_349 VGND VGND VPWR VPWR sky130_fd_sc_hd__decap_3
XTAP_TAPCELL_ROW_64_1191 VGND VPWR sky130_fd_sc_hd__tapvpwrvgnd_1
X_7530_ _8757_/CLK _7530_/D fanout715/X VGND VGND VPWR VPWR _7530_/Q sky130_fd_sc_hd__dfrtp_2
X_4742_ _4740_/X _7509_/Q _4778_/S VGND VGND VPWR VPWR _4743_/A sky130_fd_sc_hd__mux2_2
XFILLER_119_204 VGND VGND VPWR VPWR sky130_fd_sc_hd__decap_3
X_7461_ _7461_/A VGND VGND VPWR VPWR _8786_/D sky130_fd_sc_hd__buf_1
X_4673_ _4669_/X _4672_/X _4673_/S VGND VGND VPWR VPWR _4674_/A sky130_fd_sc_hd__mux2_2
XFILLER_135_719 VGND VGND VPWR VPWR sky130_fd_sc_hd__decap_3
X_6412_ _6412_/A VGND VGND VPWR VPWR _8261_/D sky130_fd_sc_hd__buf_2
XFILLER_128_760 VGND VGND VPWR VPWR sky130_fd_sc_hd__decap_3
XFILLER_128_793 VGND VGND VPWR VPWR sky130_fd_sc_hd__decap_3
XFILLER_134_218 VGND VGND VPWR VPWR sky130_fd_sc_hd__decap_3
X_7392_ _7392_/A VGND VGND VPWR VPWR _8753_/D sky130_fd_sc_hd__buf_1
X_6343_ _6343_/A VGND VGND VPWR VPWR _8228_/D sky130_fd_sc_hd__buf_2
XFILLER_0_209 VGND VGND VPWR VPWR sky130_fd_sc_hd__fill_2
X_6274_ _6274_/A VGND VGND VPWR VPWR _8196_/D sky130_fd_sc_hd__buf_6
XFILLER_130_424 VGND VGND VPWR VPWR sky130_fd_sc_hd__decap_3
X_8013_ _8672_/CLK _8013_/D load_slew687/X VGND VGND VPWR VPWR _8013_/Q sky130_fd_sc_hd__dfrtp_2
X_5225_ _5225_/A VGND VGND VPWR VPWR _7667_/D sky130_fd_sc_hd__buf_1
XFILLER_130_457 VGND VGND VPWR VPWR sky130_fd_sc_hd__decap_3
Xclkbuf_leaf_111_CLK clkbuf_5_20__f_CLK/X VGND VGND VPWR VPWR _8792_/CLK sky130_fd_sc_hd__clkbuf_8
XFILLER_111_660 VGND VGND VPWR VPWR sky130_fd_sc_hd__decap_3
XFILLER_29_427 VGND VGND VPWR VPWR sky130_fd_sc_hd__decap_3
XFILLER_69_596 VGND VGND VPWR VPWR sky130_fd_sc_hd__fill_1
XFILLER_96_371 VGND VGND VPWR VPWR sky130_fd_sc_hd__decap_3
X_5156_ _4933_/X _7636_/Q _5158_/S VGND VGND VPWR VPWR _5157_/A sky130_fd_sc_hd__mux2_2
XFILLER_110_170 VGND VGND VPWR VPWR sky130_fd_sc_hd__decap_3
XFILLER_29_449 VGND VGND VPWR VPWR sky130_fd_sc_hd__decap_3
XFILLER_84_533 VGND VGND VPWR VPWR sky130_fd_sc_hd__fill_2
XFILLER_84_544 VGND VGND VPWR VPWR sky130_fd_sc_hd__decap_3
X_5087_ _4795_/X _7603_/Q _5095_/S VGND VGND VPWR VPWR _5088_/A sky130_fd_sc_hd__mux2_2
X_4107_ _8731_/Q _7506_/Q _7587_/Q _7668_/Q _4110_/S0 _4110_/S1 VGND VGND VPWR VPWR
+ _4107_/X sky130_fd_sc_hd__mux4_2
XFILLER_112_24 VGND VGND VPWR VPWR sky130_fd_sc_hd__decap_3
XFILLER_56_268 VGND VGND VPWR VPWR sky130_fd_sc_hd__fill_1
X_4038_ _4032_/X _4034_/X _4036_/X _4037_/X VGND VGND VPWR VPWR _4038_/X sky130_fd_sc_hd__a22o_2
XFILLER_37_493 VGND VGND VPWR VPWR sky130_fd_sc_hd__fill_2
XFILLER_65_780 VGND VGND VPWR VPWR sky130_fd_sc_hd__decap_3
XFILLER_24_132 VGND VGND VPWR VPWR sky130_fd_sc_hd__fill_1
XFILLER_25_655 VGND VGND VPWR VPWR sky130_fd_sc_hd__decap_3
XTAP_TAPCELL_ROW_80_1409 VGND VPWR sky130_fd_sc_hd__tapvpwrvgnd_1
XFILLER_24_154 VGND VGND VPWR VPWR sky130_fd_sc_hd__decap_3
XFILLER_40_625 VGND VGND VPWR VPWR sky130_fd_sc_hd__decap_3
X_8777_ _8777_/CLK _8777_/D load_slew750/X VGND VGND VPWR VPWR _8777_/Q sky130_fd_sc_hd__dfrtp_2
X_5989_ _5989_/A VGND VGND VPWR VPWR _8062_/D sky130_fd_sc_hd__buf_1
XFILLER_8_309 VGND VGND VPWR VPWR sky130_fd_sc_hd__fill_2
X_7728_ _8710_/CLK _7728_/D fanout660/X VGND VGND VPWR VPWR _7728_/Q sky130_fd_sc_hd__dfrtp_2
XFILLER_21_21 VGND VGND VPWR VPWR sky130_fd_sc_hd__decap_3
X_7659_ _8803_/CLK _7659_/D wire547/X VGND VGND VPWR VPWR _7659_/Q sky130_fd_sc_hd__dfrtp_2
XFILLER_21_54 VGND VGND VPWR VPWR sky130_fd_sc_hd__fill_2
XFILLER_106_421 VGND VGND VPWR VPWR sky130_fd_sc_hd__fill_2
XFILLER_108_3 VGND VGND VPWR VPWR sky130_fd_sc_hd__fill_1
XFILLER_21_87 VGND VGND VPWR VPWR sky130_fd_sc_hd__decap_3
XFILLER_4_526 VGND VGND VPWR VPWR sky130_fd_sc_hd__fill_1
XFILLER_4_548 VGND VGND VPWR VPWR sky130_fd_sc_hd__fill_1
XFILLER_121_402 VGND VGND VPWR VPWR sky130_fd_sc_hd__decap_3
XFILLER_133_240 VGND VGND VPWR VPWR sky130_fd_sc_hd__decap_3
XFILLER_134_752 VGND VGND VPWR VPWR sky130_fd_sc_hd__decap_3
XFILLER_134_763 VGND VGND VPWR VPWR sky130_fd_sc_hd__decap_3
XFILLER_0_710 VGND VGND VPWR VPWR sky130_fd_sc_hd__decap_3
XFILLER_0_732 VGND VGND VPWR VPWR sky130_fd_sc_hd__decap_3
XFILLER_121_435 VGND VGND VPWR VPWR sky130_fd_sc_hd__decap_3
XFILLER_133_273 VGND VGND VPWR VPWR sky130_fd_sc_hd__decap_3
XFILLER_133_284 VGND VGND VPWR VPWR sky130_fd_sc_hd__decap_3
XFILLER_134_796 VGND VGND VPWR VPWR sky130_fd_sc_hd__decap_3
XFILLER_121_457 VGND VGND VPWR VPWR sky130_fd_sc_hd__decap_3
XFILLER_48_725 VGND VGND VPWR VPWR sky130_fd_sc_hd__fill_1
XFILLER_75_511 VGND VGND VPWR VPWR sky130_fd_sc_hd__fill_2
XTAP_TAPCELL_ROW_7_386 VGND VPWR sky130_fd_sc_hd__tapvpwrvgnd_1
XTAP_TAPCELL_ROW_7_397 VGND VPWR sky130_fd_sc_hd__tapvpwrvgnd_1
Xclkbuf_leaf_102_CLK clkload8/A VGND VGND VPWR VPWR _8785_/CLK sky130_fd_sc_hd__clkbuf_8
XFILLER_47_235 VGND VGND VPWR VPWR sky130_fd_sc_hd__fill_1
XTAP_TAPCELL_ROW_122_2004 VGND VPWR sky130_fd_sc_hd__tapvpwrvgnd_1
XFILLER_15_110 VGND VGND VPWR VPWR sky130_fd_sc_hd__fill_2
XFILLER_16_622 VGND VGND VPWR VPWR sky130_fd_sc_hd__fill_2
XFILLER_16_633 VGND VGND VPWR VPWR sky130_fd_sc_hd__decap_3
XFILLER_90_525 VGND VGND VPWR VPWR sky130_fd_sc_hd__decap_3
XFILLER_90_536 VGND VGND VPWR VPWR sky130_fd_sc_hd__decap_3
XTAP_TAPCELL_ROW_46_937 VGND VPWR sky130_fd_sc_hd__tapvpwrvgnd_1
XFILLER_55_290 VGND VGND VPWR VPWR sky130_fd_sc_hd__decap_3
XFILLER_15_165 VGND VGND VPWR VPWR sky130_fd_sc_hd__decap_3
XFILLER_30_102 VGND VGND VPWR VPWR sky130_fd_sc_hd__fill_1
XTAP_TAPCELL_ROW_26_650 VGND VPWR sky130_fd_sc_hd__tapvpwrvgnd_1
XTAP_TAPCELL_ROW_26_661 VGND VPWR sky130_fd_sc_hd__tapvpwrvgnd_1
XFILLER_30_135 VGND VGND VPWR VPWR sky130_fd_sc_hd__decap_3
XFILLER_62_61 VGND VGND VPWR VPWR sky130_fd_sc_hd__decap_3
XFILLER_129_535 VGND VGND VPWR VPWR sky130_fd_sc_hd__decap_3
XFILLER_7_12 VGND VGND VPWR VPWR sky130_fd_sc_hd__decap_3
XFILLER_7_45 VGND VGND VPWR VPWR sky130_fd_sc_hd__decap_3
XTAP_TAPCELL_ROW_100_1689 VGND VPWR sky130_fd_sc_hd__tapvpwrvgnd_1
XFILLER_116_218 VGND VGND VPWR VPWR sky130_fd_sc_hd__decap_3
XFILLER_129_579 VGND VGND VPWR VPWR sky130_fd_sc_hd__decap_3
XFILLER_7_78 VGND VGND VPWR VPWR sky130_fd_sc_hd__decap_3
XFILLER_109_281 VGND VGND VPWR VPWR sky130_fd_sc_hd__fill_1
XTAP_TAPCELL_ROW_133_2155 VGND VPWR sky130_fd_sc_hd__tapvpwrvgnd_1
XFILLER_125_785 VGND VGND VPWR VPWR sky130_fd_sc_hd__decap_3
XFILLER_112_424 VGND VGND VPWR VPWR sky130_fd_sc_hd__decap_3
XFILLER_124_262 VGND VGND VPWR VPWR sky130_fd_sc_hd__decap_3
XFILLER_124_284 VGND VGND VPWR VPWR sky130_fd_sc_hd__decap_3
XFILLER_97_113 VGND VGND VPWR VPWR sky130_fd_sc_hd__decap_3
XFILLER_98_625 VGND VGND VPWR VPWR sky130_fd_sc_hd__fill_1
XFILLER_112_468 VGND VGND VPWR VPWR sky130_fd_sc_hd__decap_3
XFILLER_3_592 VGND VGND VPWR VPWR sky130_fd_sc_hd__decap_3
X_5010_ input9/X _5026_/B VGND VGND VPWR VPWR _5011_/A sky130_fd_sc_hd__and2_2
XFILLER_39_725 VGND VGND VPWR VPWR sky130_fd_sc_hd__decap_3
XFILLER_78_371 VGND VGND VPWR VPWR sky130_fd_sc_hd__fill_1
Xhold1009 _7622_/Q VGND VGND VPWR VPWR _5127_/A1 sky130_fd_sc_hd__dlygate4sd3_1
XFILLER_38_224 VGND VGND VPWR VPWR sky130_fd_sc_hd__decap_3
XFILLER_38_246 VGND VGND VPWR VPWR sky130_fd_sc_hd__decap_3
XFILLER_66_522 VGND VGND VPWR VPWR sky130_fd_sc_hd__fill_1
XFILLER_66_533 VGND VGND VPWR VPWR sky130_fd_sc_hd__fill_1
XFILLER_81_503 VGND VGND VPWR VPWR sky130_fd_sc_hd__fill_1
XFILLER_81_514 VGND VGND VPWR VPWR sky130_fd_sc_hd__decap_3
XFILLER_93_363 VGND VGND VPWR VPWR sky130_fd_sc_hd__decap_3
XFILLER_19_493 VGND VGND VPWR VPWR sky130_fd_sc_hd__fill_1
XFILLER_53_238 VGND VGND VPWR VPWR sky130_fd_sc_hd__decap_3
XFILLER_66_599 VGND VGND VPWR VPWR sky130_fd_sc_hd__decap_3
XTAP_TAPCELL_ROW_66_1220 VGND VPWR sky130_fd_sc_hd__tapvpwrvgnd_1
X_8700_ _8700_/CLK _8700_/D load_slew748/X VGND VGND VPWR VPWR _8700_/Q sky130_fd_sc_hd__dfrtp_2
Xclkbuf_5_28__f_CLK clkbuf_4_14_0_CLK/X VGND VGND VPWR VPWR clkbuf_leaf_84_CLK/A sky130_fd_sc_hd__clkbuf_16
X_6961_ _4857_/X _8519_/Q _6979_/S VGND VGND VPWR VPWR _6962_/A sky130_fd_sc_hd__mux2_4
XFILLER_34_430 VGND VGND VPWR VPWR sky130_fd_sc_hd__decap_3
XFILLER_34_452 VGND VGND VPWR VPWR sky130_fd_sc_hd__decap_3
X_6892_ _6892_/A VGND VGND VPWR VPWR _8486_/D sky130_fd_sc_hd__buf_6
X_5912_ _5919_/A1 _5919_/A2 _4782_/X _5919_/B1 hold804/X VGND VGND VPWR VPWR _8005_/D
+ sky130_fd_sc_hd__a32o_2
X_8631_ _8721_/CLK _8631_/D fanout588/X VGND VGND VPWR VPWR _8631_/Q sky130_fd_sc_hd__dfrtp_2
X_5843_ _7959_/Q _4929_/A _5847_/S VGND VGND VPWR VPWR _5844_/A sky130_fd_sc_hd__mux2_2
XFILLER_21_113 VGND VGND VPWR VPWR sky130_fd_sc_hd__fill_1
X_8562_ _8724_/CLK _8562_/D fanout502/A VGND VGND VPWR VPWR _8562_/Q sky130_fd_sc_hd__dfrtp_2
X_7513_ _8739_/CLK _7513_/D load_slew511/X VGND VGND VPWR VPWR _7513_/Q sky130_fd_sc_hd__dfrtp_2
X_5774_ _7926_/Q _4791_/A _5784_/S VGND VGND VPWR VPWR _5775_/A sky130_fd_sc_hd__mux2_2
X_8493_ _8493_/CLK _8493_/D fanout479/X VGND VGND VPWR VPWR _8493_/Q sky130_fd_sc_hd__dfrtp_2
X_4725_ _4725_/A VGND VGND VPWR VPWR _7505_/D sky130_fd_sc_hd__buf_1
XFILLER_107_218 VGND VGND VPWR VPWR sky130_fd_sc_hd__decap_3
XFILLER_135_505 VGND VGND VPWR VPWR sky130_fd_sc_hd__decap_3
XTAP_TAPCELL_ROW_118_1939 VGND VPWR sky130_fd_sc_hd__tapvpwrvgnd_1
X_7444_ _7444_/A VGND VGND VPWR VPWR _8778_/D sky130_fd_sc_hd__buf_1
X_4656_ _8041_/Q _3806_/X _4065_/X _7960_/Q wire326/X VGND VGND VPWR VPWR _4656_/X
+ sky130_fd_sc_hd__o221a_2
XFILLER_116_741 VGND VGND VPWR VPWR sky130_fd_sc_hd__decap_3
Xhold810 _8653_/Q VGND VGND VPWR VPWR hold810/X sky130_fd_sc_hd__dlygate4sd3_1
Xhold821 _7969_/Q VGND VGND VPWR VPWR hold821/X sky130_fd_sc_hd__dlygate4sd3_1
Xinput70 wdata[70] VGND VGND VPWR VPWR _4898_/A sky130_fd_sc_hd__clkdlybuf4s25_1
Xinput81 wdata[80] VGND VGND VPWR VPWR _4940_/A sky130_fd_sc_hd__clkdlybuf4s25_1
X_7375_ _7375_/A VGND VGND VPWR VPWR _8745_/D sky130_fd_sc_hd__buf_1
X_4587_ _4585_/X _4586_/X _4669_/S VGND VGND VPWR VPWR _4587_/X sky130_fd_sc_hd__mux2_2
XFILLER_131_700 VGND VGND VPWR VPWR sky130_fd_sc_hd__decap_3
XTAP_TAPCELL_ROW_77_1371 VGND VPWR sky130_fd_sc_hd__tapvpwrvgnd_1
Xhold832 _8004_/Q VGND VGND VPWR VPWR hold832/X sky130_fd_sc_hd__dlygate4sd3_1
Xhold843 _8040_/Q VGND VGND VPWR VPWR hold843/X sky130_fd_sc_hd__dlygate4sd3_1
Xhold854 _8632_/Q VGND VGND VPWR VPWR hold854/X sky130_fd_sc_hd__dlygate4sd3_1
X_6326_ _6326_/A VGND VGND VPWR VPWR _8220_/D sky130_fd_sc_hd__buf_2
XFILLER_107_57 VGND VGND VPWR VPWR sky130_fd_sc_hd__decap_3
XFILLER_115_284 VGND VGND VPWR VPWR sky130_fd_sc_hd__decap_3
Xhold865 _8023_/Q VGND VGND VPWR VPWR hold865/X sky130_fd_sc_hd__dlygate4sd3_1
Xhold876 _8013_/Q VGND VGND VPWR VPWR hold876/X sky130_fd_sc_hd__dlygate4sd3_1
Xhold887 _8014_/Q VGND VGND VPWR VPWR hold887/X sky130_fd_sc_hd__dlygate4sd3_1
Xhold898 _8022_/Q VGND VGND VPWR VPWR hold898/X sky130_fd_sc_hd__dlygate4sd3_1
XFILLER_130_221 VGND VGND VPWR VPWR sky130_fd_sc_hd__decap_3
XFILLER_131_744 VGND VGND VPWR VPWR sky130_fd_sc_hd__decap_3
XFILLER_131_777 VGND VGND VPWR VPWR sky130_fd_sc_hd__decap_3
X_6257_ _6257_/A VGND VGND VPWR VPWR _8188_/D sky130_fd_sc_hd__buf_6
XFILLER_103_479 VGND VGND VPWR VPWR sky130_fd_sc_hd__decap_3
XFILLER_130_265 VGND VGND VPWR VPWR sky130_fd_sc_hd__fill_1
XFILLER_130_287 VGND VGND VPWR VPWR sky130_fd_sc_hd__decap_3
XFILLER_131_788 VGND VGND VPWR VPWR sky130_fd_sc_hd__decap_3
XFILLER_57_500 VGND VGND VPWR VPWR sky130_fd_sc_hd__decap_3
X_6188_ _6188_/A VGND VGND VPWR VPWR _8155_/D sky130_fd_sc_hd__buf_6
X_5208_ _7659_/Q _5031_/X _5226_/S VGND VGND VPWR VPWR _5209_/A sky130_fd_sc_hd__mux2_2
XFILLER_123_23 VGND VGND VPWR VPWR sky130_fd_sc_hd__decap_3
XFILLER_57_522 VGND VGND VPWR VPWR sky130_fd_sc_hd__decap_3
XFILLER_69_393 VGND VGND VPWR VPWR sky130_fd_sc_hd__fill_2
XTAP_TAPCELL_ROW_4_345 VGND VPWR sky130_fd_sc_hd__tapvpwrvgnd_1
X_5139_ _5160_/S VGND VGND VPWR VPWR _5158_/S sky130_fd_sc_hd__buf_2
XFILLER_72_514 VGND VGND VPWR VPWR sky130_fd_sc_hd__decap_3
XFILLER_84_363 VGND VGND VPWR VPWR sky130_fd_sc_hd__fill_1
XFILLER_123_78 VGND VGND VPWR VPWR sky130_fd_sc_hd__decap_3
XFILLER_38_780 VGND VGND VPWR VPWR sky130_fd_sc_hd__decap_3
XFILLER_83_38 VGND VGND VPWR VPWR sky130_fd_sc_hd__decap_3
XFILLER_16_21 VGND VGND VPWR VPWR sky130_fd_sc_hd__decap_3
XFILLER_16_32 VGND VGND VPWR VPWR sky130_fd_sc_hd__decap_3
XFILLER_25_441 VGND VGND VPWR VPWR sky130_fd_sc_hd__decap_3
XFILLER_25_452 VGND VGND VPWR VPWR sky130_fd_sc_hd__decap_3
XFILLER_13_603 VGND VGND VPWR VPWR sky130_fd_sc_hd__decap_3
XFILLER_16_65 VGND VGND VPWR VPWR sky130_fd_sc_hd__decap_3
XFILLER_52_282 VGND VGND VPWR VPWR sky130_fd_sc_hd__fill_1
XTAP_TAPCELL_ROW_23_620 VGND VPWR sky130_fd_sc_hd__tapvpwrvgnd_1
XFILLER_12_168 VGND VGND VPWR VPWR sky130_fd_sc_hd__decap_3
XFILLER_32_20 VGND VGND VPWR VPWR sky130_fd_sc_hd__decap_3
XFILLER_40_455 VGND VGND VPWR VPWR sky130_fd_sc_hd__decap_3
XFILLER_40_477 VGND VGND VPWR VPWR sky130_fd_sc_hd__decap_3
XFILLER_9_629 VGND VGND VPWR VPWR sky130_fd_sc_hd__decap_3
XFILLER_12_179 VGND VGND VPWR VPWR sky130_fd_sc_hd__decap_3
XFILLER_32_53 VGND VGND VPWR VPWR sky130_fd_sc_hd__decap_3
XFILLER_8_139 VGND VGND VPWR VPWR sky130_fd_sc_hd__fill_1
XFILLER_126_505 VGND VGND VPWR VPWR sky130_fd_sc_hd__decap_3
XFILLER_106_240 VGND VGND VPWR VPWR sky130_fd_sc_hd__decap_3
XFILLER_134_560 VGND VGND VPWR VPWR sky130_fd_sc_hd__decap_3
XFILLER_107_785 VGND VGND VPWR VPWR sky130_fd_sc_hd__decap_3
XFILLER_79_113 VGND VGND VPWR VPWR sky130_fd_sc_hd__decap_3
XFILLER_122_744 VGND VGND VPWR VPWR sky130_fd_sc_hd__fill_1
XFILLER_122_755 VGND VGND VPWR VPWR sky130_fd_sc_hd__fill_1
XFILLER_122_766 VGND VGND VPWR VPWR sky130_fd_sc_hd__decap_3
XFILLER_79_157 VGND VGND VPWR VPWR sky130_fd_sc_hd__decap_3
XFILLER_67_319 VGND VGND VPWR VPWR sky130_fd_sc_hd__decap_3
XFILLER_95_617 VGND VGND VPWR VPWR sky130_fd_sc_hd__fill_1
XFILLER_95_639 VGND VGND VPWR VPWR sky130_fd_sc_hd__decap_3
XFILLER_0_584 VGND VGND VPWR VPWR sky130_fd_sc_hd__decap_3
XFILLER_48_533 VGND VGND VPWR VPWR sky130_fd_sc_hd__decap_3
XFILLER_57_50 VGND VGND VPWR VPWR sky130_fd_sc_hd__decap_3
XFILLER_75_330 VGND VGND VPWR VPWR sky130_fd_sc_hd__decap_3
XFILLER_87_190 VGND VGND VPWR VPWR sky130_fd_sc_hd__decap_3
XFILLER_57_94 VGND VGND VPWR VPWR sky130_fd_sc_hd__fill_2
XFILLER_35_216 VGND VGND VPWR VPWR sky130_fd_sc_hd__decap_3
XFILLER_44_750 VGND VGND VPWR VPWR sky130_fd_sc_hd__decap_3
XFILLER_90_344 VGND VGND VPWR VPWR sky130_fd_sc_hd__fill_1
XFILLER_90_399 VGND VGND VPWR VPWR sky130_fd_sc_hd__decap_3
XTAP_TAPCELL_ROW_102_1718 VGND VPWR sky130_fd_sc_hd__tapvpwrvgnd_1
XFILLER_31_422 VGND VGND VPWR VPWR sky130_fd_sc_hd__fill_2
XFILLER_73_93 VGND VGND VPWR VPWR sky130_fd_sc_hd__fill_1
XFILLER_92_6 VGND VGND VPWR VPWR sky130_fd_sc_hd__decap_3
XTAP_TAPCELL_ROW_61_1150 VGND VPWR sky130_fd_sc_hd__tapvpwrvgnd_1
XFILLER_129_332 VGND VGND VPWR VPWR sky130_fd_sc_hd__decap_3
XFILLER_129_343 VGND VGND VPWR VPWR sky130_fd_sc_hd__decap_3
XFILLER_8_640 VGND VGND VPWR VPWR sky130_fd_sc_hd__decap_3
XFILLER_129_365 VGND VGND VPWR VPWR sky130_fd_sc_hd__decap_3
XFILLER_8_651 VGND VGND VPWR VPWR sky130_fd_sc_hd__decap_3
X_5490_ _5490_/A VGND VGND VPWR VPWR _7792_/D sky130_fd_sc_hd__buf_1
X_4510_ _4510_/A1 _4509_/X _3848_/X VGND VGND VPWR VPWR _4510_/X sky130_fd_sc_hd__o21a_2
XFILLER_7_183 VGND VGND VPWR VPWR sky130_fd_sc_hd__decap_3
XFILLER_8_684 VGND VGND VPWR VPWR sky130_fd_sc_hd__decap_3
X_4441_ _7778_/Q _7859_/Q _4441_/S VGND VGND VPWR VPWR _4442_/B sky130_fd_sc_hd__mux2_2
XFILLER_132_519 VGND VGND VPWR VPWR sky130_fd_sc_hd__decap_3
XPHY_EDGE_ROW_9_Right_9 VGND VGND VPWR VPWR sky130_fd_sc_hd__decap_3
X_7160_ _4913_/X _8613_/Q _7172_/S VGND VGND VPWR VPWR _7161_/A sky130_fd_sc_hd__mux2_2
X_6111_ _6111_/A VGND VGND VPWR VPWR _8120_/D sky130_fd_sc_hd__buf_1
X_4372_ _4372_/A VGND VGND VPWR VPWR _4372_/X sky130_fd_sc_hd__buf_1
XFILLER_112_232 VGND VGND VPWR VPWR sky130_fd_sc_hd__decap_3
XTAP_TAPCELL_ROW_113_1869 VGND VPWR sky130_fd_sc_hd__tapvpwrvgnd_1
Xfanout619 fanout653/X VGND VGND VPWR VPWR fanout619/X sky130_fd_sc_hd__clkdlybuf4s25_1
X_7091_ _4773_/X hold932/X _7109_/S VGND VGND VPWR VPWR _7092_/A sky130_fd_sc_hd__mux2_1
XFILLER_100_416 VGND VGND VPWR VPWR sky130_fd_sc_hd__decap_3
XFILLER_112_276 VGND VGND VPWR VPWR sky130_fd_sc_hd__decap_3
XFILLER_113_788 VGND VGND VPWR VPWR sky130_fd_sc_hd__decap_3
XFILLER_39_511 VGND VGND VPWR VPWR sky130_fd_sc_hd__decap_3
XFILLER_98_477 VGND VGND VPWR VPWR sky130_fd_sc_hd__decap_3
XPHY_EDGE_ROW_107_Right_107 VGND VGND VPWR VPWR sky130_fd_sc_hd__decap_3
X_6042_ _6042_/A VGND VGND VPWR VPWR _8087_/D sky130_fd_sc_hd__buf_1
XFILLER_100_427 VGND VGND VPWR VPWR sky130_fd_sc_hd__decap_3
XFILLER_85_127 VGND VGND VPWR VPWR sky130_fd_sc_hd__fill_1
XFILLER_85_149 VGND VGND VPWR VPWR sky130_fd_sc_hd__fill_2
XFILLER_54_503 VGND VGND VPWR VPWR sky130_fd_sc_hd__decap_3
XTAP_TAPCELL_ROW_1_304 VGND VPWR sky130_fd_sc_hd__tapvpwrvgnd_1
X_7993_ _8655_/CLK _7993_/D load_slew484/X VGND VGND VPWR VPWR _7993_/Q sky130_fd_sc_hd__dfrtp_2
XFILLER_26_249 VGND VGND VPWR VPWR sky130_fd_sc_hd__decap_3
XFILLER_35_750 VGND VGND VPWR VPWR sky130_fd_sc_hd__decap_3
XPHY_EDGE_ROW_53_Left_189 VGND VGND VPWR VPWR sky130_fd_sc_hd__decap_3
X_6944_ _4824_/X _8511_/Q _6958_/S VGND VGND VPWR VPWR _6945_/A sky130_fd_sc_hd__mux2_4
XFILLER_22_400 VGND VGND VPWR VPWR sky130_fd_sc_hd__decap_3
XFILLER_53_19 VGND VGND VPWR VPWR sky130_fd_sc_hd__decap_3
XFILLER_34_282 VGND VGND VPWR VPWR sky130_fd_sc_hd__decap_3
X_8614_ _8695_/CLK _8614_/D load_slew733/X VGND VGND VPWR VPWR _8614_/Q sky130_fd_sc_hd__dfrtp_2
X_6875_ _6875_/A VGND VGND VPWR VPWR _8478_/D sky130_fd_sc_hd__buf_6
XFILLER_22_466 VGND VGND VPWR VPWR sky130_fd_sc_hd__decap_3
XFILLER_50_775 VGND VGND VPWR VPWR sky130_fd_sc_hd__decap_3
X_5826_ _7951_/Q _4895_/A _5826_/S VGND VGND VPWR VPWR _5827_/A sky130_fd_sc_hd__mux2_2
XFILLER_10_628 VGND VGND VPWR VPWR sky130_fd_sc_hd__decap_3
XTAP_TAPCELL_ROW_79_1400 VGND VPWR sky130_fd_sc_hd__tapvpwrvgnd_1
X_8545_ _8545_/CLK _8545_/D load_slew661/X VGND VGND VPWR VPWR _8545_/Q sky130_fd_sc_hd__dfrtp_2
X_5757_ _5757_/A0 _4757_/A _5763_/S VGND VGND VPWR VPWR _5758_/A sky130_fd_sc_hd__mux2_2
X_8476_ _8638_/CLK _8476_/D fanout583/X VGND VGND VPWR VPWR _8476_/Q sky130_fd_sc_hd__dfrtp_2
X_4708_ _4707_/X _4708_/A1 _4736_/S VGND VGND VPWR VPWR _4709_/A sky130_fd_sc_hd__mux2_2
XFILLER_118_12 VGND VGND VPWR VPWR sky130_fd_sc_hd__decap_3
XPHY_EDGE_ROW_62_Left_198 VGND VGND VPWR VPWR sky130_fd_sc_hd__decap_3
X_7427_ _7427_/A VGND VGND VPWR VPWR _8770_/D sky130_fd_sc_hd__buf_1
X_5688_ _7885_/Q _4961_/A _5700_/S VGND VGND VPWR VPWR _5689_/A sky130_fd_sc_hd__mux2_2
XFILLER_135_368 VGND VGND VPWR VPWR sky130_fd_sc_hd__decap_3
XTAP_TAPCELL_ROW_9_415 VGND VPWR sky130_fd_sc_hd__tapvpwrvgnd_1
X_4639_ _4639_/A1 _4638_/X _3877_/X VGND VGND VPWR VPWR _4639_/X sky130_fd_sc_hd__o21a_2
XFILLER_78_27 VGND VGND VPWR VPWR sky130_fd_sc_hd__fill_1
X_7358_ _7358_/A VGND VGND VPWR VPWR _8737_/D sky130_fd_sc_hd__buf_1
XFILLER_104_755 VGND VGND VPWR VPWR sky130_fd_sc_hd__fill_1
XFILLER_104_766 VGND VGND VPWR VPWR sky130_fd_sc_hd__fill_1
XFILLER_131_541 VGND VGND VPWR VPWR sky130_fd_sc_hd__decap_3
X_7289_ _7289_/A VGND VGND VPWR VPWR _8704_/D sky130_fd_sc_hd__buf_1
X_6309_ _6309_/A VGND VGND VPWR VPWR _8213_/D sky130_fd_sc_hd__buf_6
XFILLER_103_254 VGND VGND VPWR VPWR sky130_fd_sc_hd__fill_2
XFILLER_131_585 VGND VGND VPWR VPWR sky130_fd_sc_hd__decap_3
XFILLER_134_44 VGND VGND VPWR VPWR sky130_fd_sc_hd__decap_3
XFILLER_77_617 VGND VGND VPWR VPWR sky130_fd_sc_hd__decap_3
XFILLER_89_499 VGND VGND VPWR VPWR sky130_fd_sc_hd__decap_3
XFILLER_134_77 VGND VGND VPWR VPWR sky130_fd_sc_hd__decap_3
XFILLER_134_88 VGND VGND VPWR VPWR sky130_fd_sc_hd__decap_3
XFILLER_45_503 VGND VGND VPWR VPWR sky130_fd_sc_hd__fill_1
XFILLER_17_205 VGND VGND VPWR VPWR sky130_fd_sc_hd__decap_3
XFILLER_27_42 VGND VGND VPWR VPWR sky130_fd_sc_hd__decap_3
XFILLER_45_514 VGND VGND VPWR VPWR sky130_fd_sc_hd__decap_3
XFILLER_26_750 VGND VGND VPWR VPWR sky130_fd_sc_hd__decap_3
XFILLER_27_75 VGND VGND VPWR VPWR sky130_fd_sc_hd__decap_3
XFILLER_45_558 VGND VGND VPWR VPWR sky130_fd_sc_hd__fill_2
XFILLER_72_333 VGND VGND VPWR VPWR sky130_fd_sc_hd__decap_3
XFILLER_25_260 VGND VGND VPWR VPWR sky130_fd_sc_hd__decap_3
XFILLER_26_772 VGND VGND VPWR VPWR sky130_fd_sc_hd__decap_3
XFILLER_60_506 VGND VGND VPWR VPWR sky130_fd_sc_hd__decap_3
XFILLER_60_539 VGND VGND VPWR VPWR sky130_fd_sc_hd__decap_3
Xclkbuf_5_11__f_CLK clkbuf_4_5_0_CLK/X VGND VGND VPWR VPWR clkload3/A sky130_fd_sc_hd__clkbuf_16
XFILLER_13_411 VGND VGND VPWR VPWR sky130_fd_sc_hd__fill_1
XFILLER_53_580 VGND VGND VPWR VPWR sky130_fd_sc_hd__decap_3
XFILLER_13_444 VGND VGND VPWR VPWR sky130_fd_sc_hd__decap_3
XFILLER_13_455 VGND VGND VPWR VPWR sky130_fd_sc_hd__decap_3
XFILLER_40_241 VGND VGND VPWR VPWR sky130_fd_sc_hd__fill_2
XFILLER_41_775 VGND VGND VPWR VPWR sky130_fd_sc_hd__decap_3
XFILLER_127_803 VGND VGND VPWR VPWR sky130_fd_sc_hd__fill_1
XFILLER_126_324 VGND VGND VPWR VPWR sky130_fd_sc_hd__fill_1
XFILLER_5_632 VGND VGND VPWR VPWR sky130_fd_sc_hd__decap_3
XFILLER_126_357 VGND VGND VPWR VPWR sky130_fd_sc_hd__decap_3
XFILLER_126_368 VGND VGND VPWR VPWR sky130_fd_sc_hd__decap_3
XFILLER_5_665 VGND VGND VPWR VPWR sky130_fd_sc_hd__decap_3
XTAP_TAPCELL_ROW_130_2114 VGND VPWR sky130_fd_sc_hd__tapvpwrvgnd_1
XFILLER_4_24 VGND VGND VPWR VPWR sky130_fd_sc_hd__decap_3
XFILLER_5_676 VGND VGND VPWR VPWR sky130_fd_sc_hd__decap_3
XFILLER_4_197 VGND VGND VPWR VPWR sky130_fd_sc_hd__decap_3
XFILLER_4_35 VGND VGND VPWR VPWR sky130_fd_sc_hd__decap_3
XFILLER_4_68 VGND VGND VPWR VPWR sky130_fd_sc_hd__decap_3
XFILLER_110_747 VGND VGND VPWR VPWR sky130_fd_sc_hd__decap_3
XFILLER_67_116 VGND VGND VPWR VPWR sky130_fd_sc_hd__decap_3
XFILLER_95_458 VGND VGND VPWR VPWR sky130_fd_sc_hd__decap_3
XFILLER_110_769 VGND VGND VPWR VPWR sky130_fd_sc_hd__decap_3
XFILLER_36_514 VGND VGND VPWR VPWR sky130_fd_sc_hd__fill_2
XFILLER_48_374 VGND VGND VPWR VPWR sky130_fd_sc_hd__decap_3
XFILLER_75_160 VGND VGND VPWR VPWR sky130_fd_sc_hd__fill_2
XFILLER_76_694 VGND VGND VPWR VPWR sky130_fd_sc_hd__fill_2
XTAP_TAPCELL_ROW_128_2087 VGND VPWR sky130_fd_sc_hd__tapvpwrvgnd_1
XFILLER_17_750 VGND VGND VPWR VPWR sky130_fd_sc_hd__decap_3
XFILLER_90_130 VGND VGND VPWR VPWR sky130_fd_sc_hd__decap_3
XFILLER_90_141 VGND VGND VPWR VPWR sky130_fd_sc_hd__fill_2
XFILLER_17_783 VGND VGND VPWR VPWR sky130_fd_sc_hd__fill_1
XFILLER_63_366 VGND VGND VPWR VPWR sky130_fd_sc_hd__fill_2
XFILLER_63_377 VGND VGND VPWR VPWR sky130_fd_sc_hd__decap_3
XFILLER_91_697 VGND VGND VPWR VPWR sky130_fd_sc_hd__fill_2
X_4990_ _5118_/A VGND VGND VPWR VPWR _5028_/S sky130_fd_sc_hd__buf_2
XFILLER_90_185 VGND VGND VPWR VPWR sky130_fd_sc_hd__decap_3
X_3941_ _4393_/A _3936_/X _3938_/X _3940_/X VGND VGND VPWR VPWR _3941_/X sky130_fd_sc_hd__a22o_2
XFILLER_90_3 VGND VGND VPWR VPWR sky130_fd_sc_hd__decap_3
X_3872_ _7647_/Q _3799_/X _3870_/X _7566_/Q _3871_/X VGND VGND VPWR VPWR _3872_/X
+ sky130_fd_sc_hd__o221a_2
X_6660_ _6314_/A _7004_/B _8050_/Q _7269_/A VGND VGND VPWR VPWR _6661_/A sky130_fd_sc_hd__and4b_2
XTAP_TAPCELL_ROW_14_483 VGND VPWR sky130_fd_sc_hd__tapvpwrvgnd_1
X_6591_ _4811_/X _8346_/Q _6591_/S VGND VGND VPWR VPWR _6592_/A sky130_fd_sc_hd__mux2_2
X_5611_ _5611_/A VGND VGND VPWR VPWR _7849_/D sky130_fd_sc_hd__buf_1
XFILLER_129_140 VGND VGND VPWR VPWR sky130_fd_sc_hd__decap_3
XTAP_TAPCELL_ROW_14_494 VGND VPWR sky130_fd_sc_hd__tapvpwrvgnd_1
X_8330_ _8335_/CLK _8330_/D load_slew541/X VGND VGND VPWR VPWR _8330_/Q sky130_fd_sc_hd__dfrtp_2
X_5542_ _5542_/A VGND VGND VPWR VPWR _7816_/D sky130_fd_sc_hd__buf_1
XFILLER_129_184 VGND VGND VPWR VPWR sky130_fd_sc_hd__decap_3
XTAP_TAPCELL_ROW_115_1909 VGND VPWR sky130_fd_sc_hd__tapvpwrvgnd_1
Xclkbuf_leaf_91_CLK clkbuf_leaf_91_CLK/A VGND VGND VPWR VPWR _8782_/CLK sky130_fd_sc_hd__clkbuf_8
X_8261_ _8669_/CLK _8261_/D load_slew645/X VGND VGND VPWR VPWR _8261_/Q sky130_fd_sc_hd__dfrtp_2
X_5473_ _5473_/A VGND VGND VPWR VPWR _7784_/D sky130_fd_sc_hd__buf_1
XTAP_TAPCELL_ROW_74_1330 VGND VPWR sky130_fd_sc_hd__tapvpwrvgnd_1
X_8192_ _8597_/CLK _8192_/D fanout705/X VGND VGND VPWR VPWR _8192_/Q sky130_fd_sc_hd__dfrtp_2
X_7212_ _7213_/A1 _4715_/X _7204_/X _7205_/X hold872/X VGND VGND VPWR VPWR _8647_/D
+ sky130_fd_sc_hd__a32o_2
X_4424_ _8597_/Q _4424_/A2 _4423_/X _4455_/A _4456_/C1 VGND VGND VPWR VPWR _4424_/X
+ sky130_fd_sc_hd__o221a_2
XFILLER_132_349 VGND VGND VPWR VPWR sky130_fd_sc_hd__decap_3
Xfanout405 _4272_/S VGND VGND VPWR VPWR _4197_/S sky130_fd_sc_hd__clkdlybuf4s25_1
X_7143_ _4879_/X _8605_/Q _7151_/S VGND VGND VPWR VPWR _7144_/A sky130_fd_sc_hd__mux2_2
X_4355_ _8429_/Q _8510_/Q _8591_/Q _8672_/Q _4352_/S _4368_/A VGND VGND VPWR VPWR
+ _4355_/X sky130_fd_sc_hd__mux4_2
XFILLER_98_274 VGND VGND VPWR VPWR sky130_fd_sc_hd__decap_3
Xfanout427 fanout433/X VGND VGND VPWR VPWR _3983_/S sky130_fd_sc_hd__clkdlybuf4s25_1
X_7074_ _4740_/X _7074_/A1 _7088_/S VGND VGND VPWR VPWR _7075_/A sky130_fd_sc_hd__mux2_1
XFILLER_100_224 VGND VGND VPWR VPWR sky130_fd_sc_hd__decap_3
XFILLER_58_127 VGND VGND VPWR VPWR sky130_fd_sc_hd__decap_3
XFILLER_86_436 VGND VGND VPWR VPWR sky130_fd_sc_hd__decap_3
Xfanout449 _3861_/S VGND VGND VPWR VPWR _3747_/S sky130_fd_sc_hd__clkdlybuf4s25_1
X_4286_ _8342_/Q _4286_/A2 _3889_/X _8261_/Q _4682_/C1 VGND VGND VPWR VPWR _4286_/X
+ sky130_fd_sc_hd__o221a_2
XFILLER_104_25 VGND VGND VPWR VPWR sky130_fd_sc_hd__decap_3
XFILLER_39_341 VGND VGND VPWR VPWR sky130_fd_sc_hd__decap_3
X_6025_ _6025_/A VGND VGND VPWR VPWR _8079_/D sky130_fd_sc_hd__buf_2
XFILLER_27_525 VGND VGND VPWR VPWR sky130_fd_sc_hd__decap_3
XFILLER_73_119 VGND VGND VPWR VPWR sky130_fd_sc_hd__decap_3
XFILLER_94_480 VGND VGND VPWR VPWR sky130_fd_sc_hd__fill_2
XFILLER_39_396 VGND VGND VPWR VPWR sky130_fd_sc_hd__fill_2
XFILLER_54_333 VGND VGND VPWR VPWR sky130_fd_sc_hd__decap_3
XFILLER_64_29 VGND VGND VPWR VPWR sky130_fd_sc_hd__decap_3
XFILLER_120_13 VGND VGND VPWR VPWR sky130_fd_sc_hd__decap_3
XFILLER_54_377 VGND VGND VPWR VPWR sky130_fd_sc_hd__decap_3
XFILLER_82_675 VGND VGND VPWR VPWR sky130_fd_sc_hd__fill_1
X_7976_ _8634_/CLK _7976_/D load_slew605/X VGND VGND VPWR VPWR _7976_/Q sky130_fd_sc_hd__dfrtp_2
XFILLER_54_399 VGND VGND VPWR VPWR sky130_fd_sc_hd__decap_3
XFILLER_81_185 VGND VGND VPWR VPWR sky130_fd_sc_hd__decap_3
XTAP_TAPCELL_ROW_85_1481 VGND VPWR sky130_fd_sc_hd__tapvpwrvgnd_1
X_6927_ _4791_/X _8503_/Q _6937_/S VGND VGND VPWR VPWR _6928_/A sky130_fd_sc_hd__mux2_4
XFILLER_50_561 VGND VGND VPWR VPWR sky130_fd_sc_hd__decap_3
X_6858_ _4995_/X _8470_/Q _6874_/S VGND VGND VPWR VPWR _6859_/A sky130_fd_sc_hd__mux2_4
XFILLER_13_33 VGND VGND VPWR VPWR sky130_fd_sc_hd__decap_3
XFILLER_50_583 VGND VGND VPWR VPWR sky130_fd_sc_hd__decap_3
X_5809_ _5809_/A VGND VGND VPWR VPWR _7942_/D sky130_fd_sc_hd__buf_1
XFILLER_10_447 VGND VGND VPWR VPWR sky130_fd_sc_hd__fill_1
XFILLER_129_33 VGND VGND VPWR VPWR sky130_fd_sc_hd__decap_3
XFILLER_13_66 VGND VGND VPWR VPWR sky130_fd_sc_hd__decap_3
XPHY_EDGE_ROW_70_Left_206 VGND VGND VPWR VPWR sky130_fd_sc_hd__decap_3
X_8528_ _8688_/CLK _8528_/D load_slew572/X VGND VGND VPWR VPWR _8528_/Q sky130_fd_sc_hd__dfrtp_2
X_6789_ _8438_/Q _4856_/A _6807_/S VGND VGND VPWR VPWR _6790_/A sky130_fd_sc_hd__mux2_2
XFILLER_129_66 VGND VGND VPWR VPWR sky130_fd_sc_hd__decap_3
XFILLER_6_418 VGND VGND VPWR VPWR sky130_fd_sc_hd__fill_2
Xclkbuf_leaf_82_CLK clkbuf_leaf_84_CLK/A VGND VGND VPWR VPWR _8772_/CLK sky130_fd_sc_hd__clkbuf_8
XFILLER_129_99 VGND VGND VPWR VPWR sky130_fd_sc_hd__decap_3
X_8459_ _8783_/CLK _8459_/D wire680/A VGND VGND VPWR VPWR _8459_/Q sky130_fd_sc_hd__dfrtp_2
XFILLER_135_187 VGND VGND VPWR VPWR sky130_fd_sc_hd__decap_3
XFILLER_2_613 VGND VGND VPWR VPWR sky130_fd_sc_hd__decap_3
XFILLER_2_657 VGND VGND VPWR VPWR sky130_fd_sc_hd__decap_3
XFILLER_104_574 VGND VGND VPWR VPWR sky130_fd_sc_hd__decap_3
XFILLER_131_393 VGND VGND VPWR VPWR sky130_fd_sc_hd__decap_3
XFILLER_77_436 VGND VGND VPWR VPWR sky130_fd_sc_hd__fill_1
XFILLER_65_609 VGND VGND VPWR VPWR sky130_fd_sc_hd__decap_3
XFILLER_18_503 VGND VGND VPWR VPWR sky130_fd_sc_hd__fill_2
XFILLER_38_85 VGND VGND VPWR VPWR sky130_fd_sc_hd__fill_1
XFILLER_72_141 VGND VGND VPWR VPWR sky130_fd_sc_hd__fill_2
XFILLER_33_539 VGND VGND VPWR VPWR sky130_fd_sc_hd__decap_3
XFILLER_60_325 VGND VGND VPWR VPWR sky130_fd_sc_hd__decap_3
XFILLER_60_336 VGND VGND VPWR VPWR sky130_fd_sc_hd__decap_3
XFILLER_41_550 VGND VGND VPWR VPWR sky130_fd_sc_hd__decap_3
XFILLER_41_561 VGND VGND VPWR VPWR sky130_fd_sc_hd__decap_3
XFILLER_9_234 VGND VGND VPWR VPWR sky130_fd_sc_hd__decap_3
XPHY_EDGE_ROW_109_Left_245 VGND VGND VPWR VPWR sky130_fd_sc_hd__decap_3
XTAP_TAPCELL_ROW_31_729 VGND VPWR sky130_fd_sc_hd__tapvpwrvgnd_1
XFILLER_127_600 VGND VGND VPWR VPWR sky130_fd_sc_hd__decap_3
XFILLER_13_296 VGND VGND VPWR VPWR sky130_fd_sc_hd__decap_3
XFILLER_127_633 VGND VGND VPWR VPWR sky130_fd_sc_hd__decap_3
XTAP_TAPCELL_ROW_11_442 VGND VPWR sky130_fd_sc_hd__tapvpwrvgnd_1
XTAP_TAPCELL_ROW_11_453 VGND VPWR sky130_fd_sc_hd__tapvpwrvgnd_1
Xclkbuf_leaf_73_CLK clkload11/A VGND VGND VPWR VPWR _8779_/CLK sky130_fd_sc_hd__clkbuf_8
Xclkload15 _8655_/CLK VGND VGND VPWR VPWR clkload15/X sky130_fd_sc_hd__clkbuf_8
Xclkload26 _8410_/CLK VGND VGND VPWR VPWR clkload26/Y sky130_fd_sc_hd__bufinv_16
XFILLER_126_121 VGND VGND VPWR VPWR sky130_fd_sc_hd__decap_3
Xclkload37 _8639_/CLK VGND VGND VPWR VPWR clkload37/X sky130_fd_sc_hd__clkbuf_8
Xclkload48 _8793_/CLK VGND VGND VPWR VPWR clkload48/X sky130_fd_sc_hd__clkbuf_8
Xclkload59 _8789_/CLK VGND VGND VPWR VPWR clkload59/Y sky130_fd_sc_hd__clkinv_2
XFILLER_126_176 VGND VGND VPWR VPWR sky130_fd_sc_hd__decap_3
XFILLER_127_688 VGND VGND VPWR VPWR sky130_fd_sc_hd__decap_3
XFILLER_55_6 VGND VGND VPWR VPWR sky130_fd_sc_hd__decap_3
XFILLER_122_360 VGND VGND VPWR VPWR sky130_fd_sc_hd__decap_3
XPHY_EDGE_ROW_118_Left_254 VGND VGND VPWR VPWR sky130_fd_sc_hd__decap_3
XTAP_TAPCELL_ROW_110_1828 VGND VPWR sky130_fd_sc_hd__tapvpwrvgnd_1
XTAP_TAPCELL_ROW_110_1839 VGND VPWR sky130_fd_sc_hd__tapvpwrvgnd_1
XTAP_TAPCELL_ROW_56_1071 VGND VPWR sky130_fd_sc_hd__tapvpwrvgnd_1
XTAP_TAPCELL_ROW_56_1082 VGND VPWR sky130_fd_sc_hd__tapvpwrvgnd_1
X_4140_ _8734_/Q _7509_/Q _4140_/S VGND VGND VPWR VPWR _4141_/B sky130_fd_sc_hd__mux2_2
XFILLER_110_511 VGND VGND VPWR VPWR sky130_fd_sc_hd__decap_3
XFILLER_110_533 VGND VGND VPWR VPWR sky130_fd_sc_hd__decap_3
XFILLER_110_555 VGND VGND VPWR VPWR sky130_fd_sc_hd__decap_3
X_4071_ _4335_/A _4071_/B VGND VGND VPWR VPWR _4071_/X sky130_fd_sc_hd__or2_2
XFILLER_49_694 VGND VGND VPWR VPWR sky130_fd_sc_hd__decap_3
XFILLER_95_299 VGND VGND VPWR VPWR sky130_fd_sc_hd__fill_2
XFILLER_48_182 VGND VGND VPWR VPWR sky130_fd_sc_hd__decap_3
XFILLER_64_642 VGND VGND VPWR VPWR sky130_fd_sc_hd__fill_2
X_7830_ _8724_/CLK _7830_/D load_slew503/X VGND VGND VPWR VPWR _7830_/Q sky130_fd_sc_hd__dfrtp_2
XFILLER_36_377 VGND VGND VPWR VPWR sky130_fd_sc_hd__fill_1
XFILLER_91_461 VGND VGND VPWR VPWR sky130_fd_sc_hd__fill_2
XFILLER_91_472 VGND VGND VPWR VPWR sky130_fd_sc_hd__decap_3
XTAP_TAPCELL_ROW_19_553 VGND VPWR sky130_fd_sc_hd__tapvpwrvgnd_1
XTAP_TAPCELL_ROW_19_564 VGND VPWR sky130_fd_sc_hd__tapvpwrvgnd_1
X_7761_ _7923_/CLK _7761_/D wire618/X VGND VGND VPWR VPWR _7761_/Q sky130_fd_sc_hd__dfrtp_2
X_4973_ _4973_/A VGND VGND VPWR VPWR _4973_/X sky130_fd_sc_hd__buf_1
XPHY_EDGE_ROW_127_Left_263 VGND VGND VPWR VPWR sky130_fd_sc_hd__decap_3
X_3924_ _8066_/Q _8147_/Q _8228_/Q _8309_/Q _3973_/S _3993_/A VGND VGND VPWR VPWR
+ _3925_/B sky130_fd_sc_hd__mux4_2
X_7692_ _8593_/CLK _7692_/D load_slew712/X VGND VGND VPWR VPWR _7692_/Q sky130_fd_sc_hd__dfrtp_2
X_6712_ _6712_/A VGND VGND VPWR VPWR _8401_/D sky130_fd_sc_hd__buf_2
X_6643_ _6643_/A VGND VGND VPWR VPWR _8370_/D sky130_fd_sc_hd__buf_2
X_3855_ _7727_/Q _7808_/Q _7889_/Q _7970_/Q _3814_/S _3862_/A VGND VGND VPWR VPWR
+ _3855_/X sky130_fd_sc_hd__mux4_2
Xclkload9 clkload9/A VGND VGND VPWR VPWR clkload9/X sky130_fd_sc_hd__clkbuf_8
XFILLER_118_611 VGND VGND VPWR VPWR sky130_fd_sc_hd__decap_3
X_3786_ _3890_/A VGND VGND VPWR VPWR _3839_/S sky130_fd_sc_hd__clkbuf_2
Xclkbuf_leaf_64_CLK clkload9/A VGND VGND VPWR VPWR _8019_/CLK sky130_fd_sc_hd__clkbuf_8
X_6574_ _6574_/A VGND VGND VPWR VPWR _8337_/D sky130_fd_sc_hd__buf_2
X_8313_ _8638_/CLK _8313_/D fanout583/X VGND VGND VPWR VPWR _8313_/Q sky130_fd_sc_hd__dfrtp_2
X_5525_ _5525_/A VGND VGND VPWR VPWR _7808_/D sky130_fd_sc_hd__buf_1
XFILLER_118_688 VGND VGND VPWR VPWR sky130_fd_sc_hd__decap_3
XFILLER_133_603 VGND VGND VPWR VPWR sky130_fd_sc_hd__decap_3
X_8244_ _8658_/CLK _8244_/D load_slew529/X VGND VGND VPWR VPWR _8244_/Q sky130_fd_sc_hd__dfrtp_2
X_5456_ _5456_/A VGND VGND VPWR VPWR _7776_/D sky130_fd_sc_hd__buf_1
XFILLER_132_124 VGND VGND VPWR VPWR sky130_fd_sc_hd__decap_3
XFILLER_133_647 VGND VGND VPWR VPWR sky130_fd_sc_hd__decap_3
X_4407_ _4685_/A1 _4401_/X _4406_/X VGND VGND VPWR VPWR _4407_/X sky130_fd_sc_hd__o21a_2
XFILLER_132_168 VGND VGND VPWR VPWR sky130_fd_sc_hd__decap_3
X_8175_ _8662_/CLK _8175_/D load_slew621/X VGND VGND VPWR VPWR _8175_/Q sky130_fd_sc_hd__dfrtp_2
X_5387_ _5387_/A VGND VGND VPWR VPWR _7743_/D sky130_fd_sc_hd__buf_1
XFILLER_101_500 VGND VGND VPWR VPWR sky130_fd_sc_hd__decap_3
XFILLER_113_393 VGND VGND VPWR VPWR sky130_fd_sc_hd__decap_3
XFILLER_59_447 VGND VGND VPWR VPWR sky130_fd_sc_hd__fill_1
XFILLER_86_222 VGND VGND VPWR VPWR sky130_fd_sc_hd__fill_2
XFILLER_99_594 VGND VGND VPWR VPWR sky130_fd_sc_hd__decap_3
X_7126_ _4845_/X _8597_/Q _7130_/S VGND VGND VPWR VPWR _7127_/A sky130_fd_sc_hd__mux2_2
X_4338_ _8104_/Q _8185_/Q _4675_/S VGND VGND VPWR VPWR _4339_/B sky130_fd_sc_hd__mux2_2
XFILLER_115_57 VGND VGND VPWR VPWR sky130_fd_sc_hd__decap_3
XFILLER_59_458 VGND VGND VPWR VPWR sky130_fd_sc_hd__fill_2
Xfanout279 _4300_/A1 VGND VGND VPWR VPWR wire280/A sky130_fd_sc_hd__clkdlybuf4s25_1
X_7057_ _4707_/X _8564_/Q _7067_/S VGND VGND VPWR VPWR _7058_/A sky130_fd_sc_hd__mux2_2
X_4269_ _8422_/Q _8503_/Q _4305_/S VGND VGND VPWR VPWR _4269_/X sky130_fd_sc_hd__mux2_2
XFILLER_101_588 VGND VGND VPWR VPWR sky130_fd_sc_hd__decap_3
XFILLER_75_39 VGND VGND VPWR VPWR sky130_fd_sc_hd__decap_3
XTAP_TAPCELL_ROW_87_1510 VGND VPWR sky130_fd_sc_hd__tapvpwrvgnd_1
X_6008_ _6008_/A VGND VGND VPWR VPWR _8071_/D sky130_fd_sc_hd__buf_1
XFILLER_131_12 VGND VGND VPWR VPWR sky130_fd_sc_hd__decap_3
XFILLER_54_130 VGND VGND VPWR VPWR sky130_fd_sc_hd__fill_1
XFILLER_131_45 VGND VGND VPWR VPWR sky130_fd_sc_hd__decap_3
XFILLER_15_517 VGND VGND VPWR VPWR sky130_fd_sc_hd__fill_2
XFILLER_131_78 VGND VGND VPWR VPWR sky130_fd_sc_hd__decap_3
XFILLER_82_494 VGND VGND VPWR VPWR sky130_fd_sc_hd__fill_2
X_7959_ _8779_/CLK _7959_/D wire746/X VGND VGND VPWR VPWR _7959_/Q sky130_fd_sc_hd__dfrtp_2
XFILLER_24_21 VGND VGND VPWR VPWR sky130_fd_sc_hd__decap_3
XFILLER_24_32 VGND VGND VPWR VPWR sky130_fd_sc_hd__decap_3
XFILLER_42_358 VGND VGND VPWR VPWR sky130_fd_sc_hd__decap_3
XFILLER_23_561 VGND VGND VPWR VPWR sky130_fd_sc_hd__decap_3
XFILLER_24_65 VGND VGND VPWR VPWR sky130_fd_sc_hd__decap_3
XFILLER_11_756 VGND VGND VPWR VPWR sky130_fd_sc_hd__decap_3
XFILLER_23_594 VGND VGND VPWR VPWR sky130_fd_sc_hd__decap_3
Xwire603 wire603/A VGND VGND VPWR VPWR wire603/X sky130_fd_sc_hd__clkbuf_4
XFILLER_10_277 VGND VGND VPWR VPWR sky130_fd_sc_hd__decap_3
XFILLER_7_727 VGND VGND VPWR VPWR sky130_fd_sc_hd__fill_1
XFILLER_7_738 VGND VGND VPWR VPWR sky130_fd_sc_hd__decap_3
Xclkbuf_leaf_55_CLK clkbuf_leaf_89_CLK/A VGND VGND VPWR VPWR _8754_/CLK sky130_fd_sc_hd__clkbuf_8
XFILLER_108_132 VGND VGND VPWR VPWR sky130_fd_sc_hd__decap_3
XFILLER_6_259 VGND VGND VPWR VPWR sky130_fd_sc_hd__decap_3
XTAP_TAPCELL_ROW_98_1661 VGND VPWR sky130_fd_sc_hd__tapvpwrvgnd_1
Xwire669 wire669/A VGND VGND VPWR VPWR wire669/X sky130_fd_sc_hd__clkbuf_4
XFILLER_109_688 VGND VGND VPWR VPWR sky130_fd_sc_hd__decap_3
XFILLER_123_113 VGND VGND VPWR VPWR sky130_fd_sc_hd__decap_3
XFILLER_124_669 VGND VGND VPWR VPWR sky130_fd_sc_hd__decap_3
XFILLER_2_421 VGND VGND VPWR VPWR sky130_fd_sc_hd__fill_1
Xload_slew608 fanout607/X VGND VGND VPWR VPWR load_slew608/X sky130_fd_sc_hd__buf_4
XFILLER_49_51 VGND VGND VPWR VPWR sky130_fd_sc_hd__decap_3
XFILLER_131_190 VGND VGND VPWR VPWR sky130_fd_sc_hd__decap_3
XFILLER_77_233 VGND VGND VPWR VPWR sky130_fd_sc_hd__decap_3
XFILLER_1_36 VGND VGND VPWR VPWR sky130_fd_sc_hd__decap_3
XFILLER_77_288 VGND VGND VPWR VPWR sky130_fd_sc_hd__fill_2
XFILLER_93_748 VGND VGND VPWR VPWR sky130_fd_sc_hd__decap_3
XFILLER_1_69 VGND VGND VPWR VPWR sky130_fd_sc_hd__decap_3
XFILLER_46_631 VGND VGND VPWR VPWR sky130_fd_sc_hd__decap_3
XFILLER_58_480 VGND VGND VPWR VPWR sky130_fd_sc_hd__fill_2
XFILLER_65_50 VGND VGND VPWR VPWR sky130_fd_sc_hd__decap_3
XTAP_TAPCELL_ROW_125_2046 VGND VPWR sky130_fd_sc_hd__tapvpwrvgnd_1
Xclkbuf_5_9__f_CLK clkbuf_4_4_0_CLK/X VGND VGND VPWR VPWR clkbuf_5_9__f_CLK/X sky130_fd_sc_hd__clkbuf_16
XFILLER_60_100 VGND VGND VPWR VPWR sky130_fd_sc_hd__decap_3
XTAP_TAPCELL_ROW_16_512 VGND VPWR sky130_fd_sc_hd__tapvpwrvgnd_1
XTAP_TAPCELL_ROW_16_523 VGND VPWR sky130_fd_sc_hd__tapvpwrvgnd_1
XFILLER_60_144 VGND VGND VPWR VPWR sky130_fd_sc_hd__decap_3
XTAP_TAPCELL_ROW_107_1790 VGND VPWR sky130_fd_sc_hd__tapvpwrvgnd_1
XFILLER_14_572 VGND VGND VPWR VPWR sky130_fd_sc_hd__decap_3
XFILLER_61_689 VGND VGND VPWR VPWR sky130_fd_sc_hd__decap_3
XFILLER_81_60 VGND VGND VPWR VPWR sky130_fd_sc_hd__decap_3
XFILLER_41_391 VGND VGND VPWR VPWR sky130_fd_sc_hd__fill_1
Xclkbuf_leaf_46_CLK clkload5/A VGND VGND VPWR VPWR _8634_/CLK sky130_fd_sc_hd__clkbuf_8
XFILLER_127_452 VGND VGND VPWR VPWR sky130_fd_sc_hd__decap_3
XTAP_TAPCELL_ROW_58_1100 VGND VPWR sky130_fd_sc_hd__tapvpwrvgnd_1
XFILLER_115_614 VGND VGND VPWR VPWR sky130_fd_sc_hd__fill_2
XFILLER_127_485 VGND VGND VPWR VPWR sky130_fd_sc_hd__decap_3
XFILLER_53_3 VGND VGND VPWR VPWR sky130_fd_sc_hd__decap_3
XFILLER_6_760 VGND VGND VPWR VPWR sky130_fd_sc_hd__decap_3
XTAP_TAPCELL_ROW_58_1111 VGND VPWR sky130_fd_sc_hd__tapvpwrvgnd_1
X_6290_ _6290_/A VGND VGND VPWR VPWR _8204_/D sky130_fd_sc_hd__buf_6
X_5310_ _7708_/Q _4895_/X _5310_/S VGND VGND VPWR VPWR _5311_/A sky130_fd_sc_hd__mux2_2
XFILLER_5_281 VGND VGND VPWR VPWR sky130_fd_sc_hd__decap_3
XFILLER_6_793 VGND VGND VPWR VPWR sky130_fd_sc_hd__decap_3
XFILLER_114_157 VGND VGND VPWR VPWR sky130_fd_sc_hd__decap_3
X_5241_ _7675_/Q _4757_/X _5247_/S VGND VGND VPWR VPWR _5242_/A sky130_fd_sc_hd__mux2_2
XFILLER_130_628 VGND VGND VPWR VPWR sky130_fd_sc_hd__decap_3
XFILLER_96_531 VGND VGND VPWR VPWR sky130_fd_sc_hd__fill_1
X_5172_ _7642_/Q _4961_/X _5184_/S VGND VGND VPWR VPWR _5173_/A sky130_fd_sc_hd__mux2_2
X_4123_ _7751_/Q _7832_/Q _7913_/Q _7994_/Q _4124_/S _4125_/A VGND VGND VPWR VPWR
+ _4123_/X sky130_fd_sc_hd__mux4_2
XFILLER_110_385 VGND VGND VPWR VPWR sky130_fd_sc_hd__fill_2
XFILLER_28_119 VGND VGND VPWR VPWR sky130_fd_sc_hd__decap_3
XFILLER_56_439 VGND VGND VPWR VPWR sky130_fd_sc_hd__fill_1
XFILLER_68_277 VGND VGND VPWR VPWR sky130_fd_sc_hd__fill_2
Xinput2 ren VGND VGND VPWR VPWR input2/X sky130_fd_sc_hd__clkdlybuf4s25_1
X_4054_ _7744_/Q _7825_/Q _7906_/Q _7987_/Q _4098_/S0 _4036_/A VGND VGND VPWR VPWR
+ _4055_/B sky130_fd_sc_hd__mux4_2
XFILLER_83_225 VGND VGND VPWR VPWR sky130_fd_sc_hd__fill_1
XFILLER_37_653 VGND VGND VPWR VPWR sky130_fd_sc_hd__decap_3
XTAP_TAPCELL_ROW_69_1262 VGND VPWR sky130_fd_sc_hd__tapvpwrvgnd_1
XFILLER_24_325 VGND VGND VPWR VPWR sky130_fd_sc_hd__decap_3
XFILLER_36_185 VGND VGND VPWR VPWR sky130_fd_sc_hd__decap_3
XFILLER_51_100 VGND VGND VPWR VPWR sky130_fd_sc_hd__decap_3
XFILLER_52_623 VGND VGND VPWR VPWR sky130_fd_sc_hd__decap_3
X_8793_ _8793_/CLK _8793_/D fanout643/X VGND VGND VPWR VPWR _8793_/Q sky130_fd_sc_hd__dfrtp_2
X_7813_ _8477_/CLK _7813_/D wire603/X VGND VGND VPWR VPWR _7813_/Q sky130_fd_sc_hd__dfrtp_2
XFILLER_51_122 VGND VGND VPWR VPWR sky130_fd_sc_hd__decap_3
XTAP_TAPCELL_ROW_82_1440 VGND VPWR sky130_fd_sc_hd__tapvpwrvgnd_1
X_7744_ _8649_/CLK _7744_/D fanout500/X VGND VGND VPWR VPWR _7744_/Q sky130_fd_sc_hd__dfrtp_2
XFILLER_51_188 VGND VGND VPWR VPWR sky130_fd_sc_hd__decap_3
X_4956_ _4956_/A _4984_/B VGND VGND VPWR VPWR _4957_/A sky130_fd_sc_hd__and2_2
XFILLER_20_531 VGND VGND VPWR VPWR sky130_fd_sc_hd__fill_1
X_3907_ _8551_/Q _4652_/B1 _3906_/X _3910_/A _3988_/A VGND VGND VPWR VPWR _3907_/X
+ sky130_fd_sc_hd__o221a_2
X_7675_ _8739_/CLK _7675_/D fanout508/X VGND VGND VPWR VPWR _7675_/Q sky130_fd_sc_hd__dfrtp_2
X_4887_ _4887_/A VGND VGND VPWR VPWR _4887_/X sky130_fd_sc_hd__buf_1
XFILLER_124_9 VGND VGND VPWR VPWR sky130_fd_sc_hd__decap_3
X_3838_ _8707_/Q _8788_/Q _7563_/Q _7644_/Q _3838_/S0 _3869_/A VGND VGND VPWR VPWR
+ _3838_/X sky130_fd_sc_hd__mux4_2
Xclkbuf_leaf_37_CLK clkload3/A VGND VGND VPWR VPWR _8766_/CLK sky130_fd_sc_hd__clkbuf_8
X_6626_ _6626_/A VGND VGND VPWR VPWR _8362_/D sky130_fd_sc_hd__buf_2
X_6557_ _6557_/A VGND VGND VPWR VPWR _8329_/D sky130_fd_sc_hd__buf_2
XFILLER_10_12 VGND VGND VPWR VPWR sky130_fd_sc_hd__decap_3
XFILLER_118_474 VGND VGND VPWR VPWR sky130_fd_sc_hd__fill_2
XFILLER_3_218 VGND VGND VPWR VPWR sky130_fd_sc_hd__decap_3
XFILLER_4_719 VGND VGND VPWR VPWR sky130_fd_sc_hd__decap_3
X_3769_ _3880_/A VGND VGND VPWR VPWR _3769_/X sky130_fd_sc_hd__clkbuf_2
X_5508_ _5508_/A VGND VGND VPWR VPWR _5677_/S sky130_fd_sc_hd__clkbuf_2
XFILLER_126_12 VGND VGND VPWR VPWR sky130_fd_sc_hd__decap_3
XFILLER_133_411 VGND VGND VPWR VPWR sky130_fd_sc_hd__decap_3
XFILLER_133_444 VGND VGND VPWR VPWR sky130_fd_sc_hd__decap_3
X_6488_ _6656_/S VGND VGND VPWR VPWR _6507_/S sky130_fd_sc_hd__buf_6
XFILLER_10_56 VGND VGND VPWR VPWR sky130_fd_sc_hd__decap_3
XFILLER_121_617 VGND VGND VPWR VPWR sky130_fd_sc_hd__fill_2
XFILLER_133_455 VGND VGND VPWR VPWR sky130_fd_sc_hd__decap_3
X_8227_ _8794_/CLK _8227_/D load_slew579/X VGND VGND VPWR VPWR _8227_/Q sky130_fd_sc_hd__dfrtp_2
X_5439_ _5439_/A VGND VGND VPWR VPWR _7768_/D sky130_fd_sc_hd__buf_1
XFILLER_121_628 VGND VGND VPWR VPWR sky130_fd_sc_hd__decap_3
XFILLER_126_56 VGND VGND VPWR VPWR sky130_fd_sc_hd__decap_3
XFILLER_133_488 VGND VGND VPWR VPWR sky130_fd_sc_hd__decap_3
XFILLER_86_38 VGND VGND VPWR VPWR sky130_fd_sc_hd__decap_3
XTAP_TAPCELL_ROW_93_1591 VGND VPWR sky130_fd_sc_hd__tapvpwrvgnd_1
X_8158_ _8648_/CLK _8158_/D load_slew489/X VGND VGND VPWR VPWR _8158_/Q sky130_fd_sc_hd__dfrtp_2
XFILLER_19_21 VGND VGND VPWR VPWR sky130_fd_sc_hd__decap_3
XFILLER_87_564 VGND VGND VPWR VPWR sky130_fd_sc_hd__fill_1
X_7109_ _4811_/X _7109_/A1 _7109_/S VGND VGND VPWR VPWR _7110_/A sky130_fd_sc_hd__mux2_1
XFILLER_101_352 VGND VGND VPWR VPWR sky130_fd_sc_hd__decap_3
XFILLER_19_54 VGND VGND VPWR VPWR sky130_fd_sc_hd__fill_2
XFILLER_59_266 VGND VGND VPWR VPWR sky130_fd_sc_hd__decap_3
XFILLER_74_203 VGND VGND VPWR VPWR sky130_fd_sc_hd__decap_3
XFILLER_75_726 VGND VGND VPWR VPWR sky130_fd_sc_hd__fill_2
XFILLER_87_586 VGND VGND VPWR VPWR sky130_fd_sc_hd__decap_3
X_8089_ _8737_/CLK _8089_/D wire519/X VGND VGND VPWR VPWR _8089_/Q sky130_fd_sc_hd__dfrtp_2
XFILLER_19_87 VGND VGND VPWR VPWR sky130_fd_sc_hd__fill_1
XFILLER_74_225 VGND VGND VPWR VPWR sky130_fd_sc_hd__fill_1
XFILLER_27_130 VGND VGND VPWR VPWR sky130_fd_sc_hd__decap_3
XFILLER_28_653 VGND VGND VPWR VPWR sky130_fd_sc_hd__decap_3
XFILLER_90_707 VGND VGND VPWR VPWR sky130_fd_sc_hd__fill_1
XFILLER_90_729 VGND VGND VPWR VPWR sky130_fd_sc_hd__fill_1
XFILLER_27_163 VGND VGND VPWR VPWR sky130_fd_sc_hd__decap_3
XFILLER_28_686 VGND VGND VPWR VPWR sky130_fd_sc_hd__decap_3
XFILLER_42_144 VGND VGND VPWR VPWR sky130_fd_sc_hd__decap_3
XFILLER_70_442 VGND VGND VPWR VPWR sky130_fd_sc_hd__decap_3
XFILLER_70_486 VGND VGND VPWR VPWR sky130_fd_sc_hd__decap_3
XFILLER_129_706 VGND VGND VPWR VPWR sky130_fd_sc_hd__decap_3
XFILLER_23_391 VGND VGND VPWR VPWR sky130_fd_sc_hd__fill_1
XFILLER_11_564 VGND VGND VPWR VPWR sky130_fd_sc_hd__decap_3
XFILLER_11_575 VGND VGND VPWR VPWR sky130_fd_sc_hd__decap_3
XFILLER_128_227 VGND VGND VPWR VPWR sky130_fd_sc_hd__decap_3
XTAP_TAPCELL_ROW_41_868 VGND VPWR sky130_fd_sc_hd__tapvpwrvgnd_1
Xclkbuf_leaf_28_CLK clkbuf_leaf_35_CLK/A VGND VGND VPWR VPWR _8769_/CLK sky130_fd_sc_hd__clkbuf_8
XFILLER_11_586 VGND VGND VPWR VPWR sky130_fd_sc_hd__decap_3
XTAP_TAPCELL_ROW_21_581 VGND VPWR sky130_fd_sc_hd__tapvpwrvgnd_1
XTAP_TAPCELL_ROW_21_592 VGND VPWR sky130_fd_sc_hd__tapvpwrvgnd_1
XFILLER_124_433 VGND VGND VPWR VPWR sky130_fd_sc_hd__decap_3
XFILLER_124_477 VGND VGND VPWR VPWR sky130_fd_sc_hd__decap_3
XFILLER_3_741 VGND VGND VPWR VPWR sky130_fd_sc_hd__decap_3
XFILLER_105_691 VGND VGND VPWR VPWR sky130_fd_sc_hd__decap_3
XFILLER_3_774 VGND VGND VPWR VPWR sky130_fd_sc_hd__decap_3
XFILLER_3_785 VGND VGND VPWR VPWR sky130_fd_sc_hd__decap_3
XTAP_TAPCELL_ROW_53_1030 VGND VPWR sky130_fd_sc_hd__tapvpwrvgnd_1
Xload_slew438 _4302_/S VGND VGND VPWR VPWR _4266_/S sky130_fd_sc_hd__clkbuf_4
Xload_slew416 _3716_/A VGND VGND VPWR VPWR _3719_/C sky130_fd_sc_hd__clkbuf_4
XFILLER_104_190 VGND VGND VPWR VPWR sky130_fd_sc_hd__decap_3
XFILLER_66_704 VGND VGND VPWR VPWR sky130_fd_sc_hd__decap_3
XFILLER_78_531 VGND VGND VPWR VPWR sky130_fd_sc_hd__fill_1
XFILLER_78_564 VGND VGND VPWR VPWR sky130_fd_sc_hd__decap_3
XTAP_TAPCELL_ROW_53_1041 VGND VPWR sky130_fd_sc_hd__tapvpwrvgnd_1
XFILLER_38_406 VGND VGND VPWR VPWR sky130_fd_sc_hd__decap_3
XFILLER_18_6 VGND VGND VPWR VPWR sky130_fd_sc_hd__decap_3
XFILLER_19_620 VGND VGND VPWR VPWR sky130_fd_sc_hd__decap_3
XFILLER_76_82 VGND VGND VPWR VPWR sky130_fd_sc_hd__fill_2
XFILLER_18_141 VGND VGND VPWR VPWR sky130_fd_sc_hd__decap_3
XFILLER_34_601 VGND VGND VPWR VPWR sky130_fd_sc_hd__decap_3
XFILLER_65_269 VGND VGND VPWR VPWR sky130_fd_sc_hd__fill_2
XFILLER_81_718 VGND VGND VPWR VPWR sky130_fd_sc_hd__fill_1
XFILLER_81_729 VGND VGND VPWR VPWR sky130_fd_sc_hd__fill_1
XFILLER_93_567 VGND VGND VPWR VPWR sky130_fd_sc_hd__fill_2
XTAP_TAPCELL_ROW_49_979 VGND VPWR sky130_fd_sc_hd__tapvpwrvgnd_1
XFILLER_18_163 VGND VGND VPWR VPWR sky130_fd_sc_hd__decap_3
XFILLER_18_185 VGND VGND VPWR VPWR sky130_fd_sc_hd__decap_3
XFILLER_34_623 VGND VGND VPWR VPWR sky130_fd_sc_hd__fill_2
XFILLER_34_634 VGND VGND VPWR VPWR sky130_fd_sc_hd__decap_3
XFILLER_33_122 VGND VGND VPWR VPWR sky130_fd_sc_hd__decap_3
XFILLER_34_645 VGND VGND VPWR VPWR sky130_fd_sc_hd__decap_3
XFILLER_92_70 VGND VGND VPWR VPWR sky130_fd_sc_hd__decap_3
XTAP_TAPCELL_ROW_29_692 VGND VPWR sky130_fd_sc_hd__tapvpwrvgnd_1
X_4810_ _4810_/A _4810_/B VGND VGND VPWR VPWR _4811_/A sky130_fd_sc_hd__and2_2
XFILLER_33_177 VGND VGND VPWR VPWR sky130_fd_sc_hd__decap_3
X_5790_ _5790_/A VGND VGND VPWR VPWR _7933_/D sky130_fd_sc_hd__buf_1
XFILLER_14_380 VGND VGND VPWR VPWR sky130_fd_sc_hd__decap_3
XTAP_TAPCELL_ROW_64_1192 VGND VPWR sky130_fd_sc_hd__tapvpwrvgnd_1
X_4741_ _7455_/A VGND VGND VPWR VPWR _4778_/S sky130_fd_sc_hd__buf_2
XFILLER_119_216 VGND VGND VPWR VPWR sky130_fd_sc_hd__decap_3
Xclkbuf_leaf_19_CLK clkbuf_leaf_52_CLK/A VGND VGND VPWR VPWR _8794_/CLK sky130_fd_sc_hd__clkbuf_8
X_7460_ _4961_/X _8786_/Q _7474_/S VGND VGND VPWR VPWR _7461_/A sky130_fd_sc_hd__mux2_2
X_4672_ _4670_/X _4671_/X _4672_/S VGND VGND VPWR VPWR _4672_/X sky130_fd_sc_hd__mux2_2
X_6411_ _4795_/X _6411_/A1 _6419_/S VGND VGND VPWR VPWR _6412_/A sky130_fd_sc_hd__mux2_1
XFILLER_128_772 VGND VGND VPWR VPWR sky130_fd_sc_hd__decap_3
X_7391_ _8753_/Q _4818_/A _7407_/S VGND VGND VPWR VPWR _7392_/A sky130_fd_sc_hd__mux2_2
XFILLER_127_293 VGND VGND VPWR VPWR sky130_fd_sc_hd__decap_3
Xmax_cap755 input1/X VGND VGND VPWR VPWR fanout754/A sky130_fd_sc_hd__clkbuf_2
X_6342_ _4999_/X hold936/X _6356_/S VGND VGND VPWR VPWR _6343_/A sky130_fd_sc_hd__mux2_1
XFILLER_88_306 VGND VGND VPWR VPWR sky130_fd_sc_hd__fill_2
X_6273_ _4861_/X _8196_/Q _6289_/S VGND VGND VPWR VPWR _6274_/A sky130_fd_sc_hd__mux2_4
XFILLER_130_436 VGND VGND VPWR VPWR sky130_fd_sc_hd__decap_3
X_8012_ _8745_/CLK _8012_/D load_slew626/X VGND VGND VPWR VPWR _8012_/Q sky130_fd_sc_hd__dfrtp_2
X_5224_ _7667_/Q _4723_/X _5226_/S VGND VGND VPWR VPWR _5225_/A sky130_fd_sc_hd__mux2_2
XFILLER_130_469 VGND VGND VPWR VPWR sky130_fd_sc_hd__decap_3
XFILLER_69_531 VGND VGND VPWR VPWR sky130_fd_sc_hd__decap_3
XFILLER_69_553 VGND VGND VPWR VPWR sky130_fd_sc_hd__decap_3
XFILLER_29_406 VGND VGND VPWR VPWR sky130_fd_sc_hd__fill_1
XFILLER_84_501 VGND VGND VPWR VPWR sky130_fd_sc_hd__fill_2
XFILLER_84_512 VGND VGND VPWR VPWR sky130_fd_sc_hd__decap_3
X_5155_ _5155_/A VGND VGND VPWR VPWR _7635_/D sky130_fd_sc_hd__buf_1
XFILLER_57_759 VGND VGND VPWR VPWR sky130_fd_sc_hd__decap_3
X_5086_ _5086_/A VGND VGND VPWR VPWR _7602_/D sky130_fd_sc_hd__buf_1
X_4106_ _7749_/Q _7830_/Q _7911_/Q _7992_/Q _4106_/S0 _4106_/S1 VGND VGND VPWR VPWR
+ _4106_/X sky130_fd_sc_hd__mux4_2
XFILLER_84_578 VGND VGND VPWR VPWR sky130_fd_sc_hd__fill_1
X_4037_ _7661_/Q _3921_/X _4622_/B1 _7580_/Q _4120_/A VGND VGND VPWR VPWR _4037_/X
+ sky130_fd_sc_hd__o221a_2
XFILLER_25_612 VGND VGND VPWR VPWR sky130_fd_sc_hd__decap_3
XFILLER_25_634 VGND VGND VPWR VPWR sky130_fd_sc_hd__fill_1
XFILLER_71_239 VGND VGND VPWR VPWR sky130_fd_sc_hd__decap_3
XFILLER_24_144 VGND VGND VPWR VPWR sky130_fd_sc_hd__decap_3
XFILLER_25_689 VGND VGND VPWR VPWR sky130_fd_sc_hd__decap_3
XFILLER_40_604 VGND VGND VPWR VPWR sky130_fd_sc_hd__decap_3
X_8776_ _8776_/CLK _8776_/D fanout732/A VGND VGND VPWR VPWR _8776_/Q sky130_fd_sc_hd__dfrtp_2
Xclkbuf_4_13_0_CLK clkbuf_0_CLK/X VGND VGND VPWR VPWR clkbuf_4_13_0_CLK/X sky130_fd_sc_hd__clkbuf_8
X_5988_ _5988_/A0 _4980_/A _5990_/S VGND VGND VPWR VPWR _5989_/A sky130_fd_sc_hd__mux2_2
XFILLER_40_659 VGND VGND VPWR VPWR sky130_fd_sc_hd__fill_1
X_7727_ _8627_/CLK _7727_/D load_slew671/X VGND VGND VPWR VPWR _7727_/Q sky130_fd_sc_hd__dfrtp_2
X_4939_ _4939_/A VGND VGND VPWR VPWR _7556_/D sky130_fd_sc_hd__buf_1
X_7658_ _8802_/CLK _7658_/D load_slew587/X VGND VGND VPWR VPWR _7658_/Q sky130_fd_sc_hd__dfrtp_2
X_6609_ _6609_/A VGND VGND VPWR VPWR _8354_/D sky130_fd_sc_hd__buf_2
XFILLER_21_33 VGND VGND VPWR VPWR sky130_fd_sc_hd__decap_3
XFILLER_4_516 VGND VGND VPWR VPWR sky130_fd_sc_hd__fill_1
XTAP_TAPCELL_ROW_95_1620 VGND VPWR sky130_fd_sc_hd__tapvpwrvgnd_1
X_7589_ _8730_/CLK _7589_/D load_slew486/X VGND VGND VPWR VPWR _7589_/Q sky130_fd_sc_hd__dfrtp_2
XFILLER_106_411 VGND VGND VPWR VPWR sky130_fd_sc_hd__decap_3
XFILLER_134_731 VGND VGND VPWR VPWR sky130_fd_sc_hd__decap_3
XFILLER_21_66 VGND VGND VPWR VPWR sky130_fd_sc_hd__decap_3
XFILLER_133_252 VGND VGND VPWR VPWR sky130_fd_sc_hd__decap_3
XFILLER_134_775 VGND VGND VPWR VPWR sky130_fd_sc_hd__decap_3
XFILLER_79_306 VGND VGND VPWR VPWR sky130_fd_sc_hd__decap_3
XFILLER_0_722 VGND VGND VPWR VPWR sky130_fd_sc_hd__decap_3
XFILLER_106_477 VGND VGND VPWR VPWR sky130_fd_sc_hd__decap_3
XFILLER_79_328 VGND VGND VPWR VPWR sky130_fd_sc_hd__decap_3
XFILLER_0_744 VGND VGND VPWR VPWR sky130_fd_sc_hd__decap_3
XFILLER_121_469 VGND VGND VPWR VPWR sky130_fd_sc_hd__decap_3
XFILLER_133_296 VGND VGND VPWR VPWR sky130_fd_sc_hd__decap_3
XFILLER_0_766 VGND VGND VPWR VPWR sky130_fd_sc_hd__decap_3
XFILLER_0_788 VGND VGND VPWR VPWR sky130_fd_sc_hd__decap_3
XFILLER_102_683 VGND VGND VPWR VPWR sky130_fd_sc_hd__fill_2
XTAP_TAPCELL_ROW_7_387 VGND VPWR sky130_fd_sc_hd__tapvpwrvgnd_1
XFILLER_47_214 VGND VGND VPWR VPWR sky130_fd_sc_hd__fill_1
XFILLER_46_41 VGND VGND VPWR VPWR sky130_fd_sc_hd__decap_3
XFILLER_63_729 VGND VGND VPWR VPWR sky130_fd_sc_hd__decap_3
XTAP_TAPCELL_ROW_122_2005 VGND VPWR sky130_fd_sc_hd__tapvpwrvgnd_1
XFILLER_16_601 VGND VGND VPWR VPWR sky130_fd_sc_hd__decap_3
XFILLER_28_494 VGND VGND VPWR VPWR sky130_fd_sc_hd__decap_3
XTAP_TAPCELL_ROW_46_938 VGND VPWR sky130_fd_sc_hd__tapvpwrvgnd_1
XFILLER_15_122 VGND VGND VPWR VPWR sky130_fd_sc_hd__decap_3
XFILLER_102_80 VGND VGND VPWR VPWR sky130_fd_sc_hd__decap_3
XFILLER_15_177 VGND VGND VPWR VPWR sky130_fd_sc_hd__decap_3
XFILLER_16_678 VGND VGND VPWR VPWR sky130_fd_sc_hd__fill_1
XTAP_TAPCELL_ROW_26_651 VGND VPWR sky130_fd_sc_hd__tapvpwrvgnd_1
XTAP_TAPCELL_ROW_26_662 VGND VPWR sky130_fd_sc_hd__tapvpwrvgnd_1
XFILLER_15_199 VGND VGND VPWR VPWR sky130_fd_sc_hd__decap_3
XFILLER_129_503 VGND VGND VPWR VPWR sky130_fd_sc_hd__fill_1
XFILLER_129_514 VGND VGND VPWR VPWR sky130_fd_sc_hd__decap_3
XFILLER_30_169 VGND VGND VPWR VPWR sky130_fd_sc_hd__decap_3
XFILLER_11_383 VGND VGND VPWR VPWR sky130_fd_sc_hd__decap_3
XFILLER_129_547 VGND VGND VPWR VPWR sky130_fd_sc_hd__decap_3
XFILLER_7_24 VGND VGND VPWR VPWR sky130_fd_sc_hd__decap_3
XFILLER_7_57 VGND VGND VPWR VPWR sky130_fd_sc_hd__decap_3
XFILLER_125_720 VGND VGND VPWR VPWR sky130_fd_sc_hd__decap_3
XTAP_TAPCELL_ROW_133_2156 VGND VPWR sky130_fd_sc_hd__tapvpwrvgnd_1
XFILLER_125_797 VGND VGND VPWR VPWR sky130_fd_sc_hd__decap_3
XFILLER_98_648 VGND VGND VPWR VPWR sky130_fd_sc_hd__decap_3
XFILLER_78_361 VGND VGND VPWR VPWR sky130_fd_sc_hd__decap_3
XFILLER_87_92 VGND VGND VPWR VPWR sky130_fd_sc_hd__fill_1
XFILLER_97_169 VGND VGND VPWR VPWR sky130_fd_sc_hd__decap_3
XFILLER_16_3 VGND VGND VPWR VPWR sky130_fd_sc_hd__decap_3
Xclkbuf_leaf_8_CLK clkbuf_leaf_8_CLK/A VGND VGND VPWR VPWR _8724_/CLK sky130_fd_sc_hd__clkbuf_8
XFILLER_54_729 VGND VGND VPWR VPWR sky130_fd_sc_hd__decap_3
XFILLER_66_589 VGND VGND VPWR VPWR sky130_fd_sc_hd__decap_3
X_6960_ _7002_/S VGND VGND VPWR VPWR _6979_/S sky130_fd_sc_hd__buf_6
XFILLER_53_228 VGND VGND VPWR VPWR sky130_fd_sc_hd__decap_3
XFILLER_93_375 VGND VGND VPWR VPWR sky130_fd_sc_hd__decap_3
XTAP_TAPCELL_ROW_66_1210 VGND VPWR sky130_fd_sc_hd__tapvpwrvgnd_1
XTAP_TAPCELL_ROW_66_1221 VGND VPWR sky130_fd_sc_hd__tapvpwrvgnd_1
X_5911_ _5919_/A1 _5919_/A2 _4777_/X _5919_/B1 hold832/X VGND VGND VPWR VPWR _8004_/D
+ sky130_fd_sc_hd__a32o_2
X_6891_ _4719_/X _8486_/Q _6895_/S VGND VGND VPWR VPWR _6892_/A sky130_fd_sc_hd__mux2_4
X_8630_ _8747_/CLK _8630_/D fanout634/X VGND VGND VPWR VPWR _8630_/Q sky130_fd_sc_hd__dfrtp_2
X_5842_ _5842_/A VGND VGND VPWR VPWR _7958_/D sky130_fd_sc_hd__buf_1
XFILLER_22_648 VGND VGND VPWR VPWR sky130_fd_sc_hd__decap_3
X_8561_ _8648_/CLK _8561_/D fanout488/X VGND VGND VPWR VPWR _8561_/Q sky130_fd_sc_hd__dfrtp_2
X_5773_ _5773_/A VGND VGND VPWR VPWR _7925_/D sky130_fd_sc_hd__buf_1
XFILLER_21_169 VGND VGND VPWR VPWR sky130_fd_sc_hd__fill_2
X_7512_ _8739_/CLK _7512_/D load_slew511/X VGND VGND VPWR VPWR _7512_/Q sky130_fd_sc_hd__dfrtp_2
X_4724_ _4723_/X hold972/X _4736_/S VGND VGND VPWR VPWR _4725_/A sky130_fd_sc_hd__mux2_2
X_8492_ _8735_/CLK _8492_/D load_slew536/X VGND VGND VPWR VPWR _8492_/Q sky130_fd_sc_hd__dfrtp_2
XFILLER_135_517 VGND VGND VPWR VPWR sky130_fd_sc_hd__decap_3
X_7443_ _8778_/Q _4924_/A _7449_/S VGND VGND VPWR VPWR _7444_/A sky130_fd_sc_hd__mux2_2
X_4655_ _7798_/Q _7879_/Q _4662_/S VGND VGND VPWR VPWR _4655_/X sky130_fd_sc_hd__mux2_2
Xhold800 _8689_/Q VGND VGND VPWR VPWR hold800/X sky130_fd_sc_hd__dlygate4sd3_1
Xhold811 _8010_/Q VGND VGND VPWR VPWR hold811/X sky130_fd_sc_hd__dlygate4sd3_1
Xinput60 wdata[61] VGND VGND VPWR VPWR _4860_/A sky130_fd_sc_hd__clkdlybuf4s25_1
Xinput71 wdata[71] VGND VGND VPWR VPWR _4902_/A sky130_fd_sc_hd__clkdlybuf4s25_1
Xinput82 wdata[8] VGND VGND VPWR VPWR _4980_/A sky130_fd_sc_hd__clkdlybuf4s25_1
X_7374_ _8745_/Q _4786_/A _7386_/S VGND VGND VPWR VPWR _7375_/A sky130_fd_sc_hd__mux2_2
X_4586_ _7792_/Q _7873_/Q _7954_/Q _8035_/Q _4620_/S _4621_/A VGND VGND VPWR VPWR
+ _4586_/X sky130_fd_sc_hd__mux4_2
XTAP_TAPCELL_ROW_77_1372 VGND VPWR sky130_fd_sc_hd__tapvpwrvgnd_1
Xhold822 _8038_/Q VGND VGND VPWR VPWR hold822/X sky130_fd_sc_hd__dlygate4sd3_1
Xhold833 _8681_/Q VGND VGND VPWR VPWR hold833/X sky130_fd_sc_hd__dlygate4sd3_1
Xhold844 _8670_/Q VGND VGND VPWR VPWR hold844/X sky130_fd_sc_hd__dlygate4sd3_1
Xhold855 _8630_/Q VGND VGND VPWR VPWR hold855/X sky130_fd_sc_hd__dlygate4sd3_1
X_6325_ _4965_/X _6325_/A1 _6335_/S VGND VGND VPWR VPWR _6326_/A sky130_fd_sc_hd__mux2_1
XFILLER_103_414 VGND VGND VPWR VPWR sky130_fd_sc_hd__decap_3
XFILLER_130_200 VGND VGND VPWR VPWR sky130_fd_sc_hd__decap_3
XFILLER_131_712 VGND VGND VPWR VPWR sky130_fd_sc_hd__decap_3
XFILLER_89_615 VGND VGND VPWR VPWR sky130_fd_sc_hd__fill_1
Xhold866 _8684_/Q VGND VGND VPWR VPWR hold866/X sky130_fd_sc_hd__dlygate4sd3_1
Xhold877 _7977_/Q VGND VGND VPWR VPWR hold877/X sky130_fd_sc_hd__dlygate4sd3_1
Xhold888 _8009_/Q VGND VGND VPWR VPWR hold888/X sky130_fd_sc_hd__dlygate4sd3_1
XFILLER_103_447 VGND VGND VPWR VPWR sky130_fd_sc_hd__fill_1
XFILLER_130_233 VGND VGND VPWR VPWR sky130_fd_sc_hd__decap_3
XFILLER_131_756 VGND VGND VPWR VPWR sky130_fd_sc_hd__decap_3
XFILLER_89_659 VGND VGND VPWR VPWR sky130_fd_sc_hd__decap_3
XTAP_TAPCELL_ROW_90_1550 VGND VPWR sky130_fd_sc_hd__tapvpwrvgnd_1
Xhold899 _8639_/Q VGND VGND VPWR VPWR hold899/X sky130_fd_sc_hd__dlygate4sd3_1
X_6256_ _7248_/A2 _8188_/Q _6268_/S VGND VGND VPWR VPWR _6257_/A sky130_fd_sc_hd__mux2_4
XFILLER_29_203 VGND VGND VPWR VPWR sky130_fd_sc_hd__decap_3
XFILLER_76_309 VGND VGND VPWR VPWR sky130_fd_sc_hd__decap_3
X_6187_ _5031_/X _8155_/Q _6205_/S VGND VGND VPWR VPWR _6188_/A sky130_fd_sc_hd__mux2_4
X_5207_ _5291_/A VGND VGND VPWR VPWR _5226_/S sky130_fd_sc_hd__buf_2
XFILLER_130_299 VGND VGND VPWR VPWR sky130_fd_sc_hd__decap_3
XFILLER_29_225 VGND VGND VPWR VPWR sky130_fd_sc_hd__fill_1
XFILLER_96_180 VGND VGND VPWR VPWR sky130_fd_sc_hd__fill_2
XTAP_TAPCELL_ROW_4_346 VGND VPWR sky130_fd_sc_hd__tapvpwrvgnd_1
X_5138_ _5138_/A VGND VGND VPWR VPWR _7627_/D sky130_fd_sc_hd__buf_1
XFILLER_123_46 VGND VGND VPWR VPWR sky130_fd_sc_hd__decap_3
XFILLER_17_409 VGND VGND VPWR VPWR sky130_fd_sc_hd__fill_2
XFILLER_29_269 VGND VGND VPWR VPWR sky130_fd_sc_hd__decap_3
XFILLER_57_556 VGND VGND VPWR VPWR sky130_fd_sc_hd__fill_1
XFILLER_96_191 VGND VGND VPWR VPWR sky130_fd_sc_hd__decap_3
XFILLER_45_729 VGND VGND VPWR VPWR sky130_fd_sc_hd__decap_3
X_5069_ _5069_/A VGND VGND VPWR VPWR _7594_/D sky130_fd_sc_hd__buf_1
XFILLER_16_44 VGND VGND VPWR VPWR sky130_fd_sc_hd__decap_3
XFILLER_16_77 VGND VGND VPWR VPWR sky130_fd_sc_hd__decap_3
XFILLER_40_401 VGND VGND VPWR VPWR sky130_fd_sc_hd__decap_3
XFILLER_52_250 VGND VGND VPWR VPWR sky130_fd_sc_hd__fill_2
XFILLER_12_136 VGND VGND VPWR VPWR sky130_fd_sc_hd__decap_3
XFILLER_13_659 VGND VGND VPWR VPWR sky130_fd_sc_hd__fill_1
XFILLER_16_88 VGND VGND VPWR VPWR sky130_fd_sc_hd__fill_1
XFILLER_80_581 VGND VGND VPWR VPWR sky130_fd_sc_hd__decap_3
XFILLER_80_592 VGND VGND VPWR VPWR sky130_fd_sc_hd__decap_3
XTAP_TAPCELL_ROW_23_610 VGND VPWR sky130_fd_sc_hd__tapvpwrvgnd_1
XTAP_TAPCELL_ROW_23_621 VGND VPWR sky130_fd_sc_hd__tapvpwrvgnd_1
X_8759_ _8759_/CLK _8759_/D fanout708/X VGND VGND VPWR VPWR _8759_/Q sky130_fd_sc_hd__dfrtp_2
XFILLER_40_467 VGND VGND VPWR VPWR sky130_fd_sc_hd__decap_3
XFILLER_21_670 VGND VGND VPWR VPWR sky130_fd_sc_hd__fill_2
XFILLER_32_32 VGND VGND VPWR VPWR sky130_fd_sc_hd__decap_3
XFILLER_32_65 VGND VGND VPWR VPWR sky130_fd_sc_hd__fill_2
XFILLER_120_3 VGND VGND VPWR VPWR sky130_fd_sc_hd__decap_3
XFILLER_126_517 VGND VGND VPWR VPWR sky130_fd_sc_hd__decap_3
XFILLER_5_803 VGND VGND VPWR VPWR sky130_fd_sc_hd__fill_1
XFILLER_4_324 VGND VGND VPWR VPWR sky130_fd_sc_hd__decap_3
XFILLER_107_775 VGND VGND VPWR VPWR sky130_fd_sc_hd__decap_3
XFILLER_122_701 VGND VGND VPWR VPWR sky130_fd_sc_hd__decap_3
XFILLER_134_572 VGND VGND VPWR VPWR sky130_fd_sc_hd__decap_3
XFILLER_4_368 VGND VGND VPWR VPWR sky130_fd_sc_hd__decap_3
XFILLER_0_530 VGND VGND VPWR VPWR sky130_fd_sc_hd__fill_2
XFILLER_121_266 VGND VGND VPWR VPWR sky130_fd_sc_hd__decap_3
XFILLER_79_169 VGND VGND VPWR VPWR sky130_fd_sc_hd__decap_3
XFILLER_121_288 VGND VGND VPWR VPWR sky130_fd_sc_hd__decap_3
XFILLER_48_545 VGND VGND VPWR VPWR sky130_fd_sc_hd__decap_3
XFILLER_94_139 VGND VGND VPWR VPWR sky130_fd_sc_hd__fill_1
XFILLER_57_73 VGND VGND VPWR VPWR sky130_fd_sc_hd__decap_3
XFILLER_91_802 VGND VGND VPWR VPWR sky130_fd_sc_hd__fill_2
XFILLER_90_312 VGND VGND VPWR VPWR sky130_fd_sc_hd__decap_3
XFILLER_16_475 VGND VGND VPWR VPWR sky130_fd_sc_hd__fill_1
XFILLER_71_570 VGND VGND VPWR VPWR sky130_fd_sc_hd__fill_2
XFILLER_73_72 VGND VGND VPWR VPWR sky130_fd_sc_hd__fill_1
XTAP_TAPCELL_ROW_102_1719 VGND VPWR sky130_fd_sc_hd__tapvpwrvgnd_1
XFILLER_16_486 VGND VGND VPWR VPWR sky130_fd_sc_hd__decap_3
XFILLER_43_294 VGND VGND VPWR VPWR sky130_fd_sc_hd__fill_1
XFILLER_71_581 VGND VGND VPWR VPWR sky130_fd_sc_hd__decap_3
XFILLER_31_445 VGND VGND VPWR VPWR sky130_fd_sc_hd__decap_3
XFILLER_31_478 VGND VGND VPWR VPWR sky130_fd_sc_hd__decap_3
XTAP_TAPCELL_ROW_61_1140 VGND VPWR sky130_fd_sc_hd__tapvpwrvgnd_1
XTAP_TAPCELL_ROW_61_1151 VGND VPWR sky130_fd_sc_hd__tapvpwrvgnd_1
XFILLER_31_489 VGND VGND VPWR VPWR sky130_fd_sc_hd__decap_3
XFILLER_12_692 VGND VGND VPWR VPWR sky130_fd_sc_hd__fill_1
XFILLER_7_140 VGND VGND VPWR VPWR sky130_fd_sc_hd__decap_3
XFILLER_8_663 VGND VGND VPWR VPWR sky130_fd_sc_hd__decap_3
XFILLER_129_399 VGND VGND VPWR VPWR sky130_fd_sc_hd__decap_3
XFILLER_8_696 VGND VGND VPWR VPWR sky130_fd_sc_hd__decap_3
X_4440_ _4442_/A _4438_/X _4439_/X VGND VGND VPWR VPWR _4440_/X sky130_fd_sc_hd__o21a_2
XFILLER_125_550 VGND VGND VPWR VPWR sky130_fd_sc_hd__decap_3
XFILLER_112_200 VGND VGND VPWR VPWR sky130_fd_sc_hd__fill_2
XFILLER_125_561 VGND VGND VPWR VPWR sky130_fd_sc_hd__decap_3
XFILLER_98_80 VGND VGND VPWR VPWR sky130_fd_sc_hd__decap_3
X_6110_ _8120_/Q _4882_/A _6116_/S VGND VGND VPWR VPWR _6111_/A sky130_fd_sc_hd__mux2_2
X_4371_ _4365_/X _4370_/X _4393_/A VGND VGND VPWR VPWR _4372_/A sky130_fd_sc_hd__mux2_2
XFILLER_125_594 VGND VGND VPWR VPWR sky130_fd_sc_hd__decap_3
Xfanout609 fanout609/A VGND VGND VPWR VPWR fanout609/X sky130_fd_sc_hd__clkdlybuf4s25_1
X_7090_ _7174_/S VGND VGND VPWR VPWR _7109_/S sky130_fd_sc_hd__buf_4
XFILLER_112_244 VGND VGND VPWR VPWR sky130_fd_sc_hd__decap_3
XFILLER_39_501 VGND VGND VPWR VPWR sky130_fd_sc_hd__decap_3
XFILLER_58_309 VGND VGND VPWR VPWR sky130_fd_sc_hd__decap_3
X_6041_ _8087_/Q _4744_/A _6053_/S VGND VGND VPWR VPWR _6042_/A sky130_fd_sc_hd__mux2_2
XFILLER_112_288 VGND VGND VPWR VPWR sky130_fd_sc_hd__decap_3
XFILLER_39_545 VGND VGND VPWR VPWR sky130_fd_sc_hd__decap_3
XFILLER_39_567 VGND VGND VPWR VPWR sky130_fd_sc_hd__decap_3
XFILLER_78_191 VGND VGND VPWR VPWR sky130_fd_sc_hd__fill_1
XFILLER_94_651 VGND VGND VPWR VPWR sky130_fd_sc_hd__decap_3
XTAP_TAPCELL_ROW_1_305 VGND VPWR sky130_fd_sc_hd__tapvpwrvgnd_1
XFILLER_26_206 VGND VGND VPWR VPWR sky130_fd_sc_hd__decap_3
XFILLER_94_684 VGND VGND VPWR VPWR sky130_fd_sc_hd__decap_3
X_7992_ _8731_/CLK _7992_/D fanout497/X VGND VGND VPWR VPWR _7992_/Q sky130_fd_sc_hd__dfrtp_2
XFILLER_19_291 VGND VGND VPWR VPWR sky130_fd_sc_hd__decap_3
X_6943_ _6943_/A VGND VGND VPWR VPWR _8510_/D sky130_fd_sc_hd__buf_6
XFILLER_34_261 VGND VGND VPWR VPWR sky130_fd_sc_hd__decap_3
X_6874_ _5027_/X _8478_/Q _6874_/S VGND VGND VPWR VPWR _6875_/A sky130_fd_sc_hd__mux2_4
XFILLER_34_294 VGND VGND VPWR VPWR sky130_fd_sc_hd__decap_3
X_8613_ _8694_/CLK _8613_/D load_slew729/X VGND VGND VPWR VPWR _8613_/Q sky130_fd_sc_hd__dfrtp_2
X_5825_ _5825_/A VGND VGND VPWR VPWR _7950_/D sky130_fd_sc_hd__buf_1
XFILLER_50_754 VGND VGND VPWR VPWR sky130_fd_sc_hd__fill_2
XFILLER_22_489 VGND VGND VPWR VPWR sky130_fd_sc_hd__decap_3
XTAP_TAPCELL_ROW_79_1401 VGND VPWR sky130_fd_sc_hd__tapvpwrvgnd_1
X_8544_ _8786_/CLK _8544_/D load_slew667/X VGND VGND VPWR VPWR _8544_/Q sky130_fd_sc_hd__dfrtp_2
X_5756_ _5756_/A VGND VGND VPWR VPWR _7917_/D sky130_fd_sc_hd__buf_1
XFILLER_135_303 VGND VGND VPWR VPWR sky130_fd_sc_hd__decap_3
X_8475_ _8719_/CLK _8475_/D load_slew591/X VGND VGND VPWR VPWR _8475_/Q sky130_fd_sc_hd__dfrtp_2
X_5687_ _5687_/A VGND VGND VPWR VPWR _7884_/D sky130_fd_sc_hd__buf_1
X_4707_ _4707_/A VGND VGND VPWR VPWR _4707_/X sky130_fd_sc_hd__buf_1
X_7426_ _8770_/Q _4890_/A _7428_/S VGND VGND VPWR VPWR _7427_/A sky130_fd_sc_hd__mux2_2
X_4638_ _8454_/Q _8535_/Q _8616_/Q _8697_/Q _4632_/S _4569_/A VGND VGND VPWR VPWR
+ _4638_/X sky130_fd_sc_hd__mux4_2
XFILLER_118_46 VGND VGND VPWR VPWR sky130_fd_sc_hd__fill_1
XTAP_TAPCELL_ROW_9_416 VGND VPWR sky130_fd_sc_hd__tapvpwrvgnd_1
XFILLER_118_68 VGND VGND VPWR VPWR sky130_fd_sc_hd__fill_2
XFILLER_118_79 VGND VGND VPWR VPWR sky130_fd_sc_hd__decap_3
X_7357_ _8737_/Q _4752_/A _7365_/S VGND VGND VPWR VPWR _7358_/A sky130_fd_sc_hd__mux2_2
X_4569_ _4569_/A _4569_/B VGND VGND VPWR VPWR _4569_/X sky130_fd_sc_hd__or2_2
XFILLER_131_520 VGND VGND VPWR VPWR sky130_fd_sc_hd__decap_3
X_7288_ _8704_/Q _4956_/A _7302_/S VGND VGND VPWR VPWR _7289_/A sky130_fd_sc_hd__mux2_2
X_6308_ _4933_/X _8213_/Q _6310_/S VGND VGND VPWR VPWR _6309_/A sky130_fd_sc_hd__mux2_4
XFILLER_131_553 VGND VGND VPWR VPWR sky130_fd_sc_hd__decap_3
XFILLER_131_564 VGND VGND VPWR VPWR sky130_fd_sc_hd__decap_3
XFILLER_134_12 VGND VGND VPWR VPWR sky130_fd_sc_hd__decap_3
XFILLER_76_106 VGND VGND VPWR VPWR sky130_fd_sc_hd__decap_3
XFILLER_89_467 VGND VGND VPWR VPWR sky130_fd_sc_hd__decap_3
X_6239_ _4795_/X _8180_/Q _6247_/S VGND VGND VPWR VPWR _6240_/A sky130_fd_sc_hd__mux2_4
XFILLER_131_597 VGND VGND VPWR VPWR sky130_fd_sc_hd__decap_3
XFILLER_134_56 VGND VGND VPWR VPWR sky130_fd_sc_hd__decap_3
XFILLER_76_139 VGND VGND VPWR VPWR sky130_fd_sc_hd__fill_1
XFILLER_94_27 VGND VGND VPWR VPWR sky130_fd_sc_hd__fill_1
XFILLER_91_109 VGND VGND VPWR VPWR sky130_fd_sc_hd__decap_3
XFILLER_17_217 VGND VGND VPWR VPWR sky130_fd_sc_hd__decap_3
XFILLER_17_228 VGND VGND VPWR VPWR sky130_fd_sc_hd__decap_3
XFILLER_27_21 VGND VGND VPWR VPWR sky130_fd_sc_hd__decap_3
XFILLER_27_54 VGND VGND VPWR VPWR sky130_fd_sc_hd__fill_2
XFILLER_85_673 VGND VGND VPWR VPWR sky130_fd_sc_hd__fill_1
XFILLER_85_695 VGND VGND VPWR VPWR sky130_fd_sc_hd__decap_3
XFILLER_27_87 VGND VGND VPWR VPWR sky130_fd_sc_hd__decap_3
XFILLER_60_518 VGND VGND VPWR VPWR sky130_fd_sc_hd__decap_3
XFILLER_72_378 VGND VGND VPWR VPWR sky130_fd_sc_hd__decap_3
XFILLER_13_423 VGND VGND VPWR VPWR sky130_fd_sc_hd__decap_3
XFILLER_41_732 VGND VGND VPWR VPWR sky130_fd_sc_hd__decap_3
XFILLER_43_31 VGND VGND VPWR VPWR sky130_fd_sc_hd__decap_3
XTAP_TAPCELL_ROW_36_790 VGND VPWR sky130_fd_sc_hd__tapvpwrvgnd_1
XFILLER_40_253 VGND VGND VPWR VPWR sky130_fd_sc_hd__fill_1
XFILLER_41_765 VGND VGND VPWR VPWR sky130_fd_sc_hd__fill_1
XFILLER_43_53 VGND VGND VPWR VPWR sky130_fd_sc_hd__decap_3
XFILLER_9_405 VGND VGND VPWR VPWR sky130_fd_sc_hd__decap_3
XFILLER_9_438 VGND VGND VPWR VPWR sky130_fd_sc_hd__decap_3
XFILLER_5_611 VGND VGND VPWR VPWR sky130_fd_sc_hd__decap_3
XFILLER_4_132 VGND VGND VPWR VPWR sky130_fd_sc_hd__decap_3
XFILLER_5_644 VGND VGND VPWR VPWR sky130_fd_sc_hd__decap_3
XTAP_TAPCELL_ROW_130_2115 VGND VPWR sky130_fd_sc_hd__tapvpwrvgnd_1
XFILLER_107_561 VGND VGND VPWR VPWR sky130_fd_sc_hd__decap_3
XFILLER_5_688 VGND VGND VPWR VPWR sky130_fd_sc_hd__decap_3
XFILLER_122_531 VGND VGND VPWR VPWR sky130_fd_sc_hd__fill_1
XFILLER_122_542 VGND VGND VPWR VPWR sky130_fd_sc_hd__decap_3
XFILLER_134_380 VGND VGND VPWR VPWR sky130_fd_sc_hd__decap_3
XFILLER_4_47 VGND VGND VPWR VPWR sky130_fd_sc_hd__decap_3
XFILLER_122_575 VGND VGND VPWR VPWR sky130_fd_sc_hd__decap_3
XFILLER_68_72 VGND VGND VPWR VPWR sky130_fd_sc_hd__decap_3
XFILLER_110_726 VGND VGND VPWR VPWR sky130_fd_sc_hd__decap_3
XFILLER_67_128 VGND VGND VPWR VPWR sky130_fd_sc_hd__decap_3
XFILLER_68_94 VGND VGND VPWR VPWR sky130_fd_sc_hd__fill_2
XFILLER_63_312 VGND VGND VPWR VPWR sky130_fd_sc_hd__decap_3
XTAP_TAPCELL_ROW_128_2088 VGND VPWR sky130_fd_sc_hd__tapvpwrvgnd_1
XFILLER_48_397 VGND VGND VPWR VPWR sky130_fd_sc_hd__decap_3
XFILLER_63_334 VGND VGND VPWR VPWR sky130_fd_sc_hd__fill_2
XFILLER_51_518 VGND VGND VPWR VPWR sky130_fd_sc_hd__fill_2
X_3940_ _8634_/Q _4399_/A2 _3916_/B _8553_/Q _3900_/S VGND VGND VPWR VPWR _3940_/X
+ sky130_fd_sc_hd__o221a_2
XFILLER_32_710 VGND VGND VPWR VPWR sky130_fd_sc_hd__fill_2
XFILLER_90_197 VGND VGND VPWR VPWR sky130_fd_sc_hd__decap_3
X_3871_ _3890_/A VGND VGND VPWR VPWR _3871_/X sky130_fd_sc_hd__clkbuf_2
XFILLER_31_275 VGND VGND VPWR VPWR sky130_fd_sc_hd__decap_3
X_6590_ _6590_/A VGND VGND VPWR VPWR _8345_/D sky130_fd_sc_hd__buf_2
X_5610_ _7849_/Q _4807_/A _5612_/S VGND VGND VPWR VPWR _5611_/A sky130_fd_sc_hd__mux2_2
XFILLER_129_152 VGND VGND VPWR VPWR sky130_fd_sc_hd__decap_3
XTAP_TAPCELL_ROW_14_484 VGND VPWR sky130_fd_sc_hd__tapvpwrvgnd_1
XTAP_TAPCELL_ROW_14_495 VGND VPWR sky130_fd_sc_hd__tapvpwrvgnd_1
X_5541_ _7816_/Q _5011_/A _5549_/S VGND VGND VPWR VPWR _5542_/A sky130_fd_sc_hd__mux2_2
X_8260_ _8740_/CLK _8260_/D load_slew538/X VGND VGND VPWR VPWR _8260_/Q sky130_fd_sc_hd__dfrtp_2
XFILLER_129_196 VGND VGND VPWR VPWR sky130_fd_sc_hd__decap_3
X_7211_ _7202_/X _4711_/X _7204_/X _7205_/X hold756/X VGND VGND VPWR VPWR _8646_/D
+ sky130_fd_sc_hd__a32o_2
X_5472_ _7784_/Q _4874_/A _5482_/S VGND VGND VPWR VPWR _5473_/A sky130_fd_sc_hd__mux2_2
XFILLER_132_328 VGND VGND VPWR VPWR sky130_fd_sc_hd__decap_3
XTAP_TAPCELL_ROW_74_1331 VGND VPWR sky130_fd_sc_hd__tapvpwrvgnd_1
X_8191_ _8593_/CLK _8191_/D fanout709/X VGND VGND VPWR VPWR _8191_/Q sky130_fd_sc_hd__dfrtp_2
X_4423_ _8435_/Q _8516_/Q _4446_/S VGND VGND VPWR VPWR _4423_/X sky130_fd_sc_hd__mux2_2
XFILLER_99_743 VGND VGND VPWR VPWR sky130_fd_sc_hd__decap_3
X_7142_ _7142_/A VGND VGND VPWR VPWR _8604_/D sky130_fd_sc_hd__buf_2
X_4354_ _7933_/Q _4660_/A2 _4353_/X VGND VGND VPWR VPWR _4354_/X sky130_fd_sc_hd__o21a_2
XFILLER_101_704 VGND VGND VPWR VPWR sky130_fd_sc_hd__decap_3
XFILLER_113_564 VGND VGND VPWR VPWR sky130_fd_sc_hd__decap_3
XFILLER_59_607 VGND VGND VPWR VPWR sky130_fd_sc_hd__decap_3
XFILLER_86_415 VGND VGND VPWR VPWR sky130_fd_sc_hd__decap_3
XFILLER_98_242 VGND VGND VPWR VPWR sky130_fd_sc_hd__decap_3
XFILLER_98_253 VGND VGND VPWR VPWR sky130_fd_sc_hd__decap_3
Xfanout417 _4471_/S VGND VGND VPWR VPWR _4544_/S0 sky130_fd_sc_hd__clkdlybuf4s25_1
Xfanout439 _4675_/S VGND VGND VPWR VPWR _4314_/S sky130_fd_sc_hd__clkdlybuf4s25_1
X_7073_ _7073_/A VGND VGND VPWR VPWR _8571_/D sky130_fd_sc_hd__buf_2
XFILLER_101_726 VGND VGND VPWR VPWR sky130_fd_sc_hd__fill_2
XFILLER_58_139 VGND VGND VPWR VPWR sky130_fd_sc_hd__fill_1
XFILLER_86_426 VGND VGND VPWR VPWR sky130_fd_sc_hd__fill_1
X_6024_ _8079_/Q _4710_/A _6032_/S VGND VGND VPWR VPWR _6025_/A sky130_fd_sc_hd__mux2_2
X_4285_ _4681_/A _4285_/B VGND VGND VPWR VPWR _4285_/X sky130_fd_sc_hd__or2_2
XFILLER_100_236 VGND VGND VPWR VPWR sky130_fd_sc_hd__decap_3
XFILLER_104_48 VGND VGND VPWR VPWR sky130_fd_sc_hd__fill_1
XFILLER_54_312 VGND VGND VPWR VPWR sky130_fd_sc_hd__decap_3
XFILLER_66_161 VGND VGND VPWR VPWR sky130_fd_sc_hd__decap_3
XFILLER_67_673 VGND VGND VPWR VPWR sky130_fd_sc_hd__decap_3
XFILLER_27_537 VGND VGND VPWR VPWR sky130_fd_sc_hd__decap_3
XFILLER_82_654 VGND VGND VPWR VPWR sky130_fd_sc_hd__decap_3
X_7975_ _8639_/CLK _7975_/D wire603/X VGND VGND VPWR VPWR _7975_/Q sky130_fd_sc_hd__dfrtp_2
XFILLER_42_518 VGND VGND VPWR VPWR sky130_fd_sc_hd__decap_3
X_6926_ _6926_/A VGND VGND VPWR VPWR _8502_/D sky130_fd_sc_hd__buf_6
XFILLER_81_175 VGND VGND VPWR VPWR sky130_fd_sc_hd__fill_1
XTAP_TAPCELL_ROW_85_1482 VGND VPWR sky130_fd_sc_hd__tapvpwrvgnd_1
XFILLER_23_776 VGND VGND VPWR VPWR sky130_fd_sc_hd__decap_3
XFILLER_80_29 VGND VGND VPWR VPWR sky130_fd_sc_hd__fill_2
X_6857_ _6857_/A VGND VGND VPWR VPWR _8469_/D sky130_fd_sc_hd__buf_6
XFILLER_13_12 VGND VGND VPWR VPWR sky130_fd_sc_hd__decap_3
XFILLER_22_264 VGND VGND VPWR VPWR sky130_fd_sc_hd__decap_3
XFILLER_50_595 VGND VGND VPWR VPWR sky130_fd_sc_hd__fill_1
XTAP_TAPCELL_ROW_33_760 VGND VPWR sky130_fd_sc_hd__tapvpwrvgnd_1
X_6788_ _6830_/S VGND VGND VPWR VPWR _6807_/S sky130_fd_sc_hd__buf_2
X_5808_ _7942_/Q _4857_/A _5826_/S VGND VGND VPWR VPWR _5809_/A sky130_fd_sc_hd__mux2_2
XFILLER_129_12 VGND VGND VPWR VPWR sky130_fd_sc_hd__decap_3
XFILLER_13_45 VGND VGND VPWR VPWR sky130_fd_sc_hd__decap_3
X_8527_ _8763_/CLK _8527_/D wire555/X VGND VGND VPWR VPWR _8527_/Q sky130_fd_sc_hd__dfrtp_2
X_5739_ _5739_/A VGND VGND VPWR VPWR _7909_/D sky130_fd_sc_hd__buf_1
XFILLER_108_303 VGND VGND VPWR VPWR sky130_fd_sc_hd__decap_3
XFILLER_108_325 VGND VGND VPWR VPWR sky130_fd_sc_hd__decap_3
XFILLER_129_45 VGND VGND VPWR VPWR sky130_fd_sc_hd__decap_3
XFILLER_135_100 VGND VGND VPWR VPWR sky130_fd_sc_hd__decap_3
XFILLER_13_78 VGND VGND VPWR VPWR sky130_fd_sc_hd__decap_3
XFILLER_129_78 VGND VGND VPWR VPWR sky130_fd_sc_hd__decap_3
XFILLER_135_122 VGND VGND VPWR VPWR sky130_fd_sc_hd__decap_3
XFILLER_135_144 VGND VGND VPWR VPWR sky130_fd_sc_hd__decap_3
XFILLER_89_49 VGND VGND VPWR VPWR sky130_fd_sc_hd__decap_3
X_8458_ _8701_/CLK _8458_/D fanout648/A VGND VGND VPWR VPWR _8458_/Q sky130_fd_sc_hd__dfrtp_2
XFILLER_123_317 VGND VGND VPWR VPWR sky130_fd_sc_hd__fill_2
X_8389_ _8719_/CLK _8389_/D load_slew584/X VGND VGND VPWR VPWR _8389_/Q sky130_fd_sc_hd__dfrtp_2
X_7409_ _7451_/S VGND VGND VPWR VPWR _7428_/S sky130_fd_sc_hd__clkbuf_2
XFILLER_116_391 VGND VGND VPWR VPWR sky130_fd_sc_hd__decap_3
XFILLER_1_102 VGND VGND VPWR VPWR sky130_fd_sc_hd__decap_3
XFILLER_1_113 VGND VGND VPWR VPWR sky130_fd_sc_hd__decap_3
XFILLER_2_625 VGND VGND VPWR VPWR sky130_fd_sc_hd__decap_3
XFILLER_2_669 VGND VGND VPWR VPWR sky130_fd_sc_hd__decap_3
Xmax_cap190 _5882_/X VGND VGND VPWR VPWR _5893_/A2 sky130_fd_sc_hd__buf_2
XFILLER_131_361 VGND VGND VPWR VPWR sky130_fd_sc_hd__fill_1
XFILLER_131_383 VGND VGND VPWR VPWR sky130_fd_sc_hd__decap_3
XFILLER_49_128 VGND VGND VPWR VPWR sky130_fd_sc_hd__decap_3
XFILLER_58_640 VGND VGND VPWR VPWR sky130_fd_sc_hd__fill_1
XFILLER_38_64 VGND VGND VPWR VPWR sky130_fd_sc_hd__decap_3
XFILLER_58_684 VGND VGND VPWR VPWR sky130_fd_sc_hd__decap_3
XFILLER_92_418 VGND VGND VPWR VPWR sky130_fd_sc_hd__fill_2
XFILLER_73_632 VGND VGND VPWR VPWR sky130_fd_sc_hd__decap_3
XFILLER_73_676 VGND VGND VPWR VPWR sky130_fd_sc_hd__decap_3
XFILLER_14_732 VGND VGND VPWR VPWR sky130_fd_sc_hd__decap_3
XFILLER_60_315 VGND VGND VPWR VPWR sky130_fd_sc_hd__fill_1
XFILLER_13_220 VGND VGND VPWR VPWR sky130_fd_sc_hd__decap_3
XFILLER_54_85 VGND VGND VPWR VPWR sky130_fd_sc_hd__decap_3
XFILLER_14_776 VGND VGND VPWR VPWR sky130_fd_sc_hd__decap_3
XFILLER_41_595 VGND VGND VPWR VPWR sky130_fd_sc_hd__decap_3
XFILLER_9_268 VGND VGND VPWR VPWR sky130_fd_sc_hd__decap_3
XFILLER_126_100 VGND VGND VPWR VPWR sky130_fd_sc_hd__decap_3
XFILLER_127_612 VGND VGND VPWR VPWR sky130_fd_sc_hd__decap_3
XFILLER_127_623 VGND VGND VPWR VPWR sky130_fd_sc_hd__decap_3
XTAP_TAPCELL_ROW_11_443 VGND VPWR sky130_fd_sc_hd__tapvpwrvgnd_1
Xclkload16 _8732_/CLK VGND VGND VPWR VPWR clkload16/X sky130_fd_sc_hd__clkbuf_4
XFILLER_127_645 VGND VGND VPWR VPWR sky130_fd_sc_hd__decap_3
Xclkload27 _8803_/CLK VGND VGND VPWR VPWR clkload27/Y sky130_fd_sc_hd__clkinv_2
Xclkload38 _8798_/CLK VGND VGND VPWR VPWR clkload38/X sky130_fd_sc_hd__clkbuf_8
Xclkload49 _8547_/CLK VGND VGND VPWR VPWR clkload49/X sky130_fd_sc_hd__clkbuf_4
XFILLER_5_452 VGND VGND VPWR VPWR sky130_fd_sc_hd__fill_1
XFILLER_107_391 VGND VGND VPWR VPWR sky130_fd_sc_hd__fill_1
XTAP_TAPCELL_ROW_110_1829 VGND VPWR sky130_fd_sc_hd__tapvpwrvgnd_1
XTAP_TAPCELL_ROW_56_1072 VGND VPWR sky130_fd_sc_hd__tapvpwrvgnd_1
XTAP_TAPCELL_ROW_56_1083 VGND VPWR sky130_fd_sc_hd__tapvpwrvgnd_1
XFILLER_110_567 VGND VGND VPWR VPWR sky130_fd_sc_hd__decap_3
XFILLER_1_691 VGND VGND VPWR VPWR sky130_fd_sc_hd__decap_3
XFILLER_95_234 VGND VGND VPWR VPWR sky130_fd_sc_hd__decap_3
XFILLER_96_757 VGND VGND VPWR VPWR sky130_fd_sc_hd__decap_3
X_4070_ _7745_/Q _7826_/Q _7907_/Q _7988_/Q _4074_/S _4110_/S1 VGND VGND VPWR VPWR
+ _4071_/B sky130_fd_sc_hd__mux4_2
XFILLER_110_589 VGND VGND VPWR VPWR sky130_fd_sc_hd__decap_3
XFILLER_37_802 VGND VGND VPWR VPWR sky130_fd_sc_hd__fill_2
XFILLER_48_161 VGND VGND VPWR VPWR sky130_fd_sc_hd__decap_3
XFILLER_49_673 VGND VGND VPWR VPWR sky130_fd_sc_hd__decap_3
XFILLER_95_278 VGND VGND VPWR VPWR sky130_fd_sc_hd__fill_2
XFILLER_95_92 VGND VGND VPWR VPWR sky130_fd_sc_hd__decap_3
XFILLER_48_194 VGND VGND VPWR VPWR sky130_fd_sc_hd__fill_2
XFILLER_63_142 VGND VGND VPWR VPWR sky130_fd_sc_hd__fill_1
XFILLER_63_164 VGND VGND VPWR VPWR sky130_fd_sc_hd__fill_1
XFILLER_91_440 VGND VGND VPWR VPWR sky130_fd_sc_hd__decap_3
XTAP_TAPCELL_ROW_19_554 VGND VPWR sky130_fd_sc_hd__tapvpwrvgnd_1
XTAP_TAPCELL_ROW_19_565 VGND VPWR sky130_fd_sc_hd__tapvpwrvgnd_1
XFILLER_51_337 VGND VGND VPWR VPWR sky130_fd_sc_hd__decap_3
XFILLER_91_484 VGND VGND VPWR VPWR sky130_fd_sc_hd__decap_3
X_7760_ _7923_/CLK _7760_/D load_slew616/X VGND VGND VPWR VPWR _7760_/Q sky130_fd_sc_hd__dfrtp_2
X_4972_ _4972_/A _4984_/B VGND VGND VPWR VPWR _4973_/A sky130_fd_sc_hd__and2_2
XFILLER_32_540 VGND VGND VPWR VPWR sky130_fd_sc_hd__decap_3
X_3923_ _3916_/X _3918_/X _3920_/X _3922_/X VGND VGND VPWR VPWR _3923_/X sky130_fd_sc_hd__a22o_2
X_7691_ _8672_/CLK _7691_/D load_slew689/X VGND VGND VPWR VPWR _7691_/Q sky130_fd_sc_hd__dfrtp_2
X_6711_ _8401_/Q _4702_/A _6723_/S VGND VGND VPWR VPWR _6712_/A sky130_fd_sc_hd__mux2_2
XFILLER_20_713 VGND VGND VPWR VPWR sky130_fd_sc_hd__decap_3
X_3854_ _4666_/A1 _3844_/X _3847_/X _3853_/X VGND VGND VPWR VPWR _3854_/X sky130_fd_sc_hd__o31a_2
X_6642_ _4913_/X _8370_/Q _6654_/S VGND VGND VPWR VPWR _6643_/A sky130_fd_sc_hd__mux2_2
XFILLER_20_757 VGND VGND VPWR VPWR sky130_fd_sc_hd__fill_2
XFILLER_9_780 VGND VGND VPWR VPWR sky130_fd_sc_hd__decap_3
X_3785_ _3889_/A VGND VGND VPWR VPWR _3785_/X sky130_fd_sc_hd__clkbuf_2
X_8312_ _8798_/CLK _8312_/D fanout601/X VGND VGND VPWR VPWR _8312_/Q sky130_fd_sc_hd__dfrtp_2
X_6573_ _4773_/X _8337_/Q _6591_/S VGND VGND VPWR VPWR _6574_/A sky130_fd_sc_hd__mux2_2
XFILLER_118_667 VGND VGND VPWR VPWR sky130_fd_sc_hd__decap_3
XFILLER_9_791 VGND VGND VPWR VPWR sky130_fd_sc_hd__decap_3
X_5524_ _7808_/Q _4977_/A _5528_/S VGND VGND VPWR VPWR _5525_/A sky130_fd_sc_hd__mux2_2
XFILLER_132_103 VGND VGND VPWR VPWR sky130_fd_sc_hd__decap_3
XFILLER_133_615 VGND VGND VPWR VPWR sky130_fd_sc_hd__fill_1
XFILLER_133_626 VGND VGND VPWR VPWR sky130_fd_sc_hd__decap_3
X_8243_ _8729_/CLK _8243_/D wire476/X VGND VGND VPWR VPWR _8243_/Q sky130_fd_sc_hd__dfrtp_2
X_5455_ _7776_/Q _4840_/A _5461_/S VGND VGND VPWR VPWR _5456_/A sky130_fd_sc_hd__mux2_2
XFILLER_132_136 VGND VGND VPWR VPWR sky130_fd_sc_hd__decap_3
XFILLER_133_659 VGND VGND VPWR VPWR sky130_fd_sc_hd__decap_3
X_8174_ _8742_/CLK _8174_/D load_slew521/X VGND VGND VPWR VPWR _8174_/Q sky130_fd_sc_hd__dfrtp_2
X_4406_ _4403_/X _4404_/X _4405_/X _4393_/A _4458_/B2 VGND VGND VPWR VPWR _4406_/X
+ sky130_fd_sc_hd__a221o_2
XFILLER_120_309 VGND VGND VPWR VPWR sky130_fd_sc_hd__decap_3
XFILLER_132_147 VGND VGND VPWR VPWR sky130_fd_sc_hd__decap_3
XFILLER_5_90 VGND VGND VPWR VPWR sky130_fd_sc_hd__decap_3
X_7125_ _7125_/A VGND VGND VPWR VPWR _8596_/D sky130_fd_sc_hd__buf_2
X_5386_ _7743_/Q _4702_/A _5398_/S VGND VGND VPWR VPWR _5387_/A sky130_fd_sc_hd__mux2_2
X_4337_ _3760_/X _4332_/X _4336_/X VGND VGND VPWR VPWR _4337_/X sky130_fd_sc_hd__a21o_2
XFILLER_101_567 VGND VGND VPWR VPWR sky130_fd_sc_hd__decap_3
XFILLER_115_69 VGND VGND VPWR VPWR sky130_fd_sc_hd__decap_3
XFILLER_86_256 VGND VGND VPWR VPWR sky130_fd_sc_hd__fill_2
X_7056_ _7056_/A VGND VGND VPWR VPWR _8563_/D sky130_fd_sc_hd__buf_2
X_4268_ _4261_/A _4266_/X _4267_/X VGND VGND VPWR VPWR _4268_/X sky130_fd_sc_hd__o21a_2
XFILLER_74_418 VGND VGND VPWR VPWR sky130_fd_sc_hd__fill_2
XTAP_TAPCELL_ROW_87_1511 VGND VPWR sky130_fd_sc_hd__tapvpwrvgnd_1
X_6007_ _8071_/Q _5018_/A _6011_/S VGND VGND VPWR VPWR _6008_/A sky130_fd_sc_hd__mux2_2
XFILLER_131_24 VGND VGND VPWR VPWR sky130_fd_sc_hd__decap_3
XFILLER_39_172 VGND VGND VPWR VPWR sky130_fd_sc_hd__decap_3
XTAP_TAPCELL_ROW_38_830 VGND VPWR sky130_fd_sc_hd__tapvpwrvgnd_1
X_4199_ _8334_/Q _3750_/X _3752_/X _8253_/Q _4465_/A VGND VGND VPWR VPWR _4199_/X
+ sky130_fd_sc_hd__o221a_2
XFILLER_131_57 VGND VGND VPWR VPWR sky130_fd_sc_hd__decap_3
XFILLER_55_654 VGND VGND VPWR VPWR sky130_fd_sc_hd__fill_2
XFILLER_55_665 VGND VGND VPWR VPWR sky130_fd_sc_hd__decap_3
XFILLER_54_175 VGND VGND VPWR VPWR sky130_fd_sc_hd__decap_3
XFILLER_54_197 VGND VGND VPWR VPWR sky130_fd_sc_hd__fill_2
XFILLER_70_613 VGND VGND VPWR VPWR sky130_fd_sc_hd__decap_3
X_7958_ _8778_/CLK _7958_/D fanout732/A VGND VGND VPWR VPWR _7958_/Q sky130_fd_sc_hd__dfrtp_2
X_7889_ _8790_/CLK _7889_/D load_slew673/X VGND VGND VPWR VPWR _7889_/Q sky130_fd_sc_hd__dfrtp_2
X_6909_ _6909_/A VGND VGND VPWR VPWR _8494_/D sky130_fd_sc_hd__buf_6
XFILLER_11_724 VGND VGND VPWR VPWR sky130_fd_sc_hd__decap_3
XFILLER_23_573 VGND VGND VPWR VPWR sky130_fd_sc_hd__decap_3
XFILLER_24_44 VGND VGND VPWR VPWR sky130_fd_sc_hd__decap_3
XFILLER_10_212 VGND VGND VPWR VPWR sky130_fd_sc_hd__fill_1
XFILLER_10_234 VGND VGND VPWR VPWR sky130_fd_sc_hd__decap_3
XFILLER_11_735 VGND VGND VPWR VPWR sky130_fd_sc_hd__decap_3
XFILLER_24_77 VGND VGND VPWR VPWR sky130_fd_sc_hd__decap_3
XFILLER_7_706 VGND VGND VPWR VPWR sky130_fd_sc_hd__decap_3
XFILLER_109_601 VGND VGND VPWR VPWR sky130_fd_sc_hd__decap_3
XFILLER_109_623 VGND VGND VPWR VPWR sky130_fd_sc_hd__fill_2
XFILLER_10_256 VGND VGND VPWR VPWR sky130_fd_sc_hd__decap_3
XFILLER_11_768 VGND VGND VPWR VPWR sky130_fd_sc_hd__decap_3
XFILLER_109_634 VGND VGND VPWR VPWR sky130_fd_sc_hd__decap_3
XTAP_TAPCELL_ROW_98_1662 VGND VPWR sky130_fd_sc_hd__tapvpwrvgnd_1
XFILLER_108_144 VGND VGND VPWR VPWR sky130_fd_sc_hd__decap_3
XFILLER_108_177 VGND VGND VPWR VPWR sky130_fd_sc_hd__decap_3
XFILLER_2_411 VGND VGND VPWR VPWR sky130_fd_sc_hd__fill_1
XFILLER_123_147 VGND VGND VPWR VPWR sky130_fd_sc_hd__decap_3
XFILLER_123_169 VGND VGND VPWR VPWR sky130_fd_sc_hd__decap_3
XFILLER_2_466 VGND VGND VPWR VPWR sky130_fd_sc_hd__decap_3
XFILLER_104_361 VGND VGND VPWR VPWR sky130_fd_sc_hd__decap_3
XFILLER_132_681 VGND VGND VPWR VPWR sky130_fd_sc_hd__decap_3
XFILLER_2_477 VGND VGND VPWR VPWR sky130_fd_sc_hd__decap_3
XFILLER_93_705 VGND VGND VPWR VPWR sky130_fd_sc_hd__decap_3
XFILLER_1_15 VGND VGND VPWR VPWR sky130_fd_sc_hd__decap_3
XFILLER_46_610 VGND VGND VPWR VPWR sky130_fd_sc_hd__decap_3
XFILLER_92_215 VGND VGND VPWR VPWR sky130_fd_sc_hd__fill_1
XFILLER_93_716 VGND VGND VPWR VPWR sky130_fd_sc_hd__decap_3
XFILLER_93_727 VGND VGND VPWR VPWR sky130_fd_sc_hd__fill_1
XFILLER_18_312 VGND VGND VPWR VPWR sky130_fd_sc_hd__decap_3
XFILLER_1_48 VGND VGND VPWR VPWR sky130_fd_sc_hd__decap_3
XFILLER_46_643 VGND VGND VPWR VPWR sky130_fd_sc_hd__fill_1
XFILLER_92_237 VGND VGND VPWR VPWR sky130_fd_sc_hd__decap_3
XTAP_TAPCELL_ROW_125_2036 VGND VPWR sky130_fd_sc_hd__tapvpwrvgnd_1
XTAP_TAPCELL_ROW_125_2047 VGND VPWR sky130_fd_sc_hd__tapvpwrvgnd_1
XFILLER_73_440 VGND VGND VPWR VPWR sky130_fd_sc_hd__decap_3
XFILLER_73_462 VGND VGND VPWR VPWR sky130_fd_sc_hd__fill_1
XFILLER_92_259 VGND VGND VPWR VPWR sky130_fd_sc_hd__decap_3
XFILLER_33_337 VGND VGND VPWR VPWR sky130_fd_sc_hd__decap_3
XFILLER_61_613 VGND VGND VPWR VPWR sky130_fd_sc_hd__decap_3
XTAP_TAPCELL_ROW_16_513 VGND VPWR sky130_fd_sc_hd__tapvpwrvgnd_1
XFILLER_61_679 VGND VGND VPWR VPWR sky130_fd_sc_hd__fill_1
XTAP_TAPCELL_ROW_107_1791 VGND VPWR sky130_fd_sc_hd__tapvpwrvgnd_1
XFILLER_14_584 VGND VGND VPWR VPWR sky130_fd_sc_hd__decap_3
XFILLER_60_189 VGND VGND VPWR VPWR sky130_fd_sc_hd__decap_3
XFILLER_10_790 VGND VGND VPWR VPWR sky130_fd_sc_hd__decap_3
XFILLER_127_442 VGND VGND VPWR VPWR sky130_fd_sc_hd__decap_3
XTAP_TAPCELL_ROW_58_1101 VGND VPWR sky130_fd_sc_hd__tapvpwrvgnd_1
XFILLER_127_464 VGND VGND VPWR VPWR sky130_fd_sc_hd__decap_3
XFILLER_6_772 VGND VGND VPWR VPWR sky130_fd_sc_hd__decap_3
XFILLER_114_114 VGND VGND VPWR VPWR sky130_fd_sc_hd__fill_2
XFILLER_114_136 VGND VGND VPWR VPWR sky130_fd_sc_hd__decap_3
XFILLER_127_497 VGND VGND VPWR VPWR sky130_fd_sc_hd__decap_3
X_5240_ _5240_/A VGND VGND VPWR VPWR _7674_/D sky130_fd_sc_hd__buf_1
XFILLER_114_147 VGND VGND VPWR VPWR sky130_fd_sc_hd__fill_1
XFILLER_114_169 VGND VGND VPWR VPWR sky130_fd_sc_hd__decap_3
XFILLER_130_607 VGND VGND VPWR VPWR sky130_fd_sc_hd__decap_3
XFILLER_46_3 VGND VGND VPWR VPWR sky130_fd_sc_hd__decap_3
XFILLER_5_293 VGND VGND VPWR VPWR sky130_fd_sc_hd__decap_3
XPHY_EDGE_ROW_18_Right_18 VGND VGND VPWR VPWR sky130_fd_sc_hd__decap_3
X_5171_ _5171_/A VGND VGND VPWR VPWR _7641_/D sky130_fd_sc_hd__buf_1
XFILLER_69_757 VGND VGND VPWR VPWR sky130_fd_sc_hd__decap_3
XFILLER_84_705 VGND VGND VPWR VPWR sky130_fd_sc_hd__fill_2
X_4122_ _4030_/S _4115_/X _4117_/X _4121_/X VGND VGND VPWR VPWR _4122_/X sky130_fd_sc_hd__a31o_2
XFILLER_83_204 VGND VGND VPWR VPWR sky130_fd_sc_hd__decap_3
XFILLER_96_576 VGND VGND VPWR VPWR sky130_fd_sc_hd__decap_3
X_4053_ _4129_/A _4053_/B VGND VGND VPWR VPWR _4053_/X sky130_fd_sc_hd__or2_2
XFILLER_37_632 VGND VGND VPWR VPWR sky130_fd_sc_hd__decap_3
XFILLER_83_237 VGND VGND VPWR VPWR sky130_fd_sc_hd__decap_3
XFILLER_84_749 VGND VGND VPWR VPWR sky130_fd_sc_hd__decap_3
Xinput3 wdata[0] VGND VGND VPWR VPWR input3/X sky130_fd_sc_hd__clkdlybuf4s25_1
XFILLER_37_676 VGND VGND VPWR VPWR sky130_fd_sc_hd__decap_3
XFILLER_64_462 VGND VGND VPWR VPWR sky130_fd_sc_hd__decap_3
XTAP_TAPCELL_ROW_69_1252 VGND VPWR sky130_fd_sc_hd__tapvpwrvgnd_1
XTAP_TAPCELL_ROW_69_1263 VGND VPWR sky130_fd_sc_hd__tapvpwrvgnd_1
XFILLER_91_281 VGND VGND VPWR VPWR sky130_fd_sc_hd__decap_3
X_8792_ _8792_/CLK _8792_/D fanout656/A VGND VGND VPWR VPWR _8792_/Q sky130_fd_sc_hd__dfrtp_2
X_7812_ _8470_/CLK _7812_/D load_slew587/X VGND VGND VPWR VPWR _7812_/Q sky130_fd_sc_hd__dfrtp_2
XFILLER_51_134 VGND VGND VPWR VPWR sky130_fd_sc_hd__fill_1
XFILLER_52_679 VGND VGND VPWR VPWR sky130_fd_sc_hd__decap_3
XPHY_EDGE_ROW_27_Right_27 VGND VGND VPWR VPWR sky130_fd_sc_hd__decap_3
XTAP_TAPCELL_ROW_82_1441 VGND VPWR sky130_fd_sc_hd__tapvpwrvgnd_1
X_7743_ _8731_/CLK _7743_/D fanout502/X VGND VGND VPWR VPWR _7743_/Q sky130_fd_sc_hd__dfrtp_2
X_4955_ _4955_/A VGND VGND VPWR VPWR _7559_/D sky130_fd_sc_hd__buf_1
XFILLER_51_167 VGND VGND VPWR VPWR sky130_fd_sc_hd__fill_1
X_3906_ _8389_/Q _8470_/Q _3906_/S VGND VGND VPWR VPWR _3906_/X sky130_fd_sc_hd__mux2_2
X_7674_ _8660_/CLK _7674_/D load_slew524/X VGND VGND VPWR VPWR _7674_/Q sky130_fd_sc_hd__dfrtp_2
X_4886_ _4886_/A _4902_/B VGND VGND VPWR VPWR _4887_/A sky130_fd_sc_hd__and2_2
XFILLER_20_554 VGND VGND VPWR VPWR sky130_fd_sc_hd__decap_3
X_3837_ _7725_/Q _7806_/Q _7887_/Q _7968_/Q _3838_/S0 _3869_/A VGND VGND VPWR VPWR
+ _3837_/X sky130_fd_sc_hd__mux4_2
X_6625_ _4879_/X _8362_/Q _6633_/S VGND VGND VPWR VPWR _6626_/A sky130_fd_sc_hd__mux2_2
X_3768_ _4326_/B VGND VGND VPWR VPWR _3768_/X sky130_fd_sc_hd__clkbuf_2
X_6556_ _4740_/X _8329_/Q _6570_/S VGND VGND VPWR VPWR _6557_/A sky130_fd_sc_hd__mux2_2
XFILLER_117_9 VGND VGND VPWR VPWR sky130_fd_sc_hd__decap_3
X_5507_ _6314_/A _7004_/B _6314_/C _5679_/D VGND VGND VPWR VPWR _5508_/A sky130_fd_sc_hd__and4_2
XFILLER_106_648 VGND VGND VPWR VPWR sky130_fd_sc_hd__decap_3
XFILLER_10_24 VGND VGND VPWR VPWR sky130_fd_sc_hd__decap_3
XFILLER_10_35 VGND VGND VPWR VPWR sky130_fd_sc_hd__decap_3
XFILLER_133_423 VGND VGND VPWR VPWR sky130_fd_sc_hd__decap_3
X_8226_ _8721_/CLK _8226_/D fanout542/X VGND VGND VPWR VPWR _8226_/Q sky130_fd_sc_hd__dfrtp_2
X_6487_ _6487_/A VGND VGND VPWR VPWR _6656_/S sky130_fd_sc_hd__buf_4
XFILLER_105_169 VGND VGND VPWR VPWR sky130_fd_sc_hd__decap_3
XFILLER_10_68 VGND VGND VPWR VPWR sky130_fd_sc_hd__decap_3
XFILLER_126_24 VGND VGND VPWR VPWR sky130_fd_sc_hd__decap_3
XFILLER_126_35 VGND VGND VPWR VPWR sky130_fd_sc_hd__decap_3
XFILLER_133_467 VGND VGND VPWR VPWR sky130_fd_sc_hd__decap_3
XPHY_EDGE_ROW_36_Right_36 VGND VGND VPWR VPWR sky130_fd_sc_hd__decap_3
X_5438_ _7768_/Q _4806_/A _5440_/S VGND VGND VPWR VPWR _5439_/A sky130_fd_sc_hd__mux2_2
XFILLER_120_106 VGND VGND VPWR VPWR sky130_fd_sc_hd__fill_1
XFILLER_120_128 VGND VGND VPWR VPWR sky130_fd_sc_hd__decap_3
XFILLER_126_68 VGND VGND VPWR VPWR sky130_fd_sc_hd__decap_3
XFILLER_59_212 VGND VGND VPWR VPWR sky130_fd_sc_hd__fill_2
XTAP_TAPCELL_ROW_93_1592 VGND VPWR sky130_fd_sc_hd__tapvpwrvgnd_1
X_8157_ _8728_/CLK _8157_/D fanout556/X VGND VGND VPWR VPWR _8157_/Q sky130_fd_sc_hd__dfrtp_2
X_5369_ _7735_/Q input9/X _5377_/S VGND VGND VPWR VPWR _5370_/A sky130_fd_sc_hd__mux2_2
XFILLER_101_320 VGND VGND VPWR VPWR sky130_fd_sc_hd__decap_3
XFILLER_59_223 VGND VGND VPWR VPWR sky130_fd_sc_hd__fill_1
XFILLER_59_245 VGND VGND VPWR VPWR sky130_fd_sc_hd__decap_3
X_8088_ _8493_/CLK _8088_/D load_slew480/X VGND VGND VPWR VPWR _8088_/Q sky130_fd_sc_hd__dfrtp_2
X_7108_ _7108_/A VGND VGND VPWR VPWR _8588_/D sky130_fd_sc_hd__buf_2
XFILLER_19_109 VGND VGND VPWR VPWR sky130_fd_sc_hd__decap_3
XFILLER_19_33 VGND VGND VPWR VPWR sky130_fd_sc_hd__decap_3
XFILLER_47_407 VGND VGND VPWR VPWR sky130_fd_sc_hd__decap_3
XFILLER_59_278 VGND VGND VPWR VPWR sky130_fd_sc_hd__fill_2
XFILLER_75_738 VGND VGND VPWR VPWR sky130_fd_sc_hd__decap_3
X_7039_ _7039_/A VGND VGND VPWR VPWR _8555_/D sky130_fd_sc_hd__buf_2
XFILLER_19_66 VGND VGND VPWR VPWR sky130_fd_sc_hd__decap_3
XFILLER_27_142 VGND VGND VPWR VPWR sky130_fd_sc_hd__decap_3
XFILLER_28_665 VGND VGND VPWR VPWR sky130_fd_sc_hd__decap_3
XFILLER_35_43 VGND VGND VPWR VPWR sky130_fd_sc_hd__fill_2
XFILLER_70_410 VGND VGND VPWR VPWR sky130_fd_sc_hd__decap_3
XFILLER_70_421 VGND VGND VPWR VPWR sky130_fd_sc_hd__decap_3
XPHY_EDGE_ROW_45_Right_45 VGND VGND VPWR VPWR sky130_fd_sc_hd__decap_3
XFILLER_15_337 VGND VGND VPWR VPWR sky130_fd_sc_hd__fill_2
XFILLER_70_454 VGND VGND VPWR VPWR sky130_fd_sc_hd__decap_3
XFILLER_30_318 VGND VGND VPWR VPWR sky130_fd_sc_hd__decap_3
XFILLER_35_87 VGND VGND VPWR VPWR sky130_fd_sc_hd__decap_3
XFILLER_42_167 VGND VGND VPWR VPWR sky130_fd_sc_hd__fill_2
XFILLER_43_679 VGND VGND VPWR VPWR sky130_fd_sc_hd__fill_1
XFILLER_129_718 VGND VGND VPWR VPWR sky130_fd_sc_hd__decap_3
XFILLER_70_498 VGND VGND VPWR VPWR sky130_fd_sc_hd__fill_2
XFILLER_128_206 VGND VGND VPWR VPWR sky130_fd_sc_hd__decap_3
XFILLER_129_729 VGND VGND VPWR VPWR sky130_fd_sc_hd__decap_3
XFILLER_7_503 VGND VGND VPWR VPWR sky130_fd_sc_hd__fill_1
XFILLER_7_514 VGND VGND VPWR VPWR sky130_fd_sc_hd__decap_3
XTAP_TAPCELL_ROW_41_869 VGND VPWR sky130_fd_sc_hd__tapvpwrvgnd_1
Xwire423 _4502_/S VGND VGND VPWR VPWR _4554_/S sky130_fd_sc_hd__clkbuf_4
XFILLER_109_420 VGND VGND VPWR VPWR sky130_fd_sc_hd__fill_2
XFILLER_11_598 VGND VGND VPWR VPWR sky130_fd_sc_hd__decap_3
XFILLER_128_239 VGND VGND VPWR VPWR sky130_fd_sc_hd__decap_3
XFILLER_51_97 VGND VGND VPWR VPWR sky130_fd_sc_hd__decap_3
XTAP_TAPCELL_ROW_21_582 VGND VPWR sky130_fd_sc_hd__tapvpwrvgnd_1
XTAP_TAPCELL_ROW_21_593 VGND VPWR sky130_fd_sc_hd__tapvpwrvgnd_1
XPHY_EDGE_ROW_54_Right_54 VGND VGND VPWR VPWR sky130_fd_sc_hd__decap_3
XFILLER_124_445 VGND VGND VPWR VPWR sky130_fd_sc_hd__decap_3
XFILLER_3_753 VGND VGND VPWR VPWR sky130_fd_sc_hd__decap_3
XFILLER_3_797 VGND VGND VPWR VPWR sky130_fd_sc_hd__fill_1
XTAP_TAPCELL_ROW_53_1031 VGND VPWR sky130_fd_sc_hd__tapvpwrvgnd_1
Xload_slew428 _3983_/S VGND VGND VPWR VPWR _4007_/S sky130_fd_sc_hd__clkbuf_2
Xload_slew406 _4197_/S VGND VGND VPWR VPWR _4183_/S sky130_fd_sc_hd__buf_4
XFILLER_111_128 VGND VGND VPWR VPWR sky130_fd_sc_hd__decap_3
XFILLER_120_651 VGND VGND VPWR VPWR sky130_fd_sc_hd__decap_3
XFILLER_120_684 VGND VGND VPWR VPWR sky130_fd_sc_hd__decap_3
XFILLER_66_716 VGND VGND VPWR VPWR sky130_fd_sc_hd__decap_3
XFILLER_93_502 VGND VGND VPWR VPWR sky130_fd_sc_hd__fill_2
XFILLER_19_610 VGND VGND VPWR VPWR sky130_fd_sc_hd__decap_3
XFILLER_66_749 VGND VGND VPWR VPWR sky130_fd_sc_hd__decap_3
XTAP_TAPCELL_ROW_109_1820 VGND VPWR sky130_fd_sc_hd__tapvpwrvgnd_1
XFILLER_18_131 VGND VGND VPWR VPWR sky130_fd_sc_hd__fill_1
XFILLER_74_760 VGND VGND VPWR VPWR sky130_fd_sc_hd__decap_3
XPHY_EDGE_ROW_63_Right_63 VGND VGND VPWR VPWR sky130_fd_sc_hd__decap_3
XFILLER_33_101 VGND VGND VPWR VPWR sky130_fd_sc_hd__fill_2
XFILLER_34_613 VGND VGND VPWR VPWR sky130_fd_sc_hd__decap_3
XFILLER_46_495 VGND VGND VPWR VPWR sky130_fd_sc_hd__decap_3
XFILLER_18_197 VGND VGND VPWR VPWR sky130_fd_sc_hd__decap_3
XFILLER_33_134 VGND VGND VPWR VPWR sky130_fd_sc_hd__decap_3
XFILLER_61_421 VGND VGND VPWR VPWR sky130_fd_sc_hd__fill_1
XTAP_TAPCELL_ROW_29_693 VGND VPWR sky130_fd_sc_hd__tapvpwrvgnd_1
XFILLER_61_465 VGND VGND VPWR VPWR sky130_fd_sc_hd__decap_3
XFILLER_21_329 VGND VGND VPWR VPWR sky130_fd_sc_hd__decap_3
XFILLER_33_189 VGND VGND VPWR VPWR sky130_fd_sc_hd__decap_3
XTAP_TAPCELL_ROW_64_1182 VGND VPWR sky130_fd_sc_hd__tapvpwrvgnd_1
XTAP_TAPCELL_ROW_64_1193 VGND VPWR sky130_fd_sc_hd__tapvpwrvgnd_1
X_4740_ _4740_/A VGND VGND VPWR VPWR _4740_/X sky130_fd_sc_hd__buf_1
X_4671_ _7799_/Q _7880_/Q _7961_/Q _8042_/Q _4650_/S _4651_/A VGND VGND VPWR VPWR
+ _4671_/X sky130_fd_sc_hd__mux4_2
XFILLER_128_740 VGND VGND VPWR VPWR sky130_fd_sc_hd__decap_3
X_7390_ _7390_/A VGND VGND VPWR VPWR _8752_/D sky130_fd_sc_hd__buf_1
X_6410_ _6410_/A VGND VGND VPWR VPWR _8260_/D sky130_fd_sc_hd__buf_2
XFILLER_128_784 VGND VGND VPWR VPWR sky130_fd_sc_hd__decap_3
XFILLER_134_209 VGND VGND VPWR VPWR sky130_fd_sc_hd__decap_3
XPHY_EDGE_ROW_72_Right_72 VGND VGND VPWR VPWR sky130_fd_sc_hd__decap_3
X_6341_ _6341_/A VGND VGND VPWR VPWR _8227_/D sky130_fd_sc_hd__buf_2
XFILLER_115_445 VGND VGND VPWR VPWR sky130_fd_sc_hd__decap_3
X_6272_ _6272_/A VGND VGND VPWR VPWR _8195_/D sky130_fd_sc_hd__buf_6
XFILLER_103_629 VGND VGND VPWR VPWR sky130_fd_sc_hd__fill_2
XFILLER_115_478 VGND VGND VPWR VPWR sky130_fd_sc_hd__decap_3
XFILLER_130_415 VGND VGND VPWR VPWR sky130_fd_sc_hd__decap_3
X_8011_ _8669_/CLK _8011_/D load_slew645/X VGND VGND VPWR VPWR _8011_/Q sky130_fd_sc_hd__dfrtp_2
X_5223_ _5223_/A VGND VGND VPWR VPWR _7666_/D sky130_fd_sc_hd__buf_1
XFILLER_130_448 VGND VGND VPWR VPWR sky130_fd_sc_hd__decap_3
X_5154_ _4929_/X _5154_/A1 _5158_/S VGND VGND VPWR VPWR _5155_/A sky130_fd_sc_hd__mux2_2
XFILLER_111_673 VGND VGND VPWR VPWR sky130_fd_sc_hd__decap_3
XFILLER_29_418 VGND VGND VPWR VPWR sky130_fd_sc_hd__decap_3
XFILLER_96_362 VGND VGND VPWR VPWR sky130_fd_sc_hd__fill_2
X_4105_ _3760_/X _4099_/X _4104_/X VGND VGND VPWR VPWR _4105_/X sky130_fd_sc_hd__o21a_2
XFILLER_2_80 VGND VGND VPWR VPWR sky130_fd_sc_hd__decap_3
XFILLER_56_226 VGND VGND VPWR VPWR sky130_fd_sc_hd__decap_3
XFILLER_84_524 VGND VGND VPWR VPWR sky130_fd_sc_hd__decap_3
XFILLER_96_395 VGND VGND VPWR VPWR sky130_fd_sc_hd__decap_3
XPHY_EDGE_ROW_81_Right_81 VGND VGND VPWR VPWR sky130_fd_sc_hd__decap_3
X_5085_ _4791_/X hold987/X _5095_/S VGND VGND VPWR VPWR _5086_/A sky130_fd_sc_hd__mux2_2
XFILLER_2_91 VGND VGND VPWR VPWR sky130_fd_sc_hd__decap_3
XFILLER_56_248 VGND VGND VPWR VPWR sky130_fd_sc_hd__decap_3
X_4036_ _4036_/A _4036_/B VGND VGND VPWR VPWR _4036_/X sky130_fd_sc_hd__or2_2
XFILLER_112_59 VGND VGND VPWR VPWR sky130_fd_sc_hd__decap_3
XFILLER_25_602 VGND VGND VPWR VPWR sky130_fd_sc_hd__decap_3
XFILLER_25_646 VGND VGND VPWR VPWR sky130_fd_sc_hd__decap_3
XFILLER_52_421 VGND VGND VPWR VPWR sky130_fd_sc_hd__decap_3
XFILLER_80_774 VGND VGND VPWR VPWR sky130_fd_sc_hd__fill_1
X_8775_ _8775_/CLK _8775_/D load_slew727/X VGND VGND VPWR VPWR _8775_/Q sky130_fd_sc_hd__dfrtp_2
X_5987_ _5987_/A VGND VGND VPWR VPWR _8061_/D sky130_fd_sc_hd__buf_1
XFILLER_33_690 VGND VGND VPWR VPWR sky130_fd_sc_hd__decap_3
X_7726_ _8789_/CLK _7726_/D load_slew671/X VGND VGND VPWR VPWR _7726_/Q sky130_fd_sc_hd__dfrtp_2
X_4938_ _4937_/X _7556_/Q _7453_/S VGND VGND VPWR VPWR _4939_/A sky130_fd_sc_hd__mux2_2
X_7657_ _8477_/CLK _7657_/D fanout607/A VGND VGND VPWR VPWR _7657_/Q sky130_fd_sc_hd__dfrtp_2
X_4869_ _4869_/A VGND VGND VPWR VPWR _7539_/D sky130_fd_sc_hd__buf_1
XFILLER_20_362 VGND VGND VPWR VPWR sky130_fd_sc_hd__fill_2
XFILLER_21_12 VGND VGND VPWR VPWR sky130_fd_sc_hd__decap_3
XPHY_EDGE_ROW_90_Right_90 VGND VGND VPWR VPWR sky130_fd_sc_hd__decap_3
X_6608_ _4845_/X _8354_/Q _6612_/S VGND VGND VPWR VPWR _6609_/A sky130_fd_sc_hd__mux2_2
XFILLER_115_6 VGND VGND VPWR VPWR sky130_fd_sc_hd__decap_3
XFILLER_125_209 VGND VGND VPWR VPWR sky130_fd_sc_hd__decap_3
XFILLER_21_45 VGND VGND VPWR VPWR sky130_fd_sc_hd__decap_3
XTAP_TAPCELL_ROW_95_1621 VGND VPWR sky130_fd_sc_hd__tapvpwrvgnd_1
X_7588_ _7669_/CLK _7588_/D fanout475/A VGND VGND VPWR VPWR _7588_/Q sky130_fd_sc_hd__dfrtp_2
XFILLER_134_710 VGND VGND VPWR VPWR sky130_fd_sc_hd__decap_3
XFILLER_21_78 VGND VGND VPWR VPWR sky130_fd_sc_hd__decap_3
XFILLER_4_539 VGND VGND VPWR VPWR sky130_fd_sc_hd__decap_3
X_6539_ _4707_/X _8321_/Q _6549_/S VGND VGND VPWR VPWR _6540_/A sky130_fd_sc_hd__mux2_2
XFILLER_106_445 VGND VGND VPWR VPWR sky130_fd_sc_hd__fill_1
XFILLER_133_220 VGND VGND VPWR VPWR sky130_fd_sc_hd__decap_3
XFILLER_133_231 VGND VGND VPWR VPWR sky130_fd_sc_hd__decap_3
XFILLER_134_743 VGND VGND VPWR VPWR sky130_fd_sc_hd__decap_3
XFILLER_97_38 VGND VGND VPWR VPWR sky130_fd_sc_hd__decap_3
XFILLER_0_701 VGND VGND VPWR VPWR sky130_fd_sc_hd__decap_3
XFILLER_121_426 VGND VGND VPWR VPWR sky130_fd_sc_hd__decap_3
XFILLER_133_264 VGND VGND VPWR VPWR sky130_fd_sc_hd__decap_3
XFILLER_134_787 VGND VGND VPWR VPWR sky130_fd_sc_hd__decap_3
X_8209_ _8776_/CLK _8209_/D load_slew731/X VGND VGND VPWR VPWR _8209_/Q sky130_fd_sc_hd__dfrtp_2
XFILLER_0_778 VGND VGND VPWR VPWR sky130_fd_sc_hd__decap_3
XFILLER_102_662 VGND VGND VPWR VPWR sky130_fd_sc_hd__decap_3
XFILLER_75_502 VGND VGND VPWR VPWR sky130_fd_sc_hd__fill_2
XFILLER_87_340 VGND VGND VPWR VPWR sky130_fd_sc_hd__decap_3
XTAP_TAPCELL_ROW_7_388 VGND VPWR sky130_fd_sc_hd__tapvpwrvgnd_1
XFILLER_101_194 VGND VGND VPWR VPWR sky130_fd_sc_hd__fill_1
XFILLER_63_719 VGND VGND VPWR VPWR sky130_fd_sc_hd__decap_3
XTAP_TAPCELL_ROW_122_2006 VGND VPWR sky130_fd_sc_hd__tapvpwrvgnd_1
XFILLER_16_613 VGND VGND VPWR VPWR sky130_fd_sc_hd__decap_3
XFILLER_28_473 VGND VGND VPWR VPWR sky130_fd_sc_hd__decap_3
XFILLER_46_53 VGND VGND VPWR VPWR sky130_fd_sc_hd__decap_3
XFILLER_56_771 VGND VGND VPWR VPWR sky130_fd_sc_hd__decap_3
XTAP_TAPCELL_ROW_46_939 VGND VPWR sky130_fd_sc_hd__tapvpwrvgnd_1
XFILLER_16_657 VGND VGND VPWR VPWR sky130_fd_sc_hd__decap_3
XFILLER_46_97 VGND VGND VPWR VPWR sky130_fd_sc_hd__decap_3
XFILLER_55_281 VGND VGND VPWR VPWR sky130_fd_sc_hd__decap_3
XFILLER_70_240 VGND VGND VPWR VPWR sky130_fd_sc_hd__decap_3
XTAP_TAPCELL_ROW_104_1750 VGND VPWR sky130_fd_sc_hd__tapvpwrvgnd_1
XTAP_TAPCELL_ROW_26_652 VGND VPWR sky130_fd_sc_hd__tapvpwrvgnd_1
XTAP_TAPCELL_ROW_26_663 VGND VPWR sky130_fd_sc_hd__tapvpwrvgnd_1
XFILLER_70_284 VGND VGND VPWR VPWR sky130_fd_sc_hd__decap_3
XFILLER_11_340 VGND VGND VPWR VPWR sky130_fd_sc_hd__decap_3
XFILLER_129_526 VGND VGND VPWR VPWR sky130_fd_sc_hd__decap_3
XFILLER_30_159 VGND VGND VPWR VPWR sky130_fd_sc_hd__fill_1
XFILLER_62_85 VGND VGND VPWR VPWR sky130_fd_sc_hd__fill_1
XFILLER_129_559 VGND VGND VPWR VPWR sky130_fd_sc_hd__fill_1
XFILLER_7_36 VGND VGND VPWR VPWR sky130_fd_sc_hd__decap_3
Xwire220 _4944_/B VGND VGND VPWR VPWR _4936_/B sky130_fd_sc_hd__buf_2
XFILLER_7_366 VGND VGND VPWR VPWR sky130_fd_sc_hd__decap_3
XFILLER_7_69 VGND VGND VPWR VPWR sky130_fd_sc_hd__decap_3
XTAP_TAPCELL_ROW_133_2157 VGND VPWR sky130_fd_sc_hd__tapvpwrvgnd_1
XFILLER_112_404 VGND VGND VPWR VPWR sky130_fd_sc_hd__decap_3
XFILLER_124_253 VGND VGND VPWR VPWR sky130_fd_sc_hd__fill_1
XFILLER_3_572 VGND VGND VPWR VPWR sky130_fd_sc_hd__decap_3
XFILLER_97_104 VGND VGND VPWR VPWR sky130_fd_sc_hd__decap_3
XFILLER_98_638 VGND VGND VPWR VPWR sky130_fd_sc_hd__decap_3
XFILLER_112_459 VGND VGND VPWR VPWR sky130_fd_sc_hd__decap_3
XFILLER_30_6 VGND VGND VPWR VPWR sky130_fd_sc_hd__decap_3
XFILLER_87_60 VGND VGND VPWR VPWR sky130_fd_sc_hd__decap_3
XFILLER_97_148 VGND VGND VPWR VPWR sky130_fd_sc_hd__decap_3
XFILLER_38_237 VGND VGND VPWR VPWR sky130_fd_sc_hd__decap_3
XFILLER_66_513 VGND VGND VPWR VPWR sky130_fd_sc_hd__decap_3
XFILLER_93_321 VGND VGND VPWR VPWR sky130_fd_sc_hd__decap_3
XFILLER_66_579 VGND VGND VPWR VPWR sky130_fd_sc_hd__decap_3
XFILLER_81_505 VGND VGND VPWR VPWR sky130_fd_sc_hd__decap_3
XFILLER_93_343 VGND VGND VPWR VPWR sky130_fd_sc_hd__decap_3
XFILLER_47_771 VGND VGND VPWR VPWR sky130_fd_sc_hd__decap_3
XTAP_TAPCELL_ROW_66_1211 VGND VPWR sky130_fd_sc_hd__tapvpwrvgnd_1
X_5910_ _5919_/A1 _5919_/A2 _4773_/X _5919_/B1 hold851/X VGND VGND VPWR VPWR _8003_/D
+ sky130_fd_sc_hd__a32o_2
XFILLER_34_421 VGND VGND VPWR VPWR sky130_fd_sc_hd__decap_3
XFILLER_46_292 VGND VGND VPWR VPWR sky130_fd_sc_hd__decap_3
XFILLER_62_741 VGND VGND VPWR VPWR sky130_fd_sc_hd__decap_3
XFILLER_81_549 VGND VGND VPWR VPWR sky130_fd_sc_hd__fill_2
XTAP_TAPCELL_ROW_66_1222 VGND VPWR sky130_fd_sc_hd__tapvpwrvgnd_1
X_6890_ _6890_/A VGND VGND VPWR VPWR _8485_/D sky130_fd_sc_hd__buf_6
X_5841_ _7958_/Q _4925_/A _5847_/S VGND VGND VPWR VPWR _5842_/A sky130_fd_sc_hd__mux2_2
X_8560_ _8560_/CLK _8560_/D _8053_/SET_B VGND VGND VPWR VPWR _8560_/Q sky130_fd_sc_hd__dfrtp_2
X_5772_ _7925_/Q _4787_/A _5784_/S VGND VGND VPWR VPWR _5773_/A sky130_fd_sc_hd__mux2_2
X_8491_ _8658_/CLK _8491_/D load_slew526/X VGND VGND VPWR VPWR _8491_/Q sky130_fd_sc_hd__dfrtp_2
X_7511_ _8736_/CLK _7511_/D fanout479/A VGND VGND VPWR VPWR _7511_/Q sky130_fd_sc_hd__dfrtp_2
X_4723_ _4723_/A VGND VGND VPWR VPWR _4723_/X sky130_fd_sc_hd__buf_1
XFILLER_30_682 VGND VGND VPWR VPWR sky130_fd_sc_hd__fill_1
X_7442_ _7442_/A VGND VGND VPWR VPWR _8777_/D sky130_fd_sc_hd__buf_1
X_4654_ _4673_/S _4643_/X _4646_/X _4649_/X _4653_/X VGND VGND VPWR VPWR _4654_/X
+ sky130_fd_sc_hd__o32a_2
XFILLER_128_581 VGND VGND VPWR VPWR sky130_fd_sc_hd__decap_3
XFILLER_128_592 VGND VGND VPWR VPWR sky130_fd_sc_hd__decap_3
XFILLER_135_529 VGND VGND VPWR VPWR sky130_fd_sc_hd__decap_3
Xhold801 _8642_/Q VGND VGND VPWR VPWR hold801/X sky130_fd_sc_hd__dlygate4sd3_1
Xhold812 _8638_/Q VGND VGND VPWR VPWR hold812/X sky130_fd_sc_hd__dlygate4sd3_1
Xinput50 wdata[52] VGND VGND VPWR VPWR _4823_/A sky130_fd_sc_hd__clkdlybuf4s25_1
Xinput61 wdata[62] VGND VGND VPWR VPWR _4865_/A sky130_fd_sc_hd__clkdlybuf4s25_1
Xinput72 wdata[72] VGND VGND VPWR VPWR _4907_/A sky130_fd_sc_hd__clkdlybuf4s25_1
X_7373_ _7373_/A VGND VGND VPWR VPWR _8744_/D sky130_fd_sc_hd__buf_1
X_4585_ _8774_/Q _7549_/Q _7630_/Q _7711_/Q _4620_/S _4621_/A VGND VGND VPWR VPWR
+ _4585_/X sky130_fd_sc_hd__mux4_2
XFILLER_115_220 VGND VGND VPWR VPWR sky130_fd_sc_hd__decap_3
XFILLER_115_231 VGND VGND VPWR VPWR sky130_fd_sc_hd__fill_2
XFILLER_115_242 VGND VGND VPWR VPWR sky130_fd_sc_hd__decap_3
XTAP_TAPCELL_ROW_77_1373 VGND VPWR sky130_fd_sc_hd__tapvpwrvgnd_1
Xhold823 _8018_/Q VGND VGND VPWR VPWR hold823/X sky130_fd_sc_hd__dlygate4sd3_1
Xhold834 _8042_/Q VGND VGND VPWR VPWR hold834/X sky130_fd_sc_hd__dlygate4sd3_1
Xhold845 _8664_/Q VGND VGND VPWR VPWR hold845/X sky130_fd_sc_hd__dlygate4sd3_1
Xinput83 wdata[9] VGND VGND VPWR VPWR _4984_/A sky130_fd_sc_hd__clkdlybuf4s25_1
X_6324_ _6324_/A VGND VGND VPWR VPWR _8219_/D sky130_fd_sc_hd__buf_2
XFILLER_107_26 VGND VGND VPWR VPWR sky130_fd_sc_hd__fill_1
XFILLER_107_48 VGND VGND VPWR VPWR sky130_fd_sc_hd__decap_3
XFILLER_116_787 VGND VGND VPWR VPWR sky130_fd_sc_hd__decap_3
XFILLER_131_724 VGND VGND VPWR VPWR sky130_fd_sc_hd__decap_3
Xhold856 _8017_/Q VGND VGND VPWR VPWR hold856/X sky130_fd_sc_hd__dlygate4sd3_1
Xhold867 _8698_/Q VGND VGND VPWR VPWR hold867/X sky130_fd_sc_hd__dlygate4sd3_1
Xhold878 _8036_/Q VGND VGND VPWR VPWR hold878/X sky130_fd_sc_hd__dlygate4sd3_1
Xhold889 _8694_/Q VGND VGND VPWR VPWR hold889/X sky130_fd_sc_hd__dlygate4sd3_1
X_6255_ _6255_/A VGND VGND VPWR VPWR _8187_/D sky130_fd_sc_hd__buf_6
XFILLER_130_212 VGND VGND VPWR VPWR sky130_fd_sc_hd__decap_3
XFILLER_131_735 VGND VGND VPWR VPWR sky130_fd_sc_hd__decap_3
XFILLER_131_768 VGND VGND VPWR VPWR sky130_fd_sc_hd__decap_3
XTAP_TAPCELL_ROW_90_1551 VGND VPWR sky130_fd_sc_hd__tapvpwrvgnd_1
X_5206_ _5206_/A VGND VGND VPWR VPWR _7658_/D sky130_fd_sc_hd__buf_1
XFILLER_130_245 VGND VGND VPWR VPWR sky130_fd_sc_hd__decap_3
XFILLER_130_256 VGND VGND VPWR VPWR sky130_fd_sc_hd__decap_3
X_6186_ _6312_/S VGND VGND VPWR VPWR _6205_/S sky130_fd_sc_hd__buf_6
XFILLER_111_470 VGND VGND VPWR VPWR sky130_fd_sc_hd__decap_3
XFILLER_123_14 VGND VGND VPWR VPWR sky130_fd_sc_hd__decap_3
XFILLER_57_535 VGND VGND VPWR VPWR sky130_fd_sc_hd__decap_3
XFILLER_69_384 VGND VGND VPWR VPWR sky130_fd_sc_hd__decap_3
XTAP_TAPCELL_ROW_4_347 VGND VPWR sky130_fd_sc_hd__tapvpwrvgnd_1
X_5137_ _4895_/X _7627_/Q _5137_/S VGND VGND VPWR VPWR _5138_/A sky130_fd_sc_hd__mux2_2
XFILLER_45_708 VGND VGND VPWR VPWR sky130_fd_sc_hd__decap_3
X_5068_ _4757_/X _7594_/Q _5074_/S VGND VGND VPWR VPWR _5069_/A sky130_fd_sc_hd__mux2_2
XFILLER_123_69 VGND VGND VPWR VPWR sky130_fd_sc_hd__decap_3
XFILLER_38_760 VGND VGND VPWR VPWR sky130_fd_sc_hd__decap_3
XFILLER_38_771 VGND VGND VPWR VPWR sky130_fd_sc_hd__decap_3
XFILLER_72_527 VGND VGND VPWR VPWR sky130_fd_sc_hd__decap_3
XFILLER_84_365 VGND VGND VPWR VPWR sky130_fd_sc_hd__fill_1
X_4019_ _8398_/Q _8479_/Q _8560_/Q _8641_/Q _3719_/C _3705_/C VGND VGND VPWR VPWR
+ _4019_/X sky130_fd_sc_hd__mux4_2
XFILLER_16_12 VGND VGND VPWR VPWR sky130_fd_sc_hd__decap_3
XFILLER_25_410 VGND VGND VPWR VPWR sky130_fd_sc_hd__decap_3
XFILLER_37_281 VGND VGND VPWR VPWR sky130_fd_sc_hd__decap_3
XFILLER_16_56 VGND VGND VPWR VPWR sky130_fd_sc_hd__decap_3
XFILLER_25_476 VGND VGND VPWR VPWR sky130_fd_sc_hd__decap_3
XFILLER_53_785 VGND VGND VPWR VPWR sky130_fd_sc_hd__decap_3
XPHY_EDGE_ROW_0_Right_0 VGND VGND VPWR VPWR sky130_fd_sc_hd__decap_3
XFILLER_13_638 VGND VGND VPWR VPWR sky130_fd_sc_hd__decap_3
XFILLER_52_295 VGND VGND VPWR VPWR sky130_fd_sc_hd__decap_3
XTAP_TAPCELL_ROW_23_611 VGND VPWR sky130_fd_sc_hd__tapvpwrvgnd_1
X_8758_ _8758_/CLK _8758_/D load_slew714/X VGND VGND VPWR VPWR _8758_/Q sky130_fd_sc_hd__dfrtp_2
XFILLER_12_159 VGND VGND VPWR VPWR sky130_fd_sc_hd__decap_3
XFILLER_40_446 VGND VGND VPWR VPWR sky130_fd_sc_hd__decap_3
XFILLER_9_609 VGND VGND VPWR VPWR sky130_fd_sc_hd__decap_3
X_7709_ _8772_/CLK _7709_/D fanout717/X VGND VGND VPWR VPWR _7709_/Q sky130_fd_sc_hd__dfrtp_2
XFILLER_21_682 VGND VGND VPWR VPWR sky130_fd_sc_hd__decap_3
X_8689_ _8689_/CLK _8689_/D fanout557/X VGND VGND VPWR VPWR _8689_/Q sky130_fd_sc_hd__dfrtp_2
XFILLER_20_192 VGND VGND VPWR VPWR sky130_fd_sc_hd__decap_3
XFILLER_107_732 VGND VGND VPWR VPWR sky130_fd_sc_hd__fill_2
XFILLER_113_3 VGND VGND VPWR VPWR sky130_fd_sc_hd__decap_3
XFILLER_126_529 VGND VGND VPWR VPWR sky130_fd_sc_hd__decap_3
XFILLER_32_99 VGND VGND VPWR VPWR sky130_fd_sc_hd__decap_3
XFILLER_107_743 VGND VGND VPWR VPWR sky130_fd_sc_hd__decap_3
XFILLER_134_551 VGND VGND VPWR VPWR sky130_fd_sc_hd__decap_3
XFILLER_106_253 VGND VGND VPWR VPWR sky130_fd_sc_hd__decap_3
XFILLER_106_286 VGND VGND VPWR VPWR sky130_fd_sc_hd__fill_2
XFILLER_122_735 VGND VGND VPWR VPWR sky130_fd_sc_hd__fill_2
XFILLER_122_757 VGND VGND VPWR VPWR sky130_fd_sc_hd__decap_3
XFILLER_134_595 VGND VGND VPWR VPWR sky130_fd_sc_hd__decap_3
XFILLER_122_779 VGND VGND VPWR VPWR sky130_fd_sc_hd__decap_3
XFILLER_95_608 VGND VGND VPWR VPWR sky130_fd_sc_hd__decap_3
XFILLER_0_597 VGND VGND VPWR VPWR sky130_fd_sc_hd__decap_3
XFILLER_130_790 VGND VGND VPWR VPWR sky130_fd_sc_hd__decap_3
XFILLER_87_181 VGND VGND VPWR VPWR sky130_fd_sc_hd__decap_3
XFILLER_48_579 VGND VGND VPWR VPWR sky130_fd_sc_hd__decap_3
XFILLER_57_85 VGND VGND VPWR VPWR sky130_fd_sc_hd__decap_3
XFILLER_63_505 VGND VGND VPWR VPWR sky130_fd_sc_hd__decap_3
XFILLER_75_376 VGND VGND VPWR VPWR sky130_fd_sc_hd__decap_3
XFILLER_16_421 VGND VGND VPWR VPWR sky130_fd_sc_hd__decap_3
XFILLER_44_730 VGND VGND VPWR VPWR sky130_fd_sc_hd__decap_3
XFILLER_90_335 VGND VGND VPWR VPWR sky130_fd_sc_hd__decap_3
XPHY_EDGE_ROW_121_Right_121 VGND VGND VPWR VPWR sky130_fd_sc_hd__decap_3
XFILLER_16_454 VGND VGND VPWR VPWR sky130_fd_sc_hd__fill_1
XFILLER_31_402 VGND VGND VPWR VPWR sky130_fd_sc_hd__fill_2
XFILLER_44_763 VGND VGND VPWR VPWR sky130_fd_sc_hd__fill_2
XFILLER_73_51 VGND VGND VPWR VPWR sky130_fd_sc_hd__decap_3
XFILLER_90_368 VGND VGND VPWR VPWR sky130_fd_sc_hd__fill_2
XFILLER_71_593 VGND VGND VPWR VPWR sky130_fd_sc_hd__fill_2
XTAP_TAPCELL_ROW_61_1141 VGND VPWR sky130_fd_sc_hd__tapvpwrvgnd_1
XFILLER_129_323 VGND VGND VPWR VPWR sky130_fd_sc_hd__decap_3
XFILLER_8_631 VGND VGND VPWR VPWR sky130_fd_sc_hd__decap_3
XTAP_TAPCELL_ROW_61_1152 VGND VPWR sky130_fd_sc_hd__tapvpwrvgnd_1
XFILLER_7_174 VGND VGND VPWR VPWR sky130_fd_sc_hd__fill_1
XFILLER_8_675 VGND VGND VPWR VPWR sky130_fd_sc_hd__decap_3
XTAP_TAPCELL_ROW_117_1930 VGND VPWR sky130_fd_sc_hd__tapvpwrvgnd_1
X_4370_ _3955_/A _4366_/X _4368_/X _4369_/X VGND VGND VPWR VPWR _4370_/X sky130_fd_sc_hd__a22o_2
XFILLER_112_223 VGND VGND VPWR VPWR sky130_fd_sc_hd__decap_3
XFILLER_112_256 VGND VGND VPWR VPWR sky130_fd_sc_hd__fill_2
XFILLER_85_107 VGND VGND VPWR VPWR sky130_fd_sc_hd__decap_3
Xclkbuf_4_12_0_CLK clkbuf_0_CLK/X VGND VGND VPWR VPWR clkbuf_4_12_0_CLK/X sky130_fd_sc_hd__clkbuf_8
X_6040_ _6040_/A VGND VGND VPWR VPWR _8086_/D sky130_fd_sc_hd__buf_1
XFILLER_78_170 VGND VGND VPWR VPWR sky130_fd_sc_hd__decap_3
XFILLER_79_682 VGND VGND VPWR VPWR sky130_fd_sc_hd__fill_1
XFILLER_94_630 VGND VGND VPWR VPWR sky130_fd_sc_hd__fill_2
XFILLER_66_332 VGND VGND VPWR VPWR sky130_fd_sc_hd__decap_3
XTAP_TAPCELL_ROW_1_306 VGND VPWR sky130_fd_sc_hd__tapvpwrvgnd_1
XFILLER_26_218 VGND VGND VPWR VPWR sky130_fd_sc_hd__decap_3
XFILLER_66_365 VGND VGND VPWR VPWR sky130_fd_sc_hd__decap_3
XFILLER_93_162 VGND VGND VPWR VPWR sky130_fd_sc_hd__decap_3
X_7991_ _8649_/CLK _7991_/D load_slew501/X VGND VGND VPWR VPWR _7991_/Q sky130_fd_sc_hd__dfrtp_2
XFILLER_19_281 VGND VGND VPWR VPWR sky130_fd_sc_hd__fill_1
XFILLER_81_335 VGND VGND VPWR VPWR sky130_fd_sc_hd__fill_1
X_6942_ _4819_/X _8510_/Q _6958_/S VGND VGND VPWR VPWR _6943_/A sky130_fd_sc_hd__mux2_4
X_6873_ _6873_/A VGND VGND VPWR VPWR _8477_/D sky130_fd_sc_hd__buf_6
XFILLER_50_733 VGND VGND VPWR VPWR sky130_fd_sc_hd__decap_3
XFILLER_62_582 VGND VGND VPWR VPWR sky130_fd_sc_hd__fill_2
X_8612_ _8757_/CLK _8612_/D load_slew742/X VGND VGND VPWR VPWR _8612_/Q sky130_fd_sc_hd__dfrtp_2
X_5824_ _7950_/Q _4891_/A _5826_/S VGND VGND VPWR VPWR _5825_/A sky130_fd_sc_hd__mux2_2
XFILLER_22_457 VGND VGND VPWR VPWR sky130_fd_sc_hd__decap_3
XFILLER_10_619 VGND VGND VPWR VPWR sky130_fd_sc_hd__decap_3
X_8543_ _8624_/CLK _8543_/D fanout652/X VGND VGND VPWR VPWR _8543_/Q sky130_fd_sc_hd__dfrtp_2
X_5755_ _7917_/Q _4753_/A _5763_/S VGND VGND VPWR VPWR _5756_/A sky130_fd_sc_hd__mux2_2
XTAP_TAPCELL_ROW_79_1402 VGND VPWR sky130_fd_sc_hd__tapvpwrvgnd_1
X_8474_ _8799_/CLK _8474_/D fanout601/X VGND VGND VPWR VPWR _8474_/Q sky130_fd_sc_hd__dfrtp_2
X_5686_ _7884_/Q _4957_/A _5700_/S VGND VGND VPWR VPWR _5687_/A sky130_fd_sc_hd__mux2_2
X_4706_ _4706_/A _4734_/B VGND VGND VPWR VPWR _4707_/A sky130_fd_sc_hd__and2_2
XFILLER_108_529 VGND VGND VPWR VPWR sky130_fd_sc_hd__decap_3
XFILLER_135_315 VGND VGND VPWR VPWR sky130_fd_sc_hd__decap_3
X_7425_ _7425_/A VGND VGND VPWR VPWR _8769_/D sky130_fd_sc_hd__buf_1
X_4637_ _4637_/A _4637_/B VGND VGND VPWR VPWR _4637_/X sky130_fd_sc_hd__or2_2
XFILLER_118_25 VGND VGND VPWR VPWR sky130_fd_sc_hd__decap_3
XFILLER_135_348 VGND VGND VPWR VPWR sky130_fd_sc_hd__decap_3
XFILLER_116_573 VGND VGND VPWR VPWR sky130_fd_sc_hd__decap_3
XTAP_TAPCELL_ROW_9_417 VGND VPWR sky130_fd_sc_hd__tapvpwrvgnd_1
X_7356_ _7356_/A VGND VGND VPWR VPWR _8736_/D sky130_fd_sc_hd__buf_1
X_4568_ _8124_/Q _8205_/Q _4568_/S VGND VGND VPWR VPWR _4569_/B sky130_fd_sc_hd__mux2_2
XFILLER_103_223 VGND VGND VPWR VPWR sky130_fd_sc_hd__fill_1
XFILLER_131_532 VGND VGND VPWR VPWR sky130_fd_sc_hd__decap_3
X_7287_ _7287_/A VGND VGND VPWR VPWR _8703_/D sky130_fd_sc_hd__buf_1
X_6307_ _6307_/A VGND VGND VPWR VPWR _8212_/D sky130_fd_sc_hd__buf_6
X_4499_ _8026_/Q _3816_/X _4652_/B1 _7945_/Q VGND VGND VPWR VPWR _4499_/X sky130_fd_sc_hd__o22a_2
XFILLER_131_576 VGND VGND VPWR VPWR sky130_fd_sc_hd__decap_3
XFILLER_134_24 VGND VGND VPWR VPWR sky130_fd_sc_hd__decap_3
XFILLER_134_35 VGND VGND VPWR VPWR sky130_fd_sc_hd__decap_3
X_6238_ _6238_/A VGND VGND VPWR VPWR _8179_/D sky130_fd_sc_hd__buf_6
XFILLER_134_68 VGND VGND VPWR VPWR sky130_fd_sc_hd__decap_3
X_6169_ _6169_/A VGND VGND VPWR VPWR _8146_/D sky130_fd_sc_hd__buf_6
XFILLER_85_641 VGND VGND VPWR VPWR sky130_fd_sc_hd__decap_3
XFILLER_85_663 VGND VGND VPWR VPWR sky130_fd_sc_hd__decap_3
XFILLER_27_33 VGND VGND VPWR VPWR sky130_fd_sc_hd__decap_3
XFILLER_84_173 VGND VGND VPWR VPWR sky130_fd_sc_hd__fill_1
XFILLER_27_66 VGND VGND VPWR VPWR sky130_fd_sc_hd__decap_3
XFILLER_84_195 VGND VGND VPWR VPWR sky130_fd_sc_hd__fill_1
XFILLER_26_763 VGND VGND VPWR VPWR sky130_fd_sc_hd__decap_3
XFILLER_41_700 VGND VGND VPWR VPWR sky130_fd_sc_hd__decap_3
XFILLER_72_357 VGND VGND VPWR VPWR sky130_fd_sc_hd__decap_3
XFILLER_72_368 VGND VGND VPWR VPWR sky130_fd_sc_hd__decap_3
XFILLER_25_284 VGND VGND VPWR VPWR sky130_fd_sc_hd__fill_2
XFILLER_13_435 VGND VGND VPWR VPWR sky130_fd_sc_hd__decap_3
XFILLER_43_43 VGND VGND VPWR VPWR sky130_fd_sc_hd__fill_2
XTAP_TAPCELL_ROW_36_791 VGND VPWR sky130_fd_sc_hd__tapvpwrvgnd_1
XFILLER_41_788 VGND VGND VPWR VPWR sky130_fd_sc_hd__decap_3
XFILLER_126_304 VGND VGND VPWR VPWR sky130_fd_sc_hd__decap_3
XFILLER_5_623 VGND VGND VPWR VPWR sky130_fd_sc_hd__decap_3
XFILLER_4_100 VGND VGND VPWR VPWR sky130_fd_sc_hd__decap_3
XFILLER_5_656 VGND VGND VPWR VPWR sky130_fd_sc_hd__decap_3
XTAP_TAPCELL_ROW_130_2116 VGND VPWR sky130_fd_sc_hd__tapvpwrvgnd_1
XFILLER_107_573 VGND VGND VPWR VPWR sky130_fd_sc_hd__fill_2
XFILLER_4_15 VGND VGND VPWR VPWR sky130_fd_sc_hd__decap_3
XFILLER_134_392 VGND VGND VPWR VPWR sky130_fd_sc_hd__decap_3
XFILLER_4_59 VGND VGND VPWR VPWR sky130_fd_sc_hd__decap_3
XTAP_TAPCELL_ROW_112_1860 VGND VPWR sky130_fd_sc_hd__tapvpwrvgnd_1
XFILLER_110_738 VGND VGND VPWR VPWR sky130_fd_sc_hd__decap_3
XFILLER_122_587 VGND VGND VPWR VPWR sky130_fd_sc_hd__fill_1
XFILLER_95_449 VGND VGND VPWR VPWR sky130_fd_sc_hd__decap_3
XFILLER_48_365 VGND VGND VPWR VPWR sky130_fd_sc_hd__decap_3
XFILLER_75_151 VGND VGND VPWR VPWR sky130_fd_sc_hd__decap_3
XFILLER_76_663 VGND VGND VPWR VPWR sky130_fd_sc_hd__fill_1
XFILLER_76_685 VGND VGND VPWR VPWR sky130_fd_sc_hd__decap_3
XFILLER_91_611 VGND VGND VPWR VPWR sky130_fd_sc_hd__decap_3
XTAP_TAPCELL_ROW_128_2078 VGND VPWR sky130_fd_sc_hd__tapvpwrvgnd_1
XTAP_TAPCELL_ROW_128_2089 VGND VPWR sky130_fd_sc_hd__tapvpwrvgnd_1
XFILLER_17_741 VGND VGND VPWR VPWR sky130_fd_sc_hd__decap_3
XFILLER_91_644 VGND VGND VPWR VPWR sky130_fd_sc_hd__decap_3
XFILLER_91_666 VGND VGND VPWR VPWR sky130_fd_sc_hd__decap_3
XFILLER_91_688 VGND VGND VPWR VPWR sky130_fd_sc_hd__decap_3
XFILLER_17_785 VGND VGND VPWR VPWR sky130_fd_sc_hd__fill_1
XFILLER_44_593 VGND VGND VPWR VPWR sky130_fd_sc_hd__decap_3
XFILLER_90_176 VGND VGND VPWR VPWR sky130_fd_sc_hd__decap_3
XFILLER_32_766 VGND VGND VPWR VPWR sky130_fd_sc_hd__fill_2
X_3870_ _3889_/A VGND VGND VPWR VPWR _3870_/X sky130_fd_sc_hd__clkbuf_2
XFILLER_129_131 VGND VGND VPWR VPWR sky130_fd_sc_hd__decap_3
XFILLER_31_287 VGND VGND VPWR VPWR sky130_fd_sc_hd__decap_3
XFILLER_31_298 VGND VGND VPWR VPWR sky130_fd_sc_hd__decap_3
XFILLER_76_3 VGND VGND VPWR VPWR sky130_fd_sc_hd__decap_3
XTAP_TAPCELL_ROW_14_485 VGND VPWR sky130_fd_sc_hd__tapvpwrvgnd_1
X_5540_ _5540_/A VGND VGND VPWR VPWR _7815_/D sky130_fd_sc_hd__buf_1
XFILLER_129_164 VGND VGND VPWR VPWR sky130_fd_sc_hd__decap_3
XFILLER_129_175 VGND VGND VPWR VPWR sky130_fd_sc_hd__decap_3
X_5471_ _5471_/A VGND VGND VPWR VPWR _7783_/D sky130_fd_sc_hd__buf_1
X_7210_ _7202_/X _4707_/X _7216_/A3 _7216_/B1 hold773/X VGND VGND VPWR VPWR _8645_/D
+ sky130_fd_sc_hd__a32o_2
X_4422_ _4455_/A _4420_/X _4421_/X VGND VGND VPWR VPWR _4422_/X sky130_fd_sc_hd__o21a_2
XFILLER_132_307 VGND VGND VPWR VPWR sky130_fd_sc_hd__fill_1
XFILLER_132_318 VGND VGND VPWR VPWR sky130_fd_sc_hd__decap_3
X_8190_ _8773_/CLK _8190_/D load_slew738/X VGND VGND VPWR VPWR _8190_/Q sky130_fd_sc_hd__dfrtp_2
XFILLER_98_210 VGND VGND VPWR VPWR sky130_fd_sc_hd__decap_3
XTAP_TAPCELL_ROW_74_1332 VGND VPWR sky130_fd_sc_hd__tapvpwrvgnd_1
X_7141_ _4875_/X _8604_/Q _7151_/S VGND VGND VPWR VPWR _7142_/A sky130_fd_sc_hd__mux2_2
X_4353_ _8014_/Q _3816_/X _4352_/X _4442_/A _4444_/A1 VGND VGND VPWR VPWR _4353_/X
+ sky130_fd_sc_hd__o221a_2
XFILLER_101_716 VGND VGND VPWR VPWR sky130_fd_sc_hd__fill_2
Xfanout407 _4272_/S VGND VGND VPWR VPWR _4140_/S sky130_fd_sc_hd__clkdlybuf4s25_1
Xfanout418 _4524_/S0 VGND VGND VPWR VPWR _4471_/S sky130_fd_sc_hd__clkdlybuf4s25_1
Xfanout429 fanout433/X VGND VGND VPWR VPWR _4550_/S sky130_fd_sc_hd__clkdlybuf4s25_1
X_7072_ _4735_/X _8571_/Q _7088_/S VGND VGND VPWR VPWR _7073_/A sky130_fd_sc_hd__mux2_2
X_4284_ _8099_/Q _8180_/Q _4320_/S VGND VGND VPWR VPWR _4285_/B sky130_fd_sc_hd__mux2_2
XFILLER_101_738 VGND VGND VPWR VPWR sky130_fd_sc_hd__decap_3
XFILLER_39_310 VGND VGND VPWR VPWR sky130_fd_sc_hd__fill_1
X_6023_ _6023_/A VGND VGND VPWR VPWR _8078_/D sky130_fd_sc_hd__buf_2
XFILLER_39_332 VGND VGND VPWR VPWR sky130_fd_sc_hd__decap_3
XFILLER_27_516 VGND VGND VPWR VPWR sky130_fd_sc_hd__decap_3
XFILLER_82_611 VGND VGND VPWR VPWR sky130_fd_sc_hd__decap_3
XFILLER_54_324 VGND VGND VPWR VPWR sky130_fd_sc_hd__decap_3
X_7974_ _8802_/CLK _7974_/D load_slew587/X VGND VGND VPWR VPWR _7974_/Q sky130_fd_sc_hd__dfrtp_2
X_6925_ _4787_/X _8502_/Q _6937_/S VGND VGND VPWR VPWR _6926_/A sky130_fd_sc_hd__mux2_4
XTAP_TAPCELL_ROW_85_1483 VGND VPWR sky130_fd_sc_hd__tapvpwrvgnd_1
XFILLER_22_243 VGND VGND VPWR VPWR sky130_fd_sc_hd__fill_1
X_6856_ _4989_/X _8469_/Q _6874_/S VGND VGND VPWR VPWR _6857_/A sky130_fd_sc_hd__mux2_4
XFILLER_13_24 VGND VGND VPWR VPWR sky130_fd_sc_hd__decap_3
XFILLER_23_788 VGND VGND VPWR VPWR sky130_fd_sc_hd__decap_3
XTAP_TAPCELL_ROW_33_750 VGND VPWR sky130_fd_sc_hd__tapvpwrvgnd_1
XTAP_TAPCELL_ROW_33_761 VGND VPWR sky130_fd_sc_hd__tapvpwrvgnd_1
X_3999_ _8072_/Q _8153_/Q _8234_/Q _8315_/Q _3996_/S _3993_/A VGND VGND VPWR VPWR
+ _4000_/B sky130_fd_sc_hd__mux4_2
X_6787_ _6787_/A VGND VGND VPWR VPWR _8437_/D sky130_fd_sc_hd__buf_2
X_5807_ _5849_/S VGND VGND VPWR VPWR _5826_/S sky130_fd_sc_hd__buf_2
XFILLER_129_24 VGND VGND VPWR VPWR sky130_fd_sc_hd__decap_3
XFILLER_13_57 VGND VGND VPWR VPWR sky130_fd_sc_hd__decap_3
XFILLER_22_298 VGND VGND VPWR VPWR sky130_fd_sc_hd__fill_1
X_8526_ _8688_/CLK _8526_/D fanout571/X VGND VGND VPWR VPWR _8526_/Q sky130_fd_sc_hd__dfrtp_2
X_5738_ _7909_/Q _4719_/A _5742_/S VGND VGND VPWR VPWR _5739_/A sky130_fd_sc_hd__mux2_2
XFILLER_129_57 VGND VGND VPWR VPWR sky130_fd_sc_hd__decap_3
XFILLER_135_134 VGND VGND VPWR VPWR sky130_fd_sc_hd__decap_3
X_8457_ _8781_/CLK _8457_/D fanout749/A VGND VGND VPWR VPWR _8457_/Q sky130_fd_sc_hd__dfrtp_2
X_5669_ _7877_/Q _4925_/A _5675_/S VGND VGND VPWR VPWR _5670_/A sky130_fd_sc_hd__mux2_2
XFILLER_135_156 VGND VGND VPWR VPWR sky130_fd_sc_hd__decap_3
XFILLER_135_178 VGND VGND VPWR VPWR sky130_fd_sc_hd__decap_3
XFILLER_2_604 VGND VGND VPWR VPWR sky130_fd_sc_hd__decap_3
X_8388_ _8712_/CLK _8388_/D load_slew689/X VGND VGND VPWR VPWR _8388_/Q sky130_fd_sc_hd__dfrtp_2
X_7408_ _7408_/A VGND VGND VPWR VPWR _8761_/D sky130_fd_sc_hd__buf_1
XFILLER_1_125 VGND VGND VPWR VPWR sky130_fd_sc_hd__fill_1
XFILLER_2_637 VGND VGND VPWR VPWR sky130_fd_sc_hd__decap_3
XFILLER_2_648 VGND VGND VPWR VPWR sky130_fd_sc_hd__decap_3
XFILLER_8_6 VGND VGND VPWR VPWR sky130_fd_sc_hd__decap_3
Xmax_cap180 _5947_/X VGND VGND VPWR VPWR _5958_/A2 sky130_fd_sc_hd__clkbuf_2
X_7339_ _7339_/A VGND VGND VPWR VPWR _8728_/D sky130_fd_sc_hd__buf_1
XFILLER_131_340 VGND VGND VPWR VPWR sky130_fd_sc_hd__decap_3
XFILLER_77_405 VGND VGND VPWR VPWR sky130_fd_sc_hd__fill_1
XFILLER_89_265 VGND VGND VPWR VPWR sky130_fd_sc_hd__decap_3
Xmax_cap191 _5870_/X VGND VGND VPWR VPWR _5879_/B1 sky130_fd_sc_hd__buf_2
XFILLER_104_587 VGND VGND VPWR VPWR sky130_fd_sc_hd__fill_1
XFILLER_1_169 VGND VGND VPWR VPWR sky130_fd_sc_hd__fill_2
XFILLER_38_21 VGND VGND VPWR VPWR sky130_fd_sc_hd__decap_3
XFILLER_89_287 VGND VGND VPWR VPWR sky130_fd_sc_hd__decap_3
XFILLER_18_516 VGND VGND VPWR VPWR sky130_fd_sc_hd__decap_3
XFILLER_38_76 VGND VGND VPWR VPWR sky130_fd_sc_hd__decap_3
XFILLER_92_408 VGND VGND VPWR VPWR sky130_fd_sc_hd__fill_1
XFILLER_26_582 VGND VGND VPWR VPWR sky130_fd_sc_hd__decap_3
XFILLER_54_75 VGND VGND VPWR VPWR sky130_fd_sc_hd__decap_3
XFILLER_72_165 VGND VGND VPWR VPWR sky130_fd_sc_hd__fill_1
XFILLER_14_744 VGND VGND VPWR VPWR sky130_fd_sc_hd__decap_3
XFILLER_9_214 VGND VGND VPWR VPWR sky130_fd_sc_hd__decap_3
XFILLER_9_225 VGND VGND VPWR VPWR sky130_fd_sc_hd__fill_1
XFILLER_70_52 VGND VGND VPWR VPWR sky130_fd_sc_hd__fill_2
XFILLER_70_85 VGND VGND VPWR VPWR sky130_fd_sc_hd__decap_3
XTAP_TAPCELL_ROW_11_444 VGND VPWR sky130_fd_sc_hd__tapvpwrvgnd_1
Xclkload17 _8736_/CLK VGND VGND VPWR VPWR clkload17/X sky130_fd_sc_hd__clkbuf_4
XFILLER_126_112 VGND VGND VPWR VPWR sky130_fd_sc_hd__decap_3
XFILLER_126_134 VGND VGND VPWR VPWR sky130_fd_sc_hd__decap_3
XFILLER_127_657 VGND VGND VPWR VPWR sky130_fd_sc_hd__decap_3
XFILLER_127_668 VGND VGND VPWR VPWR sky130_fd_sc_hd__decap_3
Xclkload28 _8728_/CLK VGND VGND VPWR VPWR clkload28/Y sky130_fd_sc_hd__bufinv_16
Xclkload39 _8795_/CLK VGND VGND VPWR VPWR clkload39/X sky130_fd_sc_hd__clkbuf_8
XFILLER_127_679 VGND VGND VPWR VPWR sky130_fd_sc_hd__decap_3
XFILLER_135_690 VGND VGND VPWR VPWR sky130_fd_sc_hd__decap_3
XTAP_TAPCELL_ROW_56_1073 VGND VPWR sky130_fd_sc_hd__tapvpwrvgnd_1
XFILLER_95_213 VGND VGND VPWR VPWR sky130_fd_sc_hd__decap_3
XFILLER_96_725 VGND VGND VPWR VPWR sky130_fd_sc_hd__decap_3
XFILLER_122_395 VGND VGND VPWR VPWR sky130_fd_sc_hd__fill_2
XFILLER_0_191 VGND VGND VPWR VPWR sky130_fd_sc_hd__decap_3
XFILLER_49_685 VGND VGND VPWR VPWR sky130_fd_sc_hd__decap_3
XFILLER_76_471 VGND VGND VPWR VPWR sky130_fd_sc_hd__decap_3
XFILLER_83_408 VGND VGND VPWR VPWR sky130_fd_sc_hd__decap_3
XFILLER_95_60 VGND VGND VPWR VPWR sky130_fd_sc_hd__decap_3
XFILLER_48_173 VGND VGND VPWR VPWR sky130_fd_sc_hd__decap_3
XFILLER_36_368 VGND VGND VPWR VPWR sky130_fd_sc_hd__decap_3
XFILLER_91_452 VGND VGND VPWR VPWR sky130_fd_sc_hd__decap_3
XTAP_TAPCELL_ROW_19_555 VGND VPWR sky130_fd_sc_hd__tapvpwrvgnd_1
XFILLER_64_699 VGND VGND VPWR VPWR sky130_fd_sc_hd__fill_1
XFILLER_91_496 VGND VGND VPWR VPWR sky130_fd_sc_hd__decap_3
X_4971_ _4971_/A VGND VGND VPWR VPWR _7563_/D sky130_fd_sc_hd__buf_1
XFILLER_51_349 VGND VGND VPWR VPWR sky130_fd_sc_hd__decap_3
X_3922_ _8633_/Q _4634_/A2 _4622_/B1 _8552_/Q _4465_/A VGND VGND VPWR VPWR _3922_/X
+ sky130_fd_sc_hd__o221a_2
X_7690_ _8782_/CLK _7690_/D load_slew642/X VGND VGND VPWR VPWR _7690_/Q sky130_fd_sc_hd__dfrtp_2
X_6710_ _6710_/A VGND VGND VPWR VPWR _8400_/D sky130_fd_sc_hd__buf_2
XFILLER_32_585 VGND VGND VPWR VPWR sky130_fd_sc_hd__decap_3
X_3853_ _4617_/A1 _3849_/X _3852_/X _3853_/C1 VGND VGND VPWR VPWR _3853_/X sky130_fd_sc_hd__a211o_2
X_6641_ _6641_/A VGND VGND VPWR VPWR _8369_/D sky130_fd_sc_hd__buf_2
XFILLER_20_736 VGND VGND VPWR VPWR sky130_fd_sc_hd__fill_2
XPHY_EDGE_ROW_4_Left_140 VGND VGND VPWR VPWR sky130_fd_sc_hd__decap_3
XFILLER_118_602 VGND VGND VPWR VPWR sky130_fd_sc_hd__decap_3
X_3784_ _3921_/A VGND VGND VPWR VPWR _3784_/X sky130_fd_sc_hd__clkbuf_2
X_8311_ _8712_/CLK _8311_/D fanout594/X VGND VGND VPWR VPWR _8311_/Q sky130_fd_sc_hd__dfrtp_2
X_6572_ _6656_/S VGND VGND VPWR VPWR _6591_/S sky130_fd_sc_hd__buf_4
X_5523_ _5523_/A VGND VGND VPWR VPWR _7807_/D sky130_fd_sc_hd__buf_1
XFILLER_118_679 VGND VGND VPWR VPWR sky130_fd_sc_hd__decap_3
X_8242_ _8728_/CLK _8242_/D fanout556/X VGND VGND VPWR VPWR _8242_/Q sky130_fd_sc_hd__dfrtp_2
X_5454_ _5454_/A VGND VGND VPWR VPWR _7775_/D sky130_fd_sc_hd__buf_1
XFILLER_117_178 VGND VGND VPWR VPWR sky130_fd_sc_hd__fill_1
XFILLER_132_115 VGND VGND VPWR VPWR sky130_fd_sc_hd__decap_3
XFILLER_133_638 VGND VGND VPWR VPWR sky130_fd_sc_hd__decap_3
X_8173_ _8748_/CLK _8173_/D fanout542/X VGND VGND VPWR VPWR _8173_/Q sky130_fd_sc_hd__dfrtp_2
X_5385_ _5385_/A VGND VGND VPWR VPWR _7742_/D sky130_fd_sc_hd__buf_1
X_4405_ _8109_/Q _8190_/Q _8271_/Q _8352_/Q _4402_/S _4415_/A VGND VGND VPWR VPWR
+ _4405_/X sky130_fd_sc_hd__mux4_2
XFILLER_132_159 VGND VGND VPWR VPWR sky130_fd_sc_hd__decap_3
Xclkbuf_leaf_141_CLK clkbuf_5_4__f_CLK/X VGND VGND VPWR VPWR _8657_/CLK sky130_fd_sc_hd__clkbuf_8
X_7124_ _4841_/X _8596_/Q _7130_/S VGND VGND VPWR VPWR _7125_/A sky130_fd_sc_hd__mux2_2
X_4336_ _4252_/A _4333_/X _4335_/X _4336_/C1 VGND VGND VPWR VPWR _4336_/X sky130_fd_sc_hd__o211a_2
XFILLER_115_15 VGND VGND VPWR VPWR sky130_fd_sc_hd__fill_2
XFILLER_99_585 VGND VGND VPWR VPWR sky130_fd_sc_hd__decap_3
XFILLER_86_235 VGND VGND VPWR VPWR sky130_fd_sc_hd__decap_3
X_7055_ _4703_/X _8563_/Q _7067_/S VGND VGND VPWR VPWR _7056_/A sky130_fd_sc_hd__mux2_2
X_4267_ _8007_/Q _4350_/A2 _4160_/B _7926_/Q _4336_/C1 VGND VGND VPWR VPWR _4267_/X
+ sky130_fd_sc_hd__o221a_2
XFILLER_101_579 VGND VGND VPWR VPWR sky130_fd_sc_hd__decap_3
X_6006_ _6006_/A VGND VGND VPWR VPWR _8070_/D sky130_fd_sc_hd__buf_1
X_4198_ _4198_/A _4198_/B VGND VGND VPWR VPWR _4198_/X sky130_fd_sc_hd__or2_2
XFILLER_27_335 VGND VGND VPWR VPWR sky130_fd_sc_hd__fill_1
XFILLER_82_430 VGND VGND VPWR VPWR sky130_fd_sc_hd__decap_3
XTAP_TAPCELL_ROW_38_820 VGND VPWR sky130_fd_sc_hd__tapvpwrvgnd_1
XTAP_TAPCELL_ROW_38_831 VGND VPWR sky130_fd_sc_hd__tapvpwrvgnd_1
XTAP_TAPCELL_ROW_87_1512 VGND VPWR sky130_fd_sc_hd__tapvpwrvgnd_1
XFILLER_131_36 VGND VGND VPWR VPWR sky130_fd_sc_hd__decap_3
XFILLER_15_508 VGND VGND VPWR VPWR sky130_fd_sc_hd__decap_3
XFILLER_82_463 VGND VGND VPWR VPWR sky130_fd_sc_hd__decap_3
XFILLER_131_69 VGND VGND VPWR VPWR sky130_fd_sc_hd__decap_3
XFILLER_82_485 VGND VGND VPWR VPWR sky130_fd_sc_hd__decap_3
XFILLER_91_29 VGND VGND VPWR VPWR sky130_fd_sc_hd__decap_3
X_7957_ _8698_/CLK _7957_/D load_slew748/X VGND VGND VPWR VPWR _7957_/Q sky130_fd_sc_hd__dfrtp_2
XFILLER_23_541 VGND VGND VPWR VPWR sky130_fd_sc_hd__decap_3
XFILLER_24_12 VGND VGND VPWR VPWR sky130_fd_sc_hd__decap_3
X_7888_ _8789_/CLK _7888_/D wire680/X VGND VGND VPWR VPWR _7888_/Q sky130_fd_sc_hd__dfrtp_2
X_6908_ _4753_/X _8494_/Q _6916_/S VGND VGND VPWR VPWR _6909_/A sky130_fd_sc_hd__mux2_4
XFILLER_24_56 VGND VGND VPWR VPWR sky130_fd_sc_hd__decap_3
XPHY_EDGE_ROW_59_Left_195 VGND VGND VPWR VPWR sky130_fd_sc_hd__decap_3
X_6839_ _4957_/X _8461_/Q _6853_/S VGND VGND VPWR VPWR _6840_/A sky130_fd_sc_hd__mux2_4
XFILLER_11_747 VGND VGND VPWR VPWR sky130_fd_sc_hd__decap_3
XFILLER_23_585 VGND VGND VPWR VPWR sky130_fd_sc_hd__decap_3
XFILLER_109_613 VGND VGND VPWR VPWR sky130_fd_sc_hd__decap_3
XFILLER_10_246 VGND VGND VPWR VPWR sky130_fd_sc_hd__decap_3
XFILLER_7_718 VGND VGND VPWR VPWR sky130_fd_sc_hd__decap_3
XFILLER_7_729 VGND VGND VPWR VPWR sky130_fd_sc_hd__decap_3
Xwire638 wire638/A VGND VGND VPWR VPWR wire638/X sky130_fd_sc_hd__clkbuf_4
XFILLER_109_657 VGND VGND VPWR VPWR sky130_fd_sc_hd__fill_1
XFILLER_6_239 VGND VGND VPWR VPWR sky130_fd_sc_hd__fill_1
XTAP_TAPCELL_ROW_98_1663 VGND VPWR sky130_fd_sc_hd__tapvpwrvgnd_1
X_8509_ _8712_/CLK _8509_/D load_slew689/X VGND VGND VPWR VPWR _8509_/Q sky130_fd_sc_hd__dfrtp_2
XFILLER_109_679 VGND VGND VPWR VPWR sky130_fd_sc_hd__decap_3
XFILLER_123_159 VGND VGND VPWR VPWR sky130_fd_sc_hd__decap_3
XFILLER_49_20 VGND VGND VPWR VPWR sky130_fd_sc_hd__decap_3
XFILLER_6_3 VGND VGND VPWR VPWR sky130_fd_sc_hd__decap_3
Xclkbuf_leaf_132_CLK clkbuf_5_4__f_CLK/X VGND VGND VPWR VPWR _8660_/CLK sky130_fd_sc_hd__clkbuf_8
XFILLER_132_660 VGND VGND VPWR VPWR sky130_fd_sc_hd__decap_3
XFILLER_131_181 VGND VGND VPWR VPWR sky130_fd_sc_hd__decap_3
XFILLER_132_693 VGND VGND VPWR VPWR sky130_fd_sc_hd__decap_3
XFILLER_1_27 VGND VGND VPWR VPWR sky130_fd_sc_hd__decap_3
XFILLER_58_460 VGND VGND VPWR VPWR sky130_fd_sc_hd__decap_3
XFILLER_46_622 VGND VGND VPWR VPWR sky130_fd_sc_hd__decap_3
XFILLER_65_41 VGND VGND VPWR VPWR sky130_fd_sc_hd__fill_2
XTAP_TAPCELL_ROW_125_2037 VGND VPWR sky130_fd_sc_hd__tapvpwrvgnd_1
XTAP_TAPCELL_ROW_125_2048 VGND VPWR sky130_fd_sc_hd__tapvpwrvgnd_1
XFILLER_18_368 VGND VGND VPWR VPWR sky130_fd_sc_hd__fill_1
XFILLER_45_143 VGND VGND VPWR VPWR sky130_fd_sc_hd__fill_1
XFILLER_45_165 VGND VGND VPWR VPWR sky130_fd_sc_hd__decap_3
XFILLER_45_187 VGND VGND VPWR VPWR sky130_fd_sc_hd__decap_3
XFILLER_46_699 VGND VGND VPWR VPWR sky130_fd_sc_hd__fill_1
XTAP_TAPCELL_ROW_16_514 VGND VPWR sky130_fd_sc_hd__tapvpwrvgnd_1
XFILLER_60_124 VGND VGND VPWR VPWR sky130_fd_sc_hd__decap_3
XFILLER_61_658 VGND VGND VPWR VPWR sky130_fd_sc_hd__fill_2
XTAP_TAPCELL_ROW_107_1792 VGND VPWR sky130_fd_sc_hd__tapvpwrvgnd_1
XFILLER_41_393 VGND VGND VPWR VPWR sky130_fd_sc_hd__decap_3
XTAP_TAPCELL_ROW_120_1970 VGND VPWR sky130_fd_sc_hd__tapvpwrvgnd_1
XFILLER_127_476 VGND VGND VPWR VPWR sky130_fd_sc_hd__decap_3
XFILLER_6_740 VGND VGND VPWR VPWR sky130_fd_sc_hd__decap_3
XTAP_TAPCELL_ROW_58_1102 VGND VPWR sky130_fd_sc_hd__tapvpwrvgnd_1
XFILLER_115_638 VGND VGND VPWR VPWR sky130_fd_sc_hd__fill_1
XFILLER_5_261 VGND VGND VPWR VPWR sky130_fd_sc_hd__decap_3
XFILLER_5_272 VGND VGND VPWR VPWR sky130_fd_sc_hd__decap_3
XFILLER_6_784 VGND VGND VPWR VPWR sky130_fd_sc_hd__decap_3
XFILLER_130_619 VGND VGND VPWR VPWR sky130_fd_sc_hd__decap_3
XFILLER_68_213 VGND VGND VPWR VPWR sky130_fd_sc_hd__decap_3
XFILLER_96_511 VGND VGND VPWR VPWR sky130_fd_sc_hd__decap_3
Xclkbuf_leaf_123_CLK clkload6/A VGND VGND VPWR VPWR _8669_/CLK sky130_fd_sc_hd__clkbuf_8
X_5170_ _7641_/Q _4957_/X _5184_/S VGND VGND VPWR VPWR _5171_/A sky130_fd_sc_hd__mux2_2
XFILLER_122_181 VGND VGND VPWR VPWR sky130_fd_sc_hd__decap_3
XFILLER_69_747 VGND VGND VPWR VPWR sky130_fd_sc_hd__fill_1
XFILLER_96_533 VGND VGND VPWR VPWR sky130_fd_sc_hd__decap_3
XFILLER_96_555 VGND VGND VPWR VPWR sky130_fd_sc_hd__decap_3
X_4121_ _4129_/A _4118_/X _4120_/X _3976_/X VGND VGND VPWR VPWR _4121_/X sky130_fd_sc_hd__o211a_2
XFILLER_110_354 VGND VGND VPWR VPWR sky130_fd_sc_hd__decap_3
XFILLER_110_365 VGND VGND VPWR VPWR sky130_fd_sc_hd__decap_3
X_4052_ _8726_/Q _7501_/Q _7582_/Q _7663_/Q _4098_/S0 _4036_/A VGND VGND VPWR VPWR
+ _4053_/B sky130_fd_sc_hd__mux4_2
XFILLER_37_611 VGND VGND VPWR VPWR sky130_fd_sc_hd__decap_3
XFILLER_49_482 VGND VGND VPWR VPWR sky130_fd_sc_hd__decap_3
XFILLER_83_216 VGND VGND VPWR VPWR sky130_fd_sc_hd__decap_3
Xinput4 wdata[10] VGND VGND VPWR VPWR input4/X sky130_fd_sc_hd__clkdlybuf4s25_1
XTAP_TAPCELL_ROW_69_1253 VGND VPWR sky130_fd_sc_hd__tapvpwrvgnd_1
XTAP_TAPCELL_ROW_69_1264 VGND VPWR sky130_fd_sc_hd__tapvpwrvgnd_1
XFILLER_37_688 VGND VGND VPWR VPWR sky130_fd_sc_hd__fill_1
XFILLER_52_614 VGND VGND VPWR VPWR sky130_fd_sc_hd__decap_3
XFILLER_64_485 VGND VGND VPWR VPWR sky130_fd_sc_hd__fill_2
X_8791_ _8791_/CLK _8791_/D fanout665/X VGND VGND VPWR VPWR _8791_/Q sky130_fd_sc_hd__dfrtp_2
X_7811_ _8712_/CLK _7811_/D load_slew589/X VGND VGND VPWR VPWR _7811_/Q sky130_fd_sc_hd__dfrtp_2
XFILLER_101_28 VGND VGND VPWR VPWR sky130_fd_sc_hd__decap_3
XFILLER_91_293 VGND VGND VPWR VPWR sky130_fd_sc_hd__decap_3
X_7742_ _8724_/CLK _7742_/D load_slew503/X VGND VGND VPWR VPWR _7742_/Q sky130_fd_sc_hd__dfrtp_2
X_4954_ _4953_/X _7559_/Q _4986_/S VGND VGND VPWR VPWR _4955_/A sky130_fd_sc_hd__mux2_2
XTAP_TAPCELL_ROW_82_1442 VGND VPWR sky130_fd_sc_hd__tapvpwrvgnd_1
X_3905_ _3910_/A _3903_/X _3904_/X VGND VGND VPWR VPWR _3905_/X sky130_fd_sc_hd__o21a_2
X_7673_ _8736_/CLK _7673_/D load_slew480/X VGND VGND VPWR VPWR _7673_/Q sky130_fd_sc_hd__dfrtp_2
X_4885_ _4885_/A VGND VGND VPWR VPWR _7543_/D sky130_fd_sc_hd__buf_1
X_3836_ _3834_/X _3835_/X _3875_/A VGND VGND VPWR VPWR _3836_/X sky130_fd_sc_hd__mux2_2
X_6624_ _6624_/A VGND VGND VPWR VPWR _8361_/D sky130_fd_sc_hd__buf_2
XFILLER_118_421 VGND VGND VPWR VPWR sky130_fd_sc_hd__decap_3
X_3767_ _3767_/A VGND VGND VPWR VPWR _4326_/B sky130_fd_sc_hd__clkbuf_2
X_6555_ _6555_/A VGND VGND VPWR VPWR _8328_/D sky130_fd_sc_hd__buf_2
X_5506_ _5506_/A VGND VGND VPWR VPWR _7800_/D sky130_fd_sc_hd__buf_1
XFILLER_118_498 VGND VGND VPWR VPWR sky130_fd_sc_hd__decap_3
XFILLER_133_402 VGND VGND VPWR VPWR sky130_fd_sc_hd__decap_3
XFILLER_133_435 VGND VGND VPWR VPWR sky130_fd_sc_hd__decap_3
X_8225_ _8387_/CLK _8225_/D wire631/X VGND VGND VPWR VPWR _8225_/Q sky130_fd_sc_hd__dfrtp_2
X_6486_ _8050_/Q _6486_/B _7004_/D VGND VGND VPWR VPWR _6487_/A sky130_fd_sc_hd__or3_2
XFILLER_10_47 VGND VGND VPWR VPWR sky130_fd_sc_hd__decap_3
X_5437_ _5437_/A VGND VGND VPWR VPWR _7767_/D sky130_fd_sc_hd__buf_1
XFILLER_126_47 VGND VGND VPWR VPWR sky130_fd_sc_hd__decap_3
XFILLER_133_479 VGND VGND VPWR VPWR sky130_fd_sc_hd__decap_3
XTAP_TAPCELL_ROW_93_1593 VGND VPWR sky130_fd_sc_hd__tapvpwrvgnd_1
Xclkbuf_leaf_114_CLK clkbuf_5_17__f_CLK/X VGND VGND VPWR VPWR _8751_/CLK sky130_fd_sc_hd__clkbuf_8
X_8156_ _8328_/CLK _8156_/D wire476/X VGND VGND VPWR VPWR _8156_/Q sky130_fd_sc_hd__dfrtp_2
X_5368_ _5368_/A VGND VGND VPWR VPWR _7734_/D sky130_fd_sc_hd__buf_1
XFILLER_101_332 VGND VGND VPWR VPWR sky130_fd_sc_hd__decap_3
XFILLER_19_12 VGND VGND VPWR VPWR sky130_fd_sc_hd__decap_3
XFILLER_99_393 VGND VGND VPWR VPWR sky130_fd_sc_hd__decap_3
X_8087_ _8647_/CLK _8087_/D fanout532/X VGND VGND VPWR VPWR _8087_/Q sky130_fd_sc_hd__dfrtp_2
X_7107_ _4807_/X hold942/X _7109_/S VGND VGND VPWR VPWR _7108_/A sky130_fd_sc_hd__mux2_1
X_5299_ _5299_/A VGND VGND VPWR VPWR _7702_/D sky130_fd_sc_hd__buf_1
X_4319_ _7606_/Q _4660_/A2 _4318_/X VGND VGND VPWR VPWR _4319_/X sky130_fd_sc_hd__o21a_2
XFILLER_19_45 VGND VGND VPWR VPWR sky130_fd_sc_hd__decap_3
XFILLER_59_257 VGND VGND VPWR VPWR sky130_fd_sc_hd__fill_1
XFILLER_75_706 VGND VGND VPWR VPWR sky130_fd_sc_hd__decap_3
XFILLER_75_717 VGND VGND VPWR VPWR sky130_fd_sc_hd__decap_3
X_7038_ _5011_/X _8555_/Q _7046_/S VGND VGND VPWR VPWR _7039_/A sky130_fd_sc_hd__mux2_2
XFILLER_19_78 VGND VGND VPWR VPWR sky130_fd_sc_hd__decap_3
XFILLER_27_121 VGND VGND VPWR VPWR sky130_fd_sc_hd__decap_3
XFILLER_74_249 VGND VGND VPWR VPWR sky130_fd_sc_hd__decap_3
XFILLER_15_305 VGND VGND VPWR VPWR sky130_fd_sc_hd__decap_3
XFILLER_15_316 VGND VGND VPWR VPWR sky130_fd_sc_hd__fill_2
XFILLER_27_154 VGND VGND VPWR VPWR sky130_fd_sc_hd__decap_3
XFILLER_83_794 VGND VGND VPWR VPWR sky130_fd_sc_hd__fill_2
XFILLER_27_198 VGND VGND VPWR VPWR sky130_fd_sc_hd__decap_3
XFILLER_42_113 VGND VGND VPWR VPWR sky130_fd_sc_hd__decap_3
XFILLER_55_496 VGND VGND VPWR VPWR sky130_fd_sc_hd__decap_3
XFILLER_70_433 VGND VGND VPWR VPWR sky130_fd_sc_hd__decap_3
XPHY_EDGE_ROW_67_Left_203 VGND VGND VPWR VPWR sky130_fd_sc_hd__decap_3
XFILLER_35_99 VGND VGND VPWR VPWR sky130_fd_sc_hd__fill_1
XFILLER_70_477 VGND VGND VPWR VPWR sky130_fd_sc_hd__decap_3
XFILLER_11_500 VGND VGND VPWR VPWR sky130_fd_sc_hd__decap_3
XFILLER_11_511 VGND VGND VPWR VPWR sky130_fd_sc_hd__fill_2
XFILLER_11_522 VGND VGND VPWR VPWR sky130_fd_sc_hd__decap_3
XFILLER_128_218 VGND VGND VPWR VPWR sky130_fd_sc_hd__decap_3
XFILLER_51_43 VGND VGND VPWR VPWR sky130_fd_sc_hd__decap_3
XFILLER_7_526 VGND VGND VPWR VPWR sky130_fd_sc_hd__decap_3
XFILLER_109_465 VGND VGND VPWR VPWR sky130_fd_sc_hd__fill_1
XFILLER_7_559 VGND VGND VPWR VPWR sky130_fd_sc_hd__fill_1
XTAP_TAPCELL_ROW_21_583 VGND VPWR sky130_fd_sc_hd__tapvpwrvgnd_1
XFILLER_109_487 VGND VGND VPWR VPWR sky130_fd_sc_hd__fill_2
XFILLER_124_424 VGND VGND VPWR VPWR sky130_fd_sc_hd__decap_3
XFILLER_3_721 VGND VGND VPWR VPWR sky130_fd_sc_hd__decap_3
XPHY_EDGE_ROW_76_Left_212 VGND VGND VPWR VPWR sky130_fd_sc_hd__decap_3
XFILLER_124_457 VGND VGND VPWR VPWR sky130_fd_sc_hd__fill_1
XFILLER_3_732 VGND VGND VPWR VPWR sky130_fd_sc_hd__decap_3
XFILLER_105_671 VGND VGND VPWR VPWR sky130_fd_sc_hd__fill_1
XFILLER_105_682 VGND VGND VPWR VPWR sky130_fd_sc_hd__decap_3
XFILLER_3_765 VGND VGND VPWR VPWR sky130_fd_sc_hd__decap_3
XFILLER_78_511 VGND VGND VPWR VPWR sky130_fd_sc_hd__fill_2
Xclkbuf_leaf_105_CLK clkbuf_5_20__f_CLK/X VGND VGND VPWR VPWR _8786_/CLK sky130_fd_sc_hd__clkbuf_8
XFILLER_78_533 VGND VGND VPWR VPWR sky130_fd_sc_hd__fill_1
XTAP_TAPCELL_ROW_53_1032 VGND VPWR sky130_fd_sc_hd__tapvpwrvgnd_1
Xclkbuf_5_17__f_CLK clkbuf_4_8_0_CLK/X VGND VGND VPWR VPWR clkbuf_5_17__f_CLK/X sky130_fd_sc_hd__clkbuf_16
XFILLER_25_9 VGND VGND VPWR VPWR sky130_fd_sc_hd__decap_3
XFILLER_66_728 VGND VGND VPWR VPWR sky130_fd_sc_hd__decap_3
XFILLER_93_536 VGND VGND VPWR VPWR sky130_fd_sc_hd__decap_3
XTAP_TAPCELL_ROW_109_1821 VGND VPWR sky130_fd_sc_hd__tapvpwrvgnd_1
Xfanout590 fanout594/X VGND VGND VPWR VPWR fanout590/X sky130_fd_sc_hd__clkdlybuf4s25_1
XFILLER_74_750 VGND VGND VPWR VPWR sky130_fd_sc_hd__fill_1
XFILLER_18_154 VGND VGND VPWR VPWR sky130_fd_sc_hd__decap_3
XPHY_EDGE_ROW_85_Left_221 VGND VGND VPWR VPWR sky130_fd_sc_hd__decap_3
XFILLER_33_113 VGND VGND VPWR VPWR sky130_fd_sc_hd__decap_3
XTAP_TAPCELL_ROW_29_694 VGND VPWR sky130_fd_sc_hd__tapvpwrvgnd_1
XFILLER_61_477 VGND VGND VPWR VPWR sky130_fd_sc_hd__fill_2
XFILLER_92_83 VGND VGND VPWR VPWR sky130_fd_sc_hd__fill_1
XFILLER_14_371 VGND VGND VPWR VPWR sky130_fd_sc_hd__decap_3
XTAP_TAPCELL_ROW_64_1183 VGND VPWR sky130_fd_sc_hd__tapvpwrvgnd_1
XTAP_TAPCELL_ROW_64_1194 VGND VPWR sky130_fd_sc_hd__tapvpwrvgnd_1
XFILLER_119_207 VGND VGND VPWR VPWR sky130_fd_sc_hd__decap_3
X_4670_ _8781_/Q _7556_/Q _7637_/Q _7718_/Q _4670_/S0 _4651_/A VGND VGND VPWR VPWR
+ _4670_/X sky130_fd_sc_hd__mux4_2
XFILLER_127_240 VGND VGND VPWR VPWR sky130_fd_sc_hd__decap_3
XFILLER_128_752 VGND VGND VPWR VPWR sky130_fd_sc_hd__decap_3
XFILLER_128_763 VGND VGND VPWR VPWR sky130_fd_sc_hd__decap_3
XPHY_EDGE_ROW_94_Left_230 VGND VGND VPWR VPWR sky130_fd_sc_hd__decap_3
X_6340_ _4995_/X hold944/X _6356_/S VGND VGND VPWR VPWR _6341_/A sky130_fd_sc_hd__mux2_1
XFILLER_128_796 VGND VGND VPWR VPWR sky130_fd_sc_hd__decap_3
XFILLER_6_592 VGND VGND VPWR VPWR sky130_fd_sc_hd__decap_3
X_6271_ _4857_/X _8195_/Q _6289_/S VGND VGND VPWR VPWR _6272_/A sky130_fd_sc_hd__mux2_4
XFILLER_130_427 VGND VGND VPWR VPWR sky130_fd_sc_hd__decap_3
X_8010_ _8749_/CLK _8010_/D load_slew623/X VGND VGND VPWR VPWR _8010_/Q sky130_fd_sc_hd__dfrtp_2
X_5222_ _7666_/Q _7063_/A0 _5226_/S VGND VGND VPWR VPWR _5223_/A sky130_fd_sc_hd__mux2_2
XFILLER_69_544 VGND VGND VPWR VPWR sky130_fd_sc_hd__decap_3
XFILLER_96_330 VGND VGND VPWR VPWR sky130_fd_sc_hd__decap_3
XPHY_EDGE_ROW_135_Right_135 VGND VGND VPWR VPWR sky130_fd_sc_hd__decap_3
X_5153_ _5153_/A VGND VGND VPWR VPWR _7634_/D sky130_fd_sc_hd__buf_1
XFILLER_111_641 VGND VGND VPWR VPWR sky130_fd_sc_hd__decap_3
XFILLER_57_706 VGND VGND VPWR VPWR sky130_fd_sc_hd__fill_2
X_4104_ _4101_/X _4102_/X _4103_/X _4104_/B2 _4300_/A1 VGND VGND VPWR VPWR _4104_/X
+ sky130_fd_sc_hd__a221o_2
XFILLER_110_173 VGND VGND VPWR VPWR sky130_fd_sc_hd__fill_2
XFILLER_84_547 VGND VGND VPWR VPWR sky130_fd_sc_hd__fill_1
XFILLER_96_374 VGND VGND VPWR VPWR sky130_fd_sc_hd__decap_3
X_5084_ _5084_/A VGND VGND VPWR VPWR _7601_/D sky130_fd_sc_hd__buf_1
XFILLER_37_452 VGND VGND VPWR VPWR sky130_fd_sc_hd__decap_3
XFILLER_49_290 VGND VGND VPWR VPWR sky130_fd_sc_hd__fill_1
X_4035_ _8724_/Q _7499_/Q _4035_/S VGND VGND VPWR VPWR _4036_/B sky130_fd_sc_hd__mux2_2
XFILLER_112_27 VGND VGND VPWR VPWR sky130_fd_sc_hd__fill_1
XFILLER_65_783 VGND VGND VPWR VPWR sky130_fd_sc_hd__fill_1
XFILLER_71_208 VGND VGND VPWR VPWR sky130_fd_sc_hd__decap_3
XTAP_TAPCELL_ROW_48_970 VGND VPWR sky130_fd_sc_hd__tapvpwrvgnd_1
XFILLER_25_658 VGND VGND VPWR VPWR sky130_fd_sc_hd__decap_3
XFILLER_52_455 VGND VGND VPWR VPWR sky130_fd_sc_hd__decap_3
X_8774_ _8777_/CLK _8774_/D fanout743/X VGND VGND VPWR VPWR _8774_/Q sky130_fd_sc_hd__dfrtp_2
X_5986_ _8061_/Q _4976_/A _5990_/S VGND VGND VPWR VPWR _5987_/A sky130_fd_sc_hd__mux2_2
XFILLER_40_628 VGND VGND VPWR VPWR sky130_fd_sc_hd__decap_3
X_7725_ _8710_/CLK _7725_/D load_slew663/X VGND VGND VPWR VPWR _7725_/Q sky130_fd_sc_hd__dfrtp_2
X_4937_ _4937_/A VGND VGND VPWR VPWR _4937_/X sky130_fd_sc_hd__buf_1
X_7656_ _8470_/CLK _7656_/D load_slew591/X VGND VGND VPWR VPWR _7656_/Q sky130_fd_sc_hd__dfrtp_2
X_4868_ _4866_/X hold996/X _4896_/S VGND VGND VPWR VPWR _4869_/A sky130_fd_sc_hd__mux2_2
XFILLER_119_741 VGND VGND VPWR VPWR sky130_fd_sc_hd__fill_1
XFILLER_20_352 VGND VGND VPWR VPWR sky130_fd_sc_hd__fill_2
X_3819_ _4525_/S VGND VGND VPWR VPWR _3819_/X sky130_fd_sc_hd__clkbuf_2
X_6607_ _6607_/A VGND VGND VPWR VPWR _8353_/D sky130_fd_sc_hd__buf_2
XFILLER_118_251 VGND VGND VPWR VPWR sky130_fd_sc_hd__fill_1
XFILLER_119_763 VGND VGND VPWR VPWR sky130_fd_sc_hd__decap_3
XFILLER_20_396 VGND VGND VPWR VPWR sky130_fd_sc_hd__fill_2
XFILLER_21_24 VGND VGND VPWR VPWR sky130_fd_sc_hd__decap_3
XTAP_TAPCELL_ROW_95_1622 VGND VPWR sky130_fd_sc_hd__tapvpwrvgnd_1
X_7587_ _8569_/CLK _7587_/D load_slew494/X VGND VGND VPWR VPWR _7587_/Q sky130_fd_sc_hd__dfrtp_2
X_4799_ _4799_/A VGND VGND VPWR VPWR _4799_/X sky130_fd_sc_hd__buf_1
XFILLER_106_402 VGND VGND VPWR VPWR sky130_fd_sc_hd__decap_3
XFILLER_119_785 VGND VGND VPWR VPWR sky130_fd_sc_hd__fill_2
XFILLER_134_722 VGND VGND VPWR VPWR sky130_fd_sc_hd__decap_3
XFILLER_21_57 VGND VGND VPWR VPWR sky130_fd_sc_hd__decap_3
X_6538_ _6538_/A VGND VGND VPWR VPWR _8320_/D sky130_fd_sc_hd__buf_2
XFILLER_133_243 VGND VGND VPWR VPWR sky130_fd_sc_hd__decap_3
XFILLER_134_755 VGND VGND VPWR VPWR sky130_fd_sc_hd__fill_1
XFILLER_134_766 VGND VGND VPWR VPWR sky130_fd_sc_hd__decap_3
X_6469_ _6469_/A VGND VGND VPWR VPWR _8288_/D sky130_fd_sc_hd__buf_2
XFILLER_0_713 VGND VGND VPWR VPWR sky130_fd_sc_hd__decap_3
XFILLER_121_405 VGND VGND VPWR VPWR sky130_fd_sc_hd__decap_3
XFILLER_133_276 VGND VGND VPWR VPWR sky130_fd_sc_hd__decap_3
XFILLER_134_799 VGND VGND VPWR VPWR sky130_fd_sc_hd__decap_3
Xoutput160 _4640_/X VGND VGND VPWR VPWR rdata[76] sky130_fd_sc_hd__clkdlybuf4s25_1
X_8208_ _8775_/CLK _8208_/D fanout726/X VGND VGND VPWR VPWR _8208_/Q sky130_fd_sc_hd__dfrtp_2
XFILLER_0_735 VGND VGND VPWR VPWR sky130_fd_sc_hd__decap_3
XFILLER_114_490 VGND VGND VPWR VPWR sky130_fd_sc_hd__fill_1
XFILLER_121_438 VGND VGND VPWR VPWR sky130_fd_sc_hd__fill_1
XFILLER_121_449 VGND VGND VPWR VPWR sky130_fd_sc_hd__decap_3
XFILLER_133_287 VGND VGND VPWR VPWR sky130_fd_sc_hd__decap_3
X_8139_ _8382_/CLK _8139_/D load_slew678/X VGND VGND VPWR VPWR _8139_/Q sky130_fd_sc_hd__dfrtp_2
XFILLER_0_757 VGND VGND VPWR VPWR sky130_fd_sc_hd__decap_3
XFILLER_102_674 VGND VGND VPWR VPWR sky130_fd_sc_hd__decap_3
XPHY_EDGE_ROW_102_Right_102 VGND VGND VPWR VPWR sky130_fd_sc_hd__decap_3
XTAP_TAPCELL_ROW_7_389 VGND VPWR sky130_fd_sc_hd__tapvpwrvgnd_1
XFILLER_87_385 VGND VGND VPWR VPWR sky130_fd_sc_hd__decap_3
XFILLER_43_400 VGND VGND VPWR VPWR sky130_fd_sc_hd__decap_3
XFILLER_90_528 VGND VGND VPWR VPWR sky130_fd_sc_hd__decap_3
XFILLER_90_539 VGND VGND VPWR VPWR sky130_fd_sc_hd__decap_3
XTAP_TAPCELL_ROW_122_2007 VGND VPWR sky130_fd_sc_hd__tapvpwrvgnd_1
XFILLER_15_113 VGND VGND VPWR VPWR sky130_fd_sc_hd__decap_3
XFILLER_16_636 VGND VGND VPWR VPWR sky130_fd_sc_hd__decap_3
XFILLER_55_293 VGND VGND VPWR VPWR sky130_fd_sc_hd__decap_3
XFILLER_31_606 VGND VGND VPWR VPWR sky130_fd_sc_hd__decap_3
XFILLER_31_617 VGND VGND VPWR VPWR sky130_fd_sc_hd__fill_2
XTAP_TAPCELL_ROW_104_1751 VGND VPWR sky130_fd_sc_hd__tapvpwrvgnd_1
XTAP_TAPCELL_ROW_26_653 VGND VPWR sky130_fd_sc_hd__tapvpwrvgnd_1
XFILLER_62_64 VGND VGND VPWR VPWR sky130_fd_sc_hd__decap_3
XFILLER_129_505 VGND VGND VPWR VPWR sky130_fd_sc_hd__decap_3
XFILLER_30_138 VGND VGND VPWR VPWR sky130_fd_sc_hd__fill_2
XFILLER_8_802 VGND VGND VPWR VPWR sky130_fd_sc_hd__fill_2
XFILLER_11_374 VGND VGND VPWR VPWR sky130_fd_sc_hd__decap_3
XFILLER_129_538 VGND VGND VPWR VPWR sky130_fd_sc_hd__decap_3
XFILLER_7_15 VGND VGND VPWR VPWR sky130_fd_sc_hd__decap_3
XFILLER_7_312 VGND VGND VPWR VPWR sky130_fd_sc_hd__fill_2
Xwire221 _4860_/B VGND VGND VPWR VPWR _4852_/B sky130_fd_sc_hd__buf_2
XFILLER_11_396 VGND VGND VPWR VPWR sky130_fd_sc_hd__decap_3
XFILLER_7_48 VGND VGND VPWR VPWR sky130_fd_sc_hd__decap_3
XTAP_TAPCELL_ROW_133_2158 VGND VPWR sky130_fd_sc_hd__tapvpwrvgnd_1
XFILLER_124_265 VGND VGND VPWR VPWR sky130_fd_sc_hd__decap_3
XFILLER_125_788 VGND VGND VPWR VPWR sky130_fd_sc_hd__decap_3
XFILLER_97_116 VGND VGND VPWR VPWR sky130_fd_sc_hd__decap_3
XFILLER_112_427 VGND VGND VPWR VPWR sky130_fd_sc_hd__decap_3
XFILLER_124_287 VGND VGND VPWR VPWR sky130_fd_sc_hd__fill_1
XFILLER_127_90 VGND VGND VPWR VPWR sky130_fd_sc_hd__decap_3
XFILLER_3_595 VGND VGND VPWR VPWR sky130_fd_sc_hd__decap_3
XFILLER_78_341 VGND VGND VPWR VPWR sky130_fd_sc_hd__fill_2
XFILLER_87_83 VGND VGND VPWR VPWR sky130_fd_sc_hd__decap_3
XFILLER_38_227 VGND VGND VPWR VPWR sky130_fd_sc_hd__fill_1
XFILLER_38_249 VGND VGND VPWR VPWR sky130_fd_sc_hd__decap_3
XFILLER_47_783 VGND VGND VPWR VPWR sky130_fd_sc_hd__fill_1
XFILLER_81_517 VGND VGND VPWR VPWR sky130_fd_sc_hd__decap_3
XFILLER_93_366 VGND VGND VPWR VPWR sky130_fd_sc_hd__decap_3
XTAP_TAPCELL_ROW_66_1212 VGND VPWR sky130_fd_sc_hd__tapvpwrvgnd_1
XFILLER_34_433 VGND VGND VPWR VPWR sky130_fd_sc_hd__decap_3
XFILLER_74_580 VGND VGND VPWR VPWR sky130_fd_sc_hd__fill_1
XTAP_TAPCELL_ROW_66_1223 VGND VPWR sky130_fd_sc_hd__tapvpwrvgnd_1
XFILLER_61_252 VGND VGND VPWR VPWR sky130_fd_sc_hd__fill_2
X_5840_ _5840_/A VGND VGND VPWR VPWR _7957_/D sky130_fd_sc_hd__buf_1
XFILLER_22_639 VGND VGND VPWR VPWR sky130_fd_sc_hd__decap_3
X_5771_ _5771_/A VGND VGND VPWR VPWR _7924_/D sky130_fd_sc_hd__buf_1
X_8490_ _8733_/CLK _8490_/D fanout485/X VGND VGND VPWR VPWR _8490_/Q sky130_fd_sc_hd__dfrtp_2
X_7510_ _8735_/CLK _7510_/D load_slew529/X VGND VGND VPWR VPWR _7510_/Q sky130_fd_sc_hd__dfrtp_2
X_4722_ _4722_/A _4734_/B VGND VGND VPWR VPWR _4723_/A sky130_fd_sc_hd__and2_2
X_7441_ _8777_/Q _4920_/A _7449_/S VGND VGND VPWR VPWR _7442_/A sky130_fd_sc_hd__mux2_2
XFILLER_135_508 VGND VGND VPWR VPWR sky130_fd_sc_hd__fill_1
Xinput40 wdata[43] VGND VGND VPWR VPWR _4786_/A sky130_fd_sc_hd__clkdlybuf4s25_1
X_4653_ _4669_/S _4651_/X _4652_/X _3735_/X VGND VGND VPWR VPWR _4653_/X sky130_fd_sc_hd__a31o_2
XFILLER_128_560 VGND VGND VPWR VPWR sky130_fd_sc_hd__decap_3
Xhold802 _8657_/Q VGND VGND VPWR VPWR hold802/X sky130_fd_sc_hd__dlygate4sd3_1
Xinput51 wdata[53] VGND VGND VPWR VPWR _4828_/A sky130_fd_sc_hd__clkdlybuf4s25_1
Xinput62 wdata[63] VGND VGND VPWR VPWR _4870_/A sky130_fd_sc_hd__clkdlybuf4s25_1
Xinput73 wdata[73] VGND VGND VPWR VPWR _4912_/A sky130_fd_sc_hd__clkdlybuf4s25_1
X_7372_ _8744_/Q _4781_/A _7386_/S VGND VGND VPWR VPWR _7373_/A sky130_fd_sc_hd__mux2_2
X_4584_ _4669_/S _4575_/X _4578_/X _4581_/X _4583_/X VGND VGND VPWR VPWR _4584_/X
+ sky130_fd_sc_hd__o32a_2
XTAP_TAPCELL_ROW_77_1374 VGND VPWR sky130_fd_sc_hd__tapvpwrvgnd_1
Xhold813 _8668_/Q VGND VGND VPWR VPWR hold813/X sky130_fd_sc_hd__dlygate4sd3_1
Xhold824 _8680_/Q VGND VGND VPWR VPWR hold824/X sky130_fd_sc_hd__dlygate4sd3_1
Xhold835 _8655_/Q VGND VGND VPWR VPWR hold835/X sky130_fd_sc_hd__dlygate4sd3_1
Xhold846 _8665_/Q VGND VGND VPWR VPWR hold846/X sky130_fd_sc_hd__dlygate4sd3_1
Xinput84 wen VGND VGND VPWR VPWR _3723_/B sky130_fd_sc_hd__clkdlybuf4s25_1
X_6323_ _4961_/X _8219_/Q _6335_/S VGND VGND VPWR VPWR _6324_/A sky130_fd_sc_hd__mux2_2
XFILLER_131_703 VGND VGND VPWR VPWR sky130_fd_sc_hd__decap_3
XFILLER_89_617 VGND VGND VPWR VPWR sky130_fd_sc_hd__decap_3
Xhold857 _8667_/Q VGND VGND VPWR VPWR hold857/X sky130_fd_sc_hd__dlygate4sd3_1
Xhold868 _8696_/Q VGND VGND VPWR VPWR hold868/X sky130_fd_sc_hd__dlygate4sd3_1
Xhold879 _8633_/Q VGND VGND VPWR VPWR hold879/X sky130_fd_sc_hd__dlygate4sd3_1
X_6254_ _4824_/X _8187_/Q _6268_/S VGND VGND VPWR VPWR _6255_/A sky130_fd_sc_hd__mux2_4
XFILLER_103_427 VGND VGND VPWR VPWR sky130_fd_sc_hd__decap_3
XFILLER_103_449 VGND VGND VPWR VPWR sky130_fd_sc_hd__decap_3
XFILLER_115_287 VGND VGND VPWR VPWR sky130_fd_sc_hd__fill_1
XFILLER_130_224 VGND VGND VPWR VPWR sky130_fd_sc_hd__decap_3
XFILLER_131_747 VGND VGND VPWR VPWR sky130_fd_sc_hd__decap_3
XFILLER_88_138 VGND VGND VPWR VPWR sky130_fd_sc_hd__fill_2
XTAP_TAPCELL_ROW_90_1552 VGND VPWR sky130_fd_sc_hd__tapvpwrvgnd_1
X_5205_ _7658_/Q _5027_/X _5205_/S VGND VGND VPWR VPWR _5206_/A sky130_fd_sc_hd__mux2_2
XFILLER_57_503 VGND VGND VPWR VPWR sky130_fd_sc_hd__fill_1
X_6185_ _6185_/A VGND VGND VPWR VPWR _8154_/D sky130_fd_sc_hd__buf_6
XFILLER_123_26 VGND VGND VPWR VPWR sky130_fd_sc_hd__decap_3
XFILLER_57_525 VGND VGND VPWR VPWR sky130_fd_sc_hd__fill_1
XTAP_TAPCELL_ROW_4_348 VGND VPWR sky130_fd_sc_hd__tapvpwrvgnd_1
X_5136_ _5136_/A VGND VGND VPWR VPWR _7626_/D sky130_fd_sc_hd__buf_1
X_5067_ _5067_/A VGND VGND VPWR VPWR _7593_/D sky130_fd_sc_hd__buf_1
XFILLER_72_517 VGND VGND VPWR VPWR sky130_fd_sc_hd__fill_1
X_4018_ _4016_/X _4017_/X _4543_/A VGND VGND VPWR VPWR _4018_/X sky130_fd_sc_hd__mux2_2
XFILLER_16_24 VGND VGND VPWR VPWR sky130_fd_sc_hd__decap_3
XFILLER_16_35 VGND VGND VPWR VPWR sky130_fd_sc_hd__decap_3
XFILLER_65_591 VGND VGND VPWR VPWR sky130_fd_sc_hd__decap_3
XFILLER_13_606 VGND VGND VPWR VPWR sky130_fd_sc_hd__fill_1
XFILLER_16_68 VGND VGND VPWR VPWR sky130_fd_sc_hd__decap_3
XFILLER_25_444 VGND VGND VPWR VPWR sky130_fd_sc_hd__decap_3
XFILLER_80_550 VGND VGND VPWR VPWR sky130_fd_sc_hd__decap_3
XFILLER_25_488 VGND VGND VPWR VPWR sky130_fd_sc_hd__fill_2
XFILLER_40_414 VGND VGND VPWR VPWR sky130_fd_sc_hd__decap_3
XTAP_TAPCELL_ROW_23_612 VGND VPWR sky130_fd_sc_hd__tapvpwrvgnd_1
X_8757_ _8757_/CLK _8757_/D fanout715/X VGND VGND VPWR VPWR _8757_/Q sky130_fd_sc_hd__dfrtp_2
X_5969_ input2/X _7177_/A _5966_/X _5968_/X VGND VGND VPWR VPWR _8053_/D sky130_fd_sc_hd__a31o_2
XFILLER_40_458 VGND VGND VPWR VPWR sky130_fd_sc_hd__decap_3
X_7708_ _8771_/CLK _7708_/D load_slew596/X VGND VGND VPWR VPWR _7708_/Q sky130_fd_sc_hd__dfrtp_2
XFILLER_21_661 VGND VGND VPWR VPWR sky130_fd_sc_hd__decap_3
XFILLER_32_23 VGND VGND VPWR VPWR sky130_fd_sc_hd__fill_1
XFILLER_32_56 VGND VGND VPWR VPWR sky130_fd_sc_hd__decap_3
X_8688_ _8688_/CLK _8688_/D load_slew572/X VGND VGND VPWR VPWR _8688_/Q sky130_fd_sc_hd__dfrtp_2
XFILLER_126_508 VGND VGND VPWR VPWR sky130_fd_sc_hd__decap_3
X_7639_ _8783_/CLK _7639_/D load_slew682/X VGND VGND VPWR VPWR _7639_/Q sky130_fd_sc_hd__dfrtp_2
XFILLER_106_3 VGND VGND VPWR VPWR sky130_fd_sc_hd__decap_3
XFILLER_106_243 VGND VGND VPWR VPWR sky130_fd_sc_hd__decap_3
XFILLER_134_563 VGND VGND VPWR VPWR sky130_fd_sc_hd__decap_3
XFILLER_121_235 VGND VGND VPWR VPWR sky130_fd_sc_hd__decap_3
XFILLER_134_585 VGND VGND VPWR VPWR sky130_fd_sc_hd__decap_3
XFILLER_79_116 VGND VGND VPWR VPWR sky130_fd_sc_hd__fill_2
XFILLER_79_127 VGND VGND VPWR VPWR sky130_fd_sc_hd__decap_3
XFILLER_0_554 VGND VGND VPWR VPWR sky130_fd_sc_hd__decap_3
XFILLER_122_769 VGND VGND VPWR VPWR sky130_fd_sc_hd__fill_1
XFILLER_76_801 VGND VGND VPWR VPWR sky130_fd_sc_hd__decap_3
XFILLER_0_587 VGND VGND VPWR VPWR sky130_fd_sc_hd__fill_1
XFILLER_48_536 VGND VGND VPWR VPWR sky130_fd_sc_hd__decap_3
XFILLER_75_333 VGND VGND VPWR VPWR sky130_fd_sc_hd__decap_3
XFILLER_87_193 VGND VGND VPWR VPWR sky130_fd_sc_hd__decap_3
XFILLER_35_219 VGND VGND VPWR VPWR sky130_fd_sc_hd__fill_1
XFILLER_16_411 VGND VGND VPWR VPWR sky130_fd_sc_hd__decap_3
XFILLER_29_794 VGND VGND VPWR VPWR sky130_fd_sc_hd__decap_3
XFILLER_113_92 VGND VGND VPWR VPWR sky130_fd_sc_hd__decap_3
XFILLER_44_753 VGND VGND VPWR VPWR sky130_fd_sc_hd__decap_3
XFILLER_71_561 VGND VGND VPWR VPWR sky130_fd_sc_hd__decap_3
XFILLER_16_477 VGND VGND VPWR VPWR sky130_fd_sc_hd__decap_3
XFILLER_43_274 VGND VGND VPWR VPWR sky130_fd_sc_hd__decap_3
XFILLER_92_9 VGND VGND VPWR VPWR sky130_fd_sc_hd__decap_3
XTAP_TAPCELL_ROW_61_1142 VGND VPWR sky130_fd_sc_hd__tapvpwrvgnd_1
XFILLER_129_335 VGND VGND VPWR VPWR sky130_fd_sc_hd__fill_1
XFILLER_12_661 VGND VGND VPWR VPWR sky130_fd_sc_hd__fill_1
XFILLER_8_610 VGND VGND VPWR VPWR sky130_fd_sc_hd__decap_3
XTAP_TAPCELL_ROW_61_1153 VGND VPWR sky130_fd_sc_hd__tapvpwrvgnd_1
XFILLER_129_368 VGND VGND VPWR VPWR sky130_fd_sc_hd__decap_3
XFILLER_12_683 VGND VGND VPWR VPWR sky130_fd_sc_hd__decap_3
XFILLER_8_643 VGND VGND VPWR VPWR sky130_fd_sc_hd__fill_1
XFILLER_8_654 VGND VGND VPWR VPWR sky130_fd_sc_hd__decap_3
XFILLER_8_687 VGND VGND VPWR VPWR sky130_fd_sc_hd__decap_3
XTAP_TAPCELL_ROW_117_1931 VGND VPWR sky130_fd_sc_hd__tapvpwrvgnd_1
XFILLER_125_530 VGND VGND VPWR VPWR sky130_fd_sc_hd__fill_2
XFILLER_125_585 VGND VGND VPWR VPWR sky130_fd_sc_hd__decap_3
XFILLER_112_235 VGND VGND VPWR VPWR sky130_fd_sc_hd__decap_3
XFILLER_100_419 VGND VGND VPWR VPWR sky130_fd_sc_hd__fill_1
XFILLER_112_279 VGND VGND VPWR VPWR sky130_fd_sc_hd__decap_3
XFILLER_21_3 VGND VGND VPWR VPWR sky130_fd_sc_hd__decap_3
XFILLER_39_514 VGND VGND VPWR VPWR sky130_fd_sc_hd__fill_2
XPHY_EDGE_ROW_13_Left_149 VGND VGND VPWR VPWR sky130_fd_sc_hd__decap_3
XFILLER_78_182 VGND VGND VPWR VPWR sky130_fd_sc_hd__decap_3
XTAP_TAPCELL_ROW_1_307 VGND VPWR sky130_fd_sc_hd__tapvpwrvgnd_1
XFILLER_54_506 VGND VGND VPWR VPWR sky130_fd_sc_hd__decap_3
X_7990_ _8804_/CLK _7990_/D load_slew491/X VGND VGND VPWR VPWR _7990_/Q sky130_fd_sc_hd__dfrtp_2
XFILLER_19_271 VGND VGND VPWR VPWR sky130_fd_sc_hd__decap_3
XFILLER_47_580 VGND VGND VPWR VPWR sky130_fd_sc_hd__decap_3
X_6941_ _6941_/A VGND VGND VPWR VPWR _8509_/D sky130_fd_sc_hd__buf_6
XFILLER_35_753 VGND VGND VPWR VPWR sky130_fd_sc_hd__decap_3
XFILLER_50_701 VGND VGND VPWR VPWR sky130_fd_sc_hd__fill_2
X_6872_ _5023_/X _8477_/Q _6874_/S VGND VGND VPWR VPWR _6873_/A sky130_fd_sc_hd__mux2_4
XFILLER_22_403 VGND VGND VPWR VPWR sky130_fd_sc_hd__fill_1
XFILLER_34_285 VGND VGND VPWR VPWR sky130_fd_sc_hd__decap_3
X_8611_ _8773_/CLK _8611_/D load_slew738/X VGND VGND VPWR VPWR _8611_/Q sky130_fd_sc_hd__dfrtp_2
X_5823_ _5823_/A VGND VGND VPWR VPWR _7949_/D sky130_fd_sc_hd__buf_1
XFILLER_50_745 VGND VGND VPWR VPWR sky130_fd_sc_hd__fill_1
XPHY_EDGE_ROW_22_Left_158 VGND VGND VPWR VPWR sky130_fd_sc_hd__decap_3
X_8542_ _8623_/CLK _8542_/D fanout674/X VGND VGND VPWR VPWR _8542_/Q sky130_fd_sc_hd__dfrtp_2
XFILLER_22_469 VGND VGND VPWR VPWR sky130_fd_sc_hd__fill_2
XFILLER_50_778 VGND VGND VPWR VPWR sky130_fd_sc_hd__decap_3
Xclkbuf_leaf_94_CLK clkload6/A VGND VGND VPWR VPWR _8624_/CLK sky130_fd_sc_hd__clkbuf_8
X_5754_ _5754_/A VGND VGND VPWR VPWR _7916_/D sky130_fd_sc_hd__buf_1
XTAP_TAPCELL_ROW_79_1403 VGND VPWR sky130_fd_sc_hd__tapvpwrvgnd_1
X_8473_ _8634_/CLK _8473_/D fanout604/X VGND VGND VPWR VPWR _8473_/Q sky130_fd_sc_hd__dfrtp_2
X_5685_ _5685_/A VGND VGND VPWR VPWR _7883_/D sky130_fd_sc_hd__buf_1
X_4705_ _4705_/A VGND VGND VPWR VPWR _7500_/D sky130_fd_sc_hd__buf_1
XFILLER_118_15 VGND VGND VPWR VPWR sky130_fd_sc_hd__decap_3
XFILLER_135_327 VGND VGND VPWR VPWR sky130_fd_sc_hd__fill_1
XFILLER_8_80 VGND VGND VPWR VPWR sky130_fd_sc_hd__decap_3
XFILLER_8_91 VGND VGND VPWR VPWR sky130_fd_sc_hd__fill_2
X_7424_ _8769_/Q _4886_/A _7428_/S VGND VGND VPWR VPWR _7425_/A sky130_fd_sc_hd__mux2_2
X_4636_ _8130_/Q _8211_/Q _8292_/Q _8373_/Q _4632_/S _4636_/S1 VGND VGND VPWR VPWR
+ _4637_/B sky130_fd_sc_hd__mux4_2
X_7355_ _8736_/Q _4748_/A _7365_/S VGND VGND VPWR VPWR _7356_/A sky130_fd_sc_hd__mux2_2
XFILLER_118_59 VGND VGND VPWR VPWR sky130_fd_sc_hd__decap_3
XFILLER_131_500 VGND VGND VPWR VPWR sky130_fd_sc_hd__decap_3
XTAP_TAPCELL_ROW_9_418 VGND VPWR sky130_fd_sc_hd__tapvpwrvgnd_1
X_6306_ _4929_/X _8212_/Q _6310_/S VGND VGND VPWR VPWR _6307_/A sky130_fd_sc_hd__mux2_4
X_4567_ _8691_/Q _3768_/X _4566_/X VGND VGND VPWR VPWR _4567_/X sky130_fd_sc_hd__o21a_2
XFILLER_131_511 VGND VGND VPWR VPWR sky130_fd_sc_hd__decap_3
XFILLER_89_447 VGND VGND VPWR VPWR sky130_fd_sc_hd__fill_1
XPHY_EDGE_ROW_31_Left_167 VGND VGND VPWR VPWR sky130_fd_sc_hd__decap_3
X_7286_ _8703_/Q _4952_/A _7302_/S VGND VGND VPWR VPWR _7287_/A sky130_fd_sc_hd__mux2_2
X_4498_ _4498_/A _4498_/B VGND VGND VPWR VPWR _4498_/X sky130_fd_sc_hd__or2_2
XFILLER_131_544 VGND VGND VPWR VPWR sky130_fd_sc_hd__decap_3
X_6237_ _4791_/X _8179_/Q _6247_/S VGND VGND VPWR VPWR _6238_/A sky130_fd_sc_hd__mux2_4
XFILLER_103_268 VGND VGND VPWR VPWR sky130_fd_sc_hd__decap_3
XFILLER_131_588 VGND VGND VPWR VPWR sky130_fd_sc_hd__decap_3
XFILLER_134_47 VGND VGND VPWR VPWR sky130_fd_sc_hd__decap_3
XFILLER_76_119 VGND VGND VPWR VPWR sky130_fd_sc_hd__decap_3
XFILLER_97_480 VGND VGND VPWR VPWR sky130_fd_sc_hd__decap_3
X_6168_ _4995_/X _8146_/Q _6184_/S VGND VGND VPWR VPWR _6169_/A sky130_fd_sc_hd__mux2_4
XFILLER_84_130 VGND VGND VPWR VPWR sky130_fd_sc_hd__fill_1
XFILLER_94_29 VGND VGND VPWR VPWR sky130_fd_sc_hd__fill_2
X_5119_ _4857_/X hold993/X _5137_/S VGND VGND VPWR VPWR _5120_/A sky130_fd_sc_hd__mux2_2
XFILLER_17_208 VGND VGND VPWR VPWR sky130_fd_sc_hd__fill_1
XFILLER_27_12 VGND VGND VPWR VPWR sky130_fd_sc_hd__decap_3
XFILLER_27_45 VGND VGND VPWR VPWR sky130_fd_sc_hd__decap_3
XFILLER_45_517 VGND VGND VPWR VPWR sky130_fd_sc_hd__decap_3
XFILLER_84_141 VGND VGND VPWR VPWR sky130_fd_sc_hd__fill_1
X_6099_ _6099_/A VGND VGND VPWR VPWR _8114_/D sky130_fd_sc_hd__buf_1
XFILLER_27_78 VGND VGND VPWR VPWR sky130_fd_sc_hd__decap_3
XFILLER_26_753 VGND VGND VPWR VPWR sky130_fd_sc_hd__decap_3
XFILLER_26_775 VGND VGND VPWR VPWR sky130_fd_sc_hd__fill_2
XFILLER_53_550 VGND VGND VPWR VPWR sky130_fd_sc_hd__decap_3
XFILLER_60_509 VGND VGND VPWR VPWR sky130_fd_sc_hd__decap_3
XFILLER_25_263 VGND VGND VPWR VPWR sky130_fd_sc_hd__fill_2
XFILLER_25_274 VGND VGND VPWR VPWR sky130_fd_sc_hd__decap_3
XFILLER_26_786 VGND VGND VPWR VPWR sky130_fd_sc_hd__decap_3
XFILLER_40_200 VGND VGND VPWR VPWR sky130_fd_sc_hd__fill_1
XFILLER_53_561 VGND VGND VPWR VPWR sky130_fd_sc_hd__fill_1
XFILLER_53_583 VGND VGND VPWR VPWR sky130_fd_sc_hd__decap_3
XPHY_EDGE_ROW_40_Left_176 VGND VGND VPWR VPWR sky130_fd_sc_hd__decap_3
XFILLER_13_447 VGND VGND VPWR VPWR sky130_fd_sc_hd__fill_1
XFILLER_13_458 VGND VGND VPWR VPWR sky130_fd_sc_hd__decap_3
XTAP_TAPCELL_ROW_101_1710 VGND VPWR sky130_fd_sc_hd__tapvpwrvgnd_1
XTAP_TAPCELL_ROW_36_792 VGND VPWR sky130_fd_sc_hd__tapvpwrvgnd_1
XFILLER_41_778 VGND VGND VPWR VPWR sky130_fd_sc_hd__decap_3
Xclkbuf_leaf_85_CLK clkbuf_leaf_88_CLK/A VGND VGND VPWR VPWR _8756_/CLK sky130_fd_sc_hd__clkbuf_8
XFILLER_5_602 VGND VGND VPWR VPWR sky130_fd_sc_hd__decap_3
XFILLER_5_635 VGND VGND VPWR VPWR sky130_fd_sc_hd__decap_3
XTAP_TAPCELL_ROW_130_2106 VGND VPWR sky130_fd_sc_hd__tapvpwrvgnd_1
XTAP_TAPCELL_ROW_130_2117 VGND VPWR sky130_fd_sc_hd__tapvpwrvgnd_1
XFILLER_5_668 VGND VGND VPWR VPWR sky130_fd_sc_hd__decap_3
XFILLER_5_679 VGND VGND VPWR VPWR sky130_fd_sc_hd__decap_3
XFILLER_108_70 VGND VGND VPWR VPWR sky130_fd_sc_hd__fill_1
XFILLER_122_533 VGND VGND VPWR VPWR sky130_fd_sc_hd__decap_3
XFILLER_134_371 VGND VGND VPWR VPWR sky130_fd_sc_hd__decap_3
XFILLER_4_27 VGND VGND VPWR VPWR sky130_fd_sc_hd__fill_1
XFILLER_4_38 VGND VGND VPWR VPWR sky130_fd_sc_hd__decap_3
XTAP_TAPCELL_ROW_112_1861 VGND VPWR sky130_fd_sc_hd__tapvpwrvgnd_1
XFILLER_67_119 VGND VGND VPWR VPWR sky130_fd_sc_hd__decap_3
XFILLER_76_653 VGND VGND VPWR VPWR sky130_fd_sc_hd__decap_3
XFILLER_124_91 VGND VGND VPWR VPWR sky130_fd_sc_hd__decap_3
XFILLER_48_377 VGND VGND VPWR VPWR sky130_fd_sc_hd__fill_2
XTAP_TAPCELL_ROW_128_2079 VGND VPWR sky130_fd_sc_hd__tapvpwrvgnd_1
XFILLER_29_591 VGND VGND VPWR VPWR sky130_fd_sc_hd__fill_1
XFILLER_36_528 VGND VGND VPWR VPWR sky130_fd_sc_hd__fill_1
XFILLER_16_241 VGND VGND VPWR VPWR sky130_fd_sc_hd__decap_3
XFILLER_17_753 VGND VGND VPWR VPWR sky130_fd_sc_hd__fill_1
XFILLER_51_509 VGND VGND VPWR VPWR sky130_fd_sc_hd__decap_3
XFILLER_84_95 VGND VGND VPWR VPWR sky130_fd_sc_hd__decap_3
XFILLER_90_133 VGND VGND VPWR VPWR sky130_fd_sc_hd__decap_3
XFILLER_90_188 VGND VGND VPWR VPWR sky130_fd_sc_hd__decap_3
XFILLER_31_233 VGND VGND VPWR VPWR sky130_fd_sc_hd__fill_2
XFILLER_90_6 VGND VGND VPWR VPWR sky130_fd_sc_hd__fill_2
XFILLER_32_789 VGND VGND VPWR VPWR sky130_fd_sc_hd__fill_1
Xclkbuf_leaf_76_CLK clkbuf_leaf_84_CLK/A VGND VGND VPWR VPWR _8699_/CLK sky130_fd_sc_hd__clkbuf_8
XFILLER_129_143 VGND VGND VPWR VPWR sky130_fd_sc_hd__decap_3
XFILLER_8_440 VGND VGND VPWR VPWR sky130_fd_sc_hd__decap_3
XTAP_TAPCELL_ROW_14_486 VGND VPWR sky130_fd_sc_hd__tapvpwrvgnd_1
X_5470_ _7783_/Q _4870_/A _5482_/S VGND VGND VPWR VPWR _5471_/A sky130_fd_sc_hd__mux2_2
XFILLER_129_187 VGND VGND VPWR VPWR sky130_fd_sc_hd__decap_3
X_4421_ _8354_/Q _4560_/A2 _4622_/B1 _8273_/Q _4120_/A VGND VGND VPWR VPWR _4421_/X
+ sky130_fd_sc_hd__o221a_2
XTAP_TAPCELL_ROW_74_1322 VGND VPWR sky130_fd_sc_hd__tapvpwrvgnd_1
XFILLER_113_500 VGND VGND VPWR VPWR sky130_fd_sc_hd__decap_3
XFILLER_98_200 VGND VGND VPWR VPWR sky130_fd_sc_hd__fill_2
XTAP_TAPCELL_ROW_74_1333 VGND VPWR sky130_fd_sc_hd__tapvpwrvgnd_1
X_7140_ _7140_/A VGND VGND VPWR VPWR _8603_/D sky130_fd_sc_hd__buf_2
X_4352_ _7771_/Q _7852_/Q _4352_/S VGND VGND VPWR VPWR _4352_/X sky130_fd_sc_hd__mux2_2
XFILLER_4_690 VGND VGND VPWR VPWR sky130_fd_sc_hd__decap_3
XFILLER_86_406 VGND VGND VPWR VPWR sky130_fd_sc_hd__decap_3
XFILLER_99_778 VGND VGND VPWR VPWR sky130_fd_sc_hd__decap_3
X_7071_ _7071_/A VGND VGND VPWR VPWR _8570_/D sky130_fd_sc_hd__buf_2
X_4283_ _8008_/Q _4295_/A2 _4282_/X VGND VGND VPWR VPWR _4283_/X sky130_fd_sc_hd__o21a_2
XFILLER_86_439 VGND VGND VPWR VPWR sky130_fd_sc_hd__decap_3
XFILLER_98_277 VGND VGND VPWR VPWR sky130_fd_sc_hd__fill_2
X_6022_ _8078_/Q _4706_/A _6032_/S VGND VGND VPWR VPWR _6023_/A sky130_fd_sc_hd__mux2_2
XFILLER_100_227 VGND VGND VPWR VPWR sky130_fd_sc_hd__decap_3
XFILLER_39_344 VGND VGND VPWR VPWR sky130_fd_sc_hd__decap_3
XFILLER_67_642 VGND VGND VPWR VPWR sky130_fd_sc_hd__decap_3
XFILLER_39_377 VGND VGND VPWR VPWR sky130_fd_sc_hd__fill_2
XFILLER_66_141 VGND VGND VPWR VPWR sky130_fd_sc_hd__decap_3
XFILLER_27_528 VGND VGND VPWR VPWR sky130_fd_sc_hd__decap_3
XFILLER_54_336 VGND VGND VPWR VPWR sky130_fd_sc_hd__decap_3
X_7973_ _8470_/CLK _7973_/D load_slew589/X VGND VGND VPWR VPWR _7973_/Q sky130_fd_sc_hd__dfrtp_2
XFILLER_42_509 VGND VGND VPWR VPWR sky130_fd_sc_hd__decap_3
X_6924_ _6924_/A VGND VGND VPWR VPWR _8501_/D sky130_fd_sc_hd__buf_6
XFILLER_120_16 VGND VGND VPWR VPWR sky130_fd_sc_hd__decap_3
XFILLER_35_561 VGND VGND VPWR VPWR sky130_fd_sc_hd__fill_2
XFILLER_81_166 VGND VGND VPWR VPWR sky130_fd_sc_hd__fill_2
XFILLER_81_188 VGND VGND VPWR VPWR sky130_fd_sc_hd__fill_1
XTAP_TAPCELL_ROW_85_1484 VGND VPWR sky130_fd_sc_hd__tapvpwrvgnd_1
X_6855_ _7002_/S VGND VGND VPWR VPWR _6874_/S sky130_fd_sc_hd__buf_6
XFILLER_50_564 VGND VGND VPWR VPWR sky130_fd_sc_hd__fill_1
XFILLER_50_586 VGND VGND VPWR VPWR sky130_fd_sc_hd__fill_2
XTAP_TAPCELL_ROW_33_751 VGND VPWR sky130_fd_sc_hd__tapvpwrvgnd_1
X_3998_ _3993_/X _3994_/X _3995_/X _3997_/X VGND VGND VPWR VPWR _3998_/X sky130_fd_sc_hd__a22o_2
Xclkbuf_leaf_67_CLK clkbuf_leaf_75_CLK/A VGND VGND VPWR VPWR _8773_/CLK sky130_fd_sc_hd__clkbuf_8
X_6786_ _8437_/Q _4852_/A _6786_/S VGND VGND VPWR VPWR _6787_/A sky130_fd_sc_hd__mux2_2
X_5806_ _5806_/A VGND VGND VPWR VPWR _7941_/D sky130_fd_sc_hd__buf_1
XFILLER_13_36 VGND VGND VPWR VPWR sky130_fd_sc_hd__decap_3
X_8525_ _8685_/CLK _8525_/D load_slew568/X VGND VGND VPWR VPWR _8525_/Q sky130_fd_sc_hd__dfrtp_2
X_5737_ _5737_/A VGND VGND VPWR VPWR _7908_/D sky130_fd_sc_hd__buf_1
XFILLER_129_36 VGND VGND VPWR VPWR sky130_fd_sc_hd__decap_3
XFILLER_13_69 VGND VGND VPWR VPWR sky130_fd_sc_hd__decap_3
X_8456_ _8699_/CLK _8456_/D load_slew724/X VGND VGND VPWR VPWR _8456_/Q sky130_fd_sc_hd__dfrtp_2
XFILLER_108_338 VGND VGND VPWR VPWR sky130_fd_sc_hd__decap_3
XFILLER_129_69 VGND VGND VPWR VPWR sky130_fd_sc_hd__decap_3
XFILLER_135_113 VGND VGND VPWR VPWR sky130_fd_sc_hd__decap_3
X_7407_ _8761_/Q _4852_/A _7407_/S VGND VGND VPWR VPWR _7408_/A sky130_fd_sc_hd__mux2_2
X_5668_ _5668_/A VGND VGND VPWR VPWR _7876_/D sky130_fd_sc_hd__buf_1
X_8387_ _8387_/CLK _8387_/D load_slew655/X VGND VGND VPWR VPWR _8387_/Q sky130_fd_sc_hd__dfrtp_2
X_5599_ _5599_/A VGND VGND VPWR VPWR _7843_/D sky130_fd_sc_hd__buf_1
X_4619_ _8129_/Q _8210_/Q _8291_/Q _8372_/Q _4620_/S _4621_/A VGND VGND VPWR VPWR
+ _4619_/X sky130_fd_sc_hd__mux4_2
XFILLER_116_371 VGND VGND VPWR VPWR sky130_fd_sc_hd__decap_3
XFILLER_116_382 VGND VGND VPWR VPWR sky130_fd_sc_hd__decap_3
XFILLER_2_616 VGND VGND VPWR VPWR sky130_fd_sc_hd__decap_3
XFILLER_89_222 VGND VGND VPWR VPWR sky130_fd_sc_hd__fill_2
Xmax_cap170 _4719_/X VGND VGND VPWR VPWR _7063_/A0 sky130_fd_sc_hd__clkbuf_2
X_7338_ _8728_/Q _4714_/A _7344_/S VGND VGND VPWR VPWR _7339_/A sky130_fd_sc_hd__mux2_2
XFILLER_104_533 VGND VGND VPWR VPWR sky130_fd_sc_hd__decap_3
Xmax_cap192 _5869_/X VGND VGND VPWR VPWR _5879_/A2 sky130_fd_sc_hd__buf_2
Xmax_cap181 _5935_/X VGND VGND VPWR VPWR _5944_/B1 sky130_fd_sc_hd__clkbuf_2
X_7269_ _7269_/A VGND VGND VPWR VPWR _7269_/X sky130_fd_sc_hd__clkbuf_1
XFILLER_104_577 VGND VGND VPWR VPWR sky130_fd_sc_hd__fill_1
XFILLER_131_352 VGND VGND VPWR VPWR sky130_fd_sc_hd__decap_3
XFILLER_131_396 VGND VGND VPWR VPWR sky130_fd_sc_hd__decap_3
XFILLER_100_750 VGND VGND VPWR VPWR sky130_fd_sc_hd__decap_3
XFILLER_38_99 VGND VGND VPWR VPWR sky130_fd_sc_hd__decap_3
XFILLER_58_697 VGND VGND VPWR VPWR sky130_fd_sc_hd__decap_3
XFILLER_72_100 VGND VGND VPWR VPWR sky130_fd_sc_hd__fill_1
XFILLER_85_494 VGND VGND VPWR VPWR sky130_fd_sc_hd__decap_3
XFILLER_14_701 VGND VGND VPWR VPWR sky130_fd_sc_hd__fill_1
XFILLER_60_328 VGND VGND VPWR VPWR sky130_fd_sc_hd__fill_2
XFILLER_13_233 VGND VGND VPWR VPWR sky130_fd_sc_hd__decap_3
XFILLER_60_339 VGND VGND VPWR VPWR sky130_fd_sc_hd__decap_3
XFILLER_13_266 VGND VGND VPWR VPWR sky130_fd_sc_hd__fill_1
XFILLER_14_767 VGND VGND VPWR VPWR sky130_fd_sc_hd__fill_1
XFILLER_41_564 VGND VGND VPWR VPWR sky130_fd_sc_hd__fill_2
Xclkbuf_4_11_0_CLK clkbuf_0_CLK/X VGND VGND VPWR VPWR clkbuf_4_11_0_CLK/X sky130_fd_sc_hd__clkbuf_8
Xclkbuf_leaf_58_CLK clkbuf_leaf_88_CLK/A VGND VGND VPWR VPWR _8676_/CLK sky130_fd_sc_hd__clkbuf_8
XFILLER_110_82 VGND VGND VPWR VPWR sky130_fd_sc_hd__fill_2
XFILLER_13_299 VGND VGND VPWR VPWR sky130_fd_sc_hd__decap_3
XFILLER_9_237 VGND VGND VPWR VPWR sky130_fd_sc_hd__fill_2
XFILLER_127_603 VGND VGND VPWR VPWR sky130_fd_sc_hd__decap_3
XTAP_TAPCELL_ROW_11_445 VGND VPWR sky130_fd_sc_hd__tapvpwrvgnd_1
XFILLER_126_124 VGND VGND VPWR VPWR sky130_fd_sc_hd__decap_3
XFILLER_127_636 VGND VGND VPWR VPWR sky130_fd_sc_hd__decap_3
XFILLER_70_97 VGND VGND VPWR VPWR sky130_fd_sc_hd__fill_2
Xclkload18 _8725_/CLK VGND VGND VPWR VPWR clkload18/X sky130_fd_sc_hd__clkbuf_4
Xclkload29 _8400_/CLK VGND VGND VPWR VPWR clkload29/X sky130_fd_sc_hd__clkbuf_8
XFILLER_119_80 VGND VGND VPWR VPWR sky130_fd_sc_hd__fill_2
XFILLER_107_371 VGND VGND VPWR VPWR sky130_fd_sc_hd__decap_3
XFILLER_126_179 VGND VGND VPWR VPWR sky130_fd_sc_hd__decap_3
XFILLER_79_51 VGND VGND VPWR VPWR sky130_fd_sc_hd__fill_2
XFILLER_122_341 VGND VGND VPWR VPWR sky130_fd_sc_hd__decap_3
XTAP_TAPCELL_ROW_56_1074 VGND VPWR sky130_fd_sc_hd__tapvpwrvgnd_1
XFILLER_110_514 VGND VGND VPWR VPWR sky130_fd_sc_hd__decap_3
XFILLER_122_363 VGND VGND VPWR VPWR sky130_fd_sc_hd__fill_1
XFILLER_1_671 VGND VGND VPWR VPWR sky130_fd_sc_hd__fill_1
XFILLER_110_536 VGND VGND VPWR VPWR sky130_fd_sc_hd__decap_3
XFILLER_110_558 VGND VGND VPWR VPWR sky130_fd_sc_hd__decap_3
XFILLER_1_682 VGND VGND VPWR VPWR sky130_fd_sc_hd__decap_3
XFILLER_48_130 VGND VGND VPWR VPWR sky130_fd_sc_hd__decap_3
XFILLER_64_601 VGND VGND VPWR VPWR sky130_fd_sc_hd__decap_3
XFILLER_95_258 VGND VGND VPWR VPWR sky130_fd_sc_hd__fill_1
XFILLER_95_72 VGND VGND VPWR VPWR sky130_fd_sc_hd__decap_3
XFILLER_48_185 VGND VGND VPWR VPWR sky130_fd_sc_hd__decap_3
XFILLER_49_697 VGND VGND VPWR VPWR sky130_fd_sc_hd__decap_3
XFILLER_91_431 VGND VGND VPWR VPWR sky130_fd_sc_hd__decap_3
XTAP_TAPCELL_ROW_19_556 VGND VPWR sky130_fd_sc_hd__tapvpwrvgnd_1
XFILLER_17_561 VGND VGND VPWR VPWR sky130_fd_sc_hd__fill_2
XFILLER_51_328 VGND VGND VPWR VPWR sky130_fd_sc_hd__decap_3
XFILLER_91_475 VGND VGND VPWR VPWR sky130_fd_sc_hd__decap_3
X_4970_ _4969_/X _4970_/A1 _4986_/S VGND VGND VPWR VPWR _4971_/A sky130_fd_sc_hd__mux2_2
XFILLER_32_520 VGND VGND VPWR VPWR sky130_fd_sc_hd__decap_3
X_3921_ _3921_/A VGND VGND VPWR VPWR _3921_/X sky130_fd_sc_hd__clkbuf_2
X_3852_ _3862_/A _3850_/X _3851_/X VGND VGND VPWR VPWR _3852_/X sky130_fd_sc_hd__o21a_2
Xclkbuf_leaf_49_CLK clkbuf_leaf_52_CLK/A VGND VGND VPWR VPWR _8638_/CLK sky130_fd_sc_hd__clkbuf_8
X_6640_ _4908_/X _8369_/Q _6654_/S VGND VGND VPWR VPWR _6641_/A sky130_fd_sc_hd__mux2_2
XTAP_TAPCELL_ROW_30_710 VGND VPWR sky130_fd_sc_hd__tapvpwrvgnd_1
X_6571_ _6571_/A VGND VGND VPWR VPWR _8336_/D sky130_fd_sc_hd__buf_2
XFILLER_118_614 VGND VGND VPWR VPWR sky130_fd_sc_hd__decap_3
XFILLER_9_771 VGND VGND VPWR VPWR sky130_fd_sc_hd__decap_3
X_3783_ _3825_/A _3783_/B VGND VGND VPWR VPWR _3783_/X sky130_fd_sc_hd__or2_2
X_8310_ _8796_/CLK _8310_/D fanout609/X VGND VGND VPWR VPWR _8310_/Q sky130_fd_sc_hd__dfrtp_2
X_5522_ _7807_/Q _4973_/A _5528_/S VGND VGND VPWR VPWR _5523_/A sky130_fd_sc_hd__mux2_2
XFILLER_117_113 VGND VGND VPWR VPWR sky130_fd_sc_hd__fill_1
XFILLER_117_135 VGND VGND VPWR VPWR sky130_fd_sc_hd__fill_2
XFILLER_133_606 VGND VGND VPWR VPWR sky130_fd_sc_hd__decap_3
XFILLER_133_617 VGND VGND VPWR VPWR sky130_fd_sc_hd__decap_3
X_8241_ _8647_/CLK _8241_/D fanout534/X VGND VGND VPWR VPWR _8241_/Q sky130_fd_sc_hd__dfrtp_2
X_5453_ _7775_/Q _4836_/A _5461_/S VGND VGND VPWR VPWR _5454_/A sky130_fd_sc_hd__mux2_2
XFILLER_126_680 VGND VGND VPWR VPWR sky130_fd_sc_hd__decap_3
XFILLER_132_127 VGND VGND VPWR VPWR sky130_fd_sc_hd__decap_3
X_8172_ _8739_/CLK _8172_/D fanout508/X VGND VGND VPWR VPWR _8172_/Q sky130_fd_sc_hd__dfrtp_2
X_5384_ _7742_/Q _4690_/A _5398_/S VGND VGND VPWR VPWR _5385_/A sky130_fd_sc_hd__mux2_2
X_4404_ _8676_/Q _4682_/A2 _3752_/X _8595_/Q _4456_/C1 VGND VGND VPWR VPWR _4404_/X
+ sky130_fd_sc_hd__o221a_2
XFILLER_5_81 VGND VGND VPWR VPWR sky130_fd_sc_hd__decap_3
X_7123_ _7123_/A VGND VGND VPWR VPWR _8595_/D sky130_fd_sc_hd__buf_2
X_4335_ _4335_/A _4335_/B VGND VGND VPWR VPWR _4335_/X sky130_fd_sc_hd__or2_2
XFILLER_101_503 VGND VGND VPWR VPWR sky130_fd_sc_hd__fill_1
XFILLER_99_597 VGND VGND VPWR VPWR sky130_fd_sc_hd__decap_3
XFILLER_113_385 VGND VGND VPWR VPWR sky130_fd_sc_hd__decap_3
XFILLER_115_38 VGND VGND VPWR VPWR sky130_fd_sc_hd__decap_3
XPHY_EDGE_ROW_105_Left_241 VGND VGND VPWR VPWR sky130_fd_sc_hd__decap_3
X_7054_ _7054_/A VGND VGND VPWR VPWR _8562_/D sky130_fd_sc_hd__buf_2
X_4266_ _7764_/Q _7845_/Q _4266_/S VGND VGND VPWR VPWR _4266_/X sky130_fd_sc_hd__mux2_2
X_6005_ _8070_/Q _5014_/A _6011_/S VGND VGND VPWR VPWR _6006_/A sky130_fd_sc_hd__mux2_2
X_4197_ _8091_/Q _8172_/Q _4197_/S VGND VGND VPWR VPWR _4198_/B sky130_fd_sc_hd__mux2_2
XFILLER_131_15 VGND VGND VPWR VPWR sky130_fd_sc_hd__decap_3
XTAP_TAPCELL_ROW_38_821 VGND VPWR sky130_fd_sc_hd__tapvpwrvgnd_1
XTAP_TAPCELL_ROW_87_1513 VGND VPWR sky130_fd_sc_hd__tapvpwrvgnd_1
XFILLER_131_48 VGND VGND VPWR VPWR sky130_fd_sc_hd__decap_3
XFILLER_55_645 VGND VGND VPWR VPWR sky130_fd_sc_hd__decap_3
XFILLER_42_306 VGND VGND VPWR VPWR sky130_fd_sc_hd__fill_2
XFILLER_70_604 VGND VGND VPWR VPWR sky130_fd_sc_hd__decap_3
X_7956_ _8779_/CLK _7956_/D load_slew731/X VGND VGND VPWR VPWR _7956_/Q sky130_fd_sc_hd__dfrtp_2
XFILLER_23_520 VGND VGND VPWR VPWR sky130_fd_sc_hd__decap_3
XFILLER_24_24 VGND VGND VPWR VPWR sky130_fd_sc_hd__decap_3
X_7887_ _8710_/CLK _7887_/D load_slew663/X VGND VGND VPWR VPWR _7887_/Q sky130_fd_sc_hd__dfrtp_2
X_6907_ _6907_/A VGND VGND VPWR VPWR _8493_/D sky130_fd_sc_hd__buf_6
XFILLER_23_564 VGND VGND VPWR VPWR sky130_fd_sc_hd__decap_3
XFILLER_24_35 VGND VGND VPWR VPWR sky130_fd_sc_hd__decap_3
XFILLER_50_350 VGND VGND VPWR VPWR sky130_fd_sc_hd__decap_3
X_6838_ _6838_/A VGND VGND VPWR VPWR _8460_/D sky130_fd_sc_hd__buf_6
XFILLER_23_597 VGND VGND VPWR VPWR sky130_fd_sc_hd__decap_3
XFILLER_24_68 VGND VGND VPWR VPWR sky130_fd_sc_hd__decap_3
XPHY_EDGE_ROW_114_Left_250 VGND VGND VPWR VPWR sky130_fd_sc_hd__decap_3
XFILLER_11_759 VGND VGND VPWR VPWR sky130_fd_sc_hd__decap_3
X_8508_ _8670_/CLK _8508_/D wire631/X VGND VGND VPWR VPWR _8508_/Q sky130_fd_sc_hd__dfrtp_2
X_6769_ _6769_/A VGND VGND VPWR VPWR _8428_/D sky130_fd_sc_hd__buf_2
XTAP_TAPCELL_ROW_98_1664 VGND VPWR sky130_fd_sc_hd__tapvpwrvgnd_1
XFILLER_108_135 VGND VGND VPWR VPWR sky130_fd_sc_hd__decap_3
X_8439_ _8763_/CLK _8439_/D fanout559/X VGND VGND VPWR VPWR _8439_/Q sky130_fd_sc_hd__dfrtp_2
XFILLER_123_116 VGND VGND VPWR VPWR sky130_fd_sc_hd__decap_3
XFILLER_104_352 VGND VGND VPWR VPWR sky130_fd_sc_hd__decap_3
XFILLER_104_374 VGND VGND VPWR VPWR sky130_fd_sc_hd__decap_3
XFILLER_132_672 VGND VGND VPWR VPWR sky130_fd_sc_hd__decap_3
XFILLER_49_32 VGND VGND VPWR VPWR sky130_fd_sc_hd__fill_1
XFILLER_49_54 VGND VGND VPWR VPWR sky130_fd_sc_hd__fill_2
XFILLER_131_193 VGND VGND VPWR VPWR sky130_fd_sc_hd__decap_3
XFILLER_46_601 VGND VGND VPWR VPWR sky130_fd_sc_hd__decap_3
XFILLER_92_206 VGND VGND VPWR VPWR sky130_fd_sc_hd__decap_3
XFILLER_18_325 VGND VGND VPWR VPWR sky130_fd_sc_hd__fill_1
XFILLER_1_39 VGND VGND VPWR VPWR sky130_fd_sc_hd__decap_3
XFILLER_45_100 VGND VGND VPWR VPWR sky130_fd_sc_hd__decap_3
XFILLER_46_634 VGND VGND VPWR VPWR sky130_fd_sc_hd__decap_3
XFILLER_65_20 VGND VGND VPWR VPWR sky130_fd_sc_hd__decap_3
XTAP_TAPCELL_ROW_125_2038 VGND VPWR sky130_fd_sc_hd__tapvpwrvgnd_1
XTAP_TAPCELL_ROW_125_2049 VGND VPWR sky130_fd_sc_hd__tapvpwrvgnd_1
XFILLER_18_347 VGND VGND VPWR VPWR sky130_fd_sc_hd__decap_3
XFILLER_46_645 VGND VGND VPWR VPWR sky130_fd_sc_hd__decap_3
XFILLER_65_75 VGND VGND VPWR VPWR sky130_fd_sc_hd__decap_3
XFILLER_73_431 VGND VGND VPWR VPWR sky130_fd_sc_hd__decap_3
XFILLER_60_103 VGND VGND VPWR VPWR sky130_fd_sc_hd__decap_3
XFILLER_65_86 VGND VGND VPWR VPWR sky130_fd_sc_hd__decap_3
XTAP_TAPCELL_ROW_16_515 VGND VPWR sky130_fd_sc_hd__tapvpwrvgnd_1
XTAP_TAPCELL_ROW_107_1793 VGND VPWR sky130_fd_sc_hd__tapvpwrvgnd_1
XFILLER_121_92 VGND VGND VPWR VPWR sky130_fd_sc_hd__fill_2
XFILLER_14_542 VGND VGND VPWR VPWR sky130_fd_sc_hd__decap_3
XFILLER_14_575 VGND VGND VPWR VPWR sky130_fd_sc_hd__decap_3
XFILLER_60_147 VGND VGND VPWR VPWR sky130_fd_sc_hd__fill_2
XFILLER_60_158 VGND VGND VPWR VPWR sky130_fd_sc_hd__fill_2
XFILLER_81_41 VGND VGND VPWR VPWR sky130_fd_sc_hd__decap_3
XFILLER_81_52 VGND VGND VPWR VPWR sky130_fd_sc_hd__decap_3
XFILLER_81_63 VGND VGND VPWR VPWR sky130_fd_sc_hd__decap_3
XFILLER_41_361 VGND VGND VPWR VPWR sky130_fd_sc_hd__decap_3
XTAP_TAPCELL_ROW_120_1971 VGND VPWR sky130_fd_sc_hd__tapvpwrvgnd_1
XFILLER_10_781 VGND VGND VPWR VPWR sky130_fd_sc_hd__decap_3
XFILLER_127_455 VGND VGND VPWR VPWR sky130_fd_sc_hd__decap_3
XFILLER_6_752 VGND VGND VPWR VPWR sky130_fd_sc_hd__decap_3
XFILLER_6_763 VGND VGND VPWR VPWR sky130_fd_sc_hd__decap_3
XPHY_EDGE_ROW_116_Right_116 VGND VGND VPWR VPWR sky130_fd_sc_hd__decap_3
XTAP_TAPCELL_ROW_58_1103 VGND VPWR sky130_fd_sc_hd__tapvpwrvgnd_1
XFILLER_108_680 VGND VGND VPWR VPWR sky130_fd_sc_hd__decap_3
XFILLER_127_488 VGND VGND VPWR VPWR sky130_fd_sc_hd__decap_3
XFILLER_53_6 VGND VGND VPWR VPWR sky130_fd_sc_hd__decap_3
XFILLER_6_796 VGND VGND VPWR VPWR sky130_fd_sc_hd__decap_3
XFILLER_5_284 VGND VGND VPWR VPWR sky130_fd_sc_hd__decap_3
XFILLER_110_300 VGND VGND VPWR VPWR sky130_fd_sc_hd__decap_3
XFILLER_96_545 VGND VGND VPWR VPWR sky130_fd_sc_hd__fill_2
X_4120_ _4120_/A _4120_/B VGND VGND VPWR VPWR _4120_/X sky130_fd_sc_hd__or2_2
X_4051_ _4051_/A VGND VGND VPWR VPWR _4051_/X sky130_fd_sc_hd__buf_1
Xinput5 wdata[11] VGND VGND VPWR VPWR input5/X sky130_fd_sc_hd__clkdlybuf4s25_1
XFILLER_37_656 VGND VGND VPWR VPWR sky130_fd_sc_hd__decap_3
XFILLER_76_280 VGND VGND VPWR VPWR sky130_fd_sc_hd__decap_3
XFILLER_92_740 VGND VGND VPWR VPWR sky130_fd_sc_hd__decap_3
XTAP_TAPCELL_ROW_69_1254 VGND VPWR sky130_fd_sc_hd__tapvpwrvgnd_1
X_7810_ _8387_/CLK _7810_/D load_slew655/X VGND VGND VPWR VPWR _7810_/Q sky130_fd_sc_hd__dfrtp_2
XFILLER_51_103 VGND VGND VPWR VPWR sky130_fd_sc_hd__fill_1
XFILLER_64_475 VGND VGND VPWR VPWR sky130_fd_sc_hd__fill_1
XTAP_TAPCELL_ROW_69_1265 VGND VPWR sky130_fd_sc_hd__tapvpwrvgnd_1
X_8790_ _8790_/CLK _8790_/D fanout672/X VGND VGND VPWR VPWR _8790_/Q sky130_fd_sc_hd__dfrtp_2
XFILLER_17_391 VGND VGND VPWR VPWR sky130_fd_sc_hd__fill_1
XFILLER_24_328 VGND VGND VPWR VPWR sky130_fd_sc_hd__fill_1
XFILLER_36_188 VGND VGND VPWR VPWR sky130_fd_sc_hd__fill_2
XFILLER_51_125 VGND VGND VPWR VPWR sky130_fd_sc_hd__decap_3
X_7741_ _8804_/CLK _7741_/D load_slew499/X VGND VGND VPWR VPWR _7741_/Q sky130_fd_sc_hd__dfrtp_2
X_4953_ _4953_/A VGND VGND VPWR VPWR _4953_/X sky130_fd_sc_hd__buf_1
XFILLER_32_350 VGND VGND VPWR VPWR sky130_fd_sc_hd__decap_3
XFILLER_51_169 VGND VGND VPWR VPWR sky130_fd_sc_hd__fill_1
XTAP_TAPCELL_ROW_82_1443 VGND VPWR sky130_fd_sc_hd__tapvpwrvgnd_1
X_3904_ _8308_/Q _4032_/B _4160_/B _8227_/Q _3791_/A VGND VGND VPWR VPWR _3904_/X
+ sky130_fd_sc_hd__o221a_2
X_7672_ _8646_/CLK _7672_/D load_slew529/X VGND VGND VPWR VPWR _7672_/Q sky130_fd_sc_hd__dfrtp_2
XFILLER_32_372 VGND VGND VPWR VPWR sky130_fd_sc_hd__fill_1
XFILLER_60_670 VGND VGND VPWR VPWR sky130_fd_sc_hd__fill_2
X_6623_ _4875_/X _8361_/Q _6633_/S VGND VGND VPWR VPWR _6624_/A sky130_fd_sc_hd__mux2_2
X_4884_ _4883_/X _7543_/Q _4896_/S VGND VGND VPWR VPWR _4885_/A sky130_fd_sc_hd__mux2_2
XTAP_TAPCELL_ROW_43_890 VGND VPWR sky130_fd_sc_hd__tapvpwrvgnd_1
X_3835_ _8383_/Q _8464_/Q _8545_/Q _8626_/Q _3778_/S _3835_/S1 VGND VGND VPWR VPWR
+ _3835_/X sky130_fd_sc_hd__mux4_2
X_3766_ _3921_/A VGND VGND VPWR VPWR _3767_/A sky130_fd_sc_hd__clkbuf_2
X_6554_ _4735_/X _8328_/Q _6570_/S VGND VGND VPWR VPWR _6555_/A sky130_fd_sc_hd__mux2_2
X_6485_ _6485_/A VGND VGND VPWR VPWR _8296_/D sky130_fd_sc_hd__buf_1
X_5505_ _7800_/Q _4940_/A _5505_/S VGND VGND VPWR VPWR _5506_/A sky130_fd_sc_hd__mux2_2
XFILLER_10_15 VGND VGND VPWR VPWR sky130_fd_sc_hd__decap_3
XFILLER_118_477 VGND VGND VPWR VPWR sky130_fd_sc_hd__decap_3
XFILLER_133_414 VGND VGND VPWR VPWR sky130_fd_sc_hd__decap_3
X_8224_ _8792_/CLK _8224_/D fanout658/X VGND VGND VPWR VPWR _8224_/Q sky130_fd_sc_hd__dfrtp_2
X_5436_ _7767_/Q _4802_/A _5440_/S VGND VGND VPWR VPWR _5437_/A sky130_fd_sc_hd__mux2_2
XFILLER_10_59 VGND VGND VPWR VPWR sky130_fd_sc_hd__decap_3
XFILLER_126_15 VGND VGND VPWR VPWR sky130_fd_sc_hd__decap_3
XFILLER_133_447 VGND VGND VPWR VPWR sky130_fd_sc_hd__fill_1
XFILLER_133_458 VGND VGND VPWR VPWR sky130_fd_sc_hd__decap_3
XFILLER_114_661 VGND VGND VPWR VPWR sky130_fd_sc_hd__decap_3
XFILLER_126_59 VGND VGND VPWR VPWR sky130_fd_sc_hd__decap_3
XFILLER_86_19 VGND VGND VPWR VPWR sky130_fd_sc_hd__decap_3
XTAP_TAPCELL_ROW_93_1594 VGND VPWR sky130_fd_sc_hd__tapvpwrvgnd_1
X_8155_ _8560_/CLK _8155_/D _8053_/SET_B VGND VGND VPWR VPWR _8155_/Q sky130_fd_sc_hd__dfrtp_2
X_5367_ _7734_/Q input8/X _5377_/S VGND VGND VPWR VPWR _5368_/A sky130_fd_sc_hd__mux2_2
XFILLER_59_225 VGND VGND VPWR VPWR sky130_fd_sc_hd__decap_3
X_8086_ _8740_/CLK _8086_/D fanout535/X VGND VGND VPWR VPWR _8086_/Q sky130_fd_sc_hd__dfrtp_2
X_7106_ _7106_/A VGND VGND VPWR VPWR _8587_/D sky130_fd_sc_hd__buf_2
X_5298_ _7702_/Q _4871_/X _5310_/S VGND VGND VPWR VPWR _5299_/A sky130_fd_sc_hd__mux2_2
X_4318_ _7687_/Q _3774_/X _4317_/X _3739_/B _4336_/C1 VGND VGND VPWR VPWR _4318_/X
+ sky130_fd_sc_hd__o221a_2
XFILLER_101_355 VGND VGND VPWR VPWR sky130_fd_sc_hd__fill_1
XFILLER_19_24 VGND VGND VPWR VPWR sky130_fd_sc_hd__decap_3
XFILLER_59_269 VGND VGND VPWR VPWR sky130_fd_sc_hd__decap_3
XFILLER_75_729 VGND VGND VPWR VPWR sky130_fd_sc_hd__fill_2
XFILLER_87_589 VGND VGND VPWR VPWR sky130_fd_sc_hd__decap_3
X_7037_ _7037_/A VGND VGND VPWR VPWR _8554_/D sky130_fd_sc_hd__buf_2
X_4249_ _4244_/X _4245_/X _4246_/X _4248_/X VGND VGND VPWR VPWR _4249_/X sky130_fd_sc_hd__a22o_2
XFILLER_19_57 VGND VGND VPWR VPWR sky130_fd_sc_hd__decap_3
XFILLER_28_601 VGND VGND VPWR VPWR sky130_fd_sc_hd__decap_3
XFILLER_74_206 VGND VGND VPWR VPWR sky130_fd_sc_hd__decap_3
XFILLER_27_111 VGND VGND VPWR VPWR sky130_fd_sc_hd__fill_1
XFILLER_27_133 VGND VGND VPWR VPWR sky130_fd_sc_hd__decap_3
XFILLER_28_645 VGND VGND VPWR VPWR sky130_fd_sc_hd__decap_3
XFILLER_28_656 VGND VGND VPWR VPWR sky130_fd_sc_hd__decap_3
XFILLER_55_420 VGND VGND VPWR VPWR sky130_fd_sc_hd__fill_2
XFILLER_83_762 VGND VGND VPWR VPWR sky130_fd_sc_hd__fill_1
XFILLER_27_166 VGND VGND VPWR VPWR sky130_fd_sc_hd__fill_2
XFILLER_28_689 VGND VGND VPWR VPWR sky130_fd_sc_hd__fill_2
XFILLER_35_12 VGND VGND VPWR VPWR sky130_fd_sc_hd__decap_3
XFILLER_70_401 VGND VGND VPWR VPWR sky130_fd_sc_hd__fill_2
XFILLER_70_445 VGND VGND VPWR VPWR sky130_fd_sc_hd__decap_3
X_7939_ _8759_/CLK _7939_/D fanout708/X VGND VGND VPWR VPWR _7939_/Q sky130_fd_sc_hd__dfrtp_2
XFILLER_42_147 VGND VGND VPWR VPWR sky130_fd_sc_hd__decap_3
XFILLER_70_467 VGND VGND VPWR VPWR sky130_fd_sc_hd__decap_3
XFILLER_129_709 VGND VGND VPWR VPWR sky130_fd_sc_hd__decap_3
XFILLER_51_670 VGND VGND VPWR VPWR sky130_fd_sc_hd__fill_2
XFILLER_70_489 VGND VGND VPWR VPWR sky130_fd_sc_hd__decap_3
XFILLER_11_567 VGND VGND VPWR VPWR sky130_fd_sc_hd__fill_1
XFILLER_7_505 VGND VGND VPWR VPWR sky130_fd_sc_hd__decap_3
XFILLER_11_578 VGND VGND VPWR VPWR sky130_fd_sc_hd__decap_3
XFILLER_11_589 VGND VGND VPWR VPWR sky130_fd_sc_hd__decap_3
XFILLER_109_455 VGND VGND VPWR VPWR sky130_fd_sc_hd__fill_1
XTAP_TAPCELL_ROW_21_584 VGND VPWR sky130_fd_sc_hd__tapvpwrvgnd_1
XFILLER_3_700 VGND VGND VPWR VPWR sky130_fd_sc_hd__decap_3
XFILLER_124_436 VGND VGND VPWR VPWR sky130_fd_sc_hd__decap_3
XFILLER_2_221 VGND VGND VPWR VPWR sky130_fd_sc_hd__decap_3
XFILLER_3_744 VGND VGND VPWR VPWR sky130_fd_sc_hd__decap_3
XFILLER_3_777 VGND VGND VPWR VPWR sky130_fd_sc_hd__decap_3
XFILLER_3_788 VGND VGND VPWR VPWR sky130_fd_sc_hd__decap_3
Xload_slew419 _4471_/S VGND VGND VPWR VPWR _4497_/S sky130_fd_sc_hd__buf_4
Xload_slew408 _4140_/S VGND VGND VPWR VPWR _4226_/S sky130_fd_sc_hd__buf_4
XFILLER_105_694 VGND VGND VPWR VPWR sky130_fd_sc_hd__decap_3
XFILLER_132_480 VGND VGND VPWR VPWR sky130_fd_sc_hd__decap_3
XFILLER_2_287 VGND VGND VPWR VPWR sky130_fd_sc_hd__fill_2
XTAP_TAPCELL_ROW_53_1033 VGND VPWR sky130_fd_sc_hd__tapvpwrvgnd_1
XFILLER_104_193 VGND VGND VPWR VPWR sky130_fd_sc_hd__decap_3
XFILLER_38_409 VGND VGND VPWR VPWR sky130_fd_sc_hd__fill_2
XFILLER_66_707 VGND VGND VPWR VPWR sky130_fd_sc_hd__decap_3
XFILLER_78_567 VGND VGND VPWR VPWR sky130_fd_sc_hd__fill_2
XFILLER_78_578 VGND VGND VPWR VPWR sky130_fd_sc_hd__fill_1
XFILLER_18_9 VGND VGND VPWR VPWR sky130_fd_sc_hd__decap_3
XFILLER_19_623 VGND VGND VPWR VPWR sky130_fd_sc_hd__fill_1
XFILLER_59_781 VGND VGND VPWR VPWR sky130_fd_sc_hd__decap_3
XFILLER_76_85 VGND VGND VPWR VPWR sky130_fd_sc_hd__decap_3
XFILLER_78_589 VGND VGND VPWR VPWR sky130_fd_sc_hd__fill_2
XTAP_TAPCELL_ROW_109_1822 VGND VPWR sky130_fd_sc_hd__tapvpwrvgnd_1
Xfanout580 fanout613/X VGND VGND VPWR VPWR fanout580/X sky130_fd_sc_hd__clkdlybuf4s25_1
XFILLER_18_122 VGND VGND VPWR VPWR sky130_fd_sc_hd__decap_3
XFILLER_46_431 VGND VGND VPWR VPWR sky130_fd_sc_hd__fill_2
XFILLER_58_280 VGND VGND VPWR VPWR sky130_fd_sc_hd__fill_1
XFILLER_132_80 VGND VGND VPWR VPWR sky130_fd_sc_hd__decap_3
XFILLER_18_144 VGND VGND VPWR VPWR sky130_fd_sc_hd__fill_2
XFILLER_18_166 VGND VGND VPWR VPWR sky130_fd_sc_hd__fill_2
XFILLER_34_604 VGND VGND VPWR VPWR sky130_fd_sc_hd__decap_3
XFILLER_74_773 VGND VGND VPWR VPWR sky130_fd_sc_hd__fill_2
XFILLER_132_91 VGND VGND VPWR VPWR sky130_fd_sc_hd__decap_3
XFILLER_18_188 VGND VGND VPWR VPWR sky130_fd_sc_hd__decap_3
XFILLER_33_125 VGND VGND VPWR VPWR sky130_fd_sc_hd__decap_3
XFILLER_34_637 VGND VGND VPWR VPWR sky130_fd_sc_hd__decap_3
XFILLER_34_648 VGND VGND VPWR VPWR sky130_fd_sc_hd__decap_3
XTAP_TAPCELL_ROW_29_695 VGND VPWR sky130_fd_sc_hd__tapvpwrvgnd_1
XFILLER_92_73 VGND VGND VPWR VPWR sky130_fd_sc_hd__fill_1
XFILLER_14_383 VGND VGND VPWR VPWR sky130_fd_sc_hd__decap_3
XTAP_TAPCELL_ROW_64_1184 VGND VPWR sky130_fd_sc_hd__tapvpwrvgnd_1
XFILLER_119_219 VGND VGND VPWR VPWR sky130_fd_sc_hd__decap_3
XTAP_TAPCELL_ROW_64_1195 VGND VPWR sky130_fd_sc_hd__tapvpwrvgnd_1
XFILLER_128_731 VGND VGND VPWR VPWR sky130_fd_sc_hd__decap_3
XFILLER_128_775 VGND VGND VPWR VPWR sky130_fd_sc_hd__decap_3
XFILLER_115_414 VGND VGND VPWR VPWR sky130_fd_sc_hd__decap_3
XFILLER_6_571 VGND VGND VPWR VPWR sky130_fd_sc_hd__fill_2
XFILLER_51_3 VGND VGND VPWR VPWR sky130_fd_sc_hd__decap_3
X_6270_ _6312_/S VGND VGND VPWR VPWR _6289_/S sky130_fd_sc_hd__buf_6
XFILLER_88_309 VGND VGND VPWR VPWR sky130_fd_sc_hd__decap_3
X_5221_ _5221_/A VGND VGND VPWR VPWR _7665_/D sky130_fd_sc_hd__buf_1
XFILLER_123_491 VGND VGND VPWR VPWR sky130_fd_sc_hd__decap_3
XFILLER_130_439 VGND VGND VPWR VPWR sky130_fd_sc_hd__decap_3
XFILLER_69_534 VGND VGND VPWR VPWR sky130_fd_sc_hd__fill_1
X_5152_ _4925_/X _7634_/Q _5158_/S VGND VGND VPWR VPWR _5153_/A sky130_fd_sc_hd__mux2_2
XFILLER_110_141 VGND VGND VPWR VPWR sky130_fd_sc_hd__decap_3
XFILLER_69_556 VGND VGND VPWR VPWR sky130_fd_sc_hd__fill_1
X_4103_ _8406_/Q _8487_/Q _8568_/Q _8649_/Q _4100_/S _4146_/A VGND VGND VPWR VPWR
+ _4103_/X sky130_fd_sc_hd__mux4_2
XFILLER_2_71 VGND VGND VPWR VPWR sky130_fd_sc_hd__decap_3
XFILLER_84_515 VGND VGND VPWR VPWR sky130_fd_sc_hd__decap_3
XFILLER_96_386 VGND VGND VPWR VPWR sky130_fd_sc_hd__fill_1
X_5083_ _4787_/X _7601_/Q _5095_/S VGND VGND VPWR VPWR _5084_/A sky130_fd_sc_hd__mux2_2
XFILLER_56_239 VGND VGND VPWR VPWR sky130_fd_sc_hd__decap_3
X_4034_ _7904_/Q _3785_/X _4033_/X _4036_/A wire302/A VGND VGND VPWR VPWR _4034_/X
+ sky130_fd_sc_hd__o221a_2
XFILLER_25_615 VGND VGND VPWR VPWR sky130_fd_sc_hd__fill_1
XFILLER_64_261 VGND VGND VPWR VPWR sky130_fd_sc_hd__decap_3
XTAP_TAPCELL_ROW_48_960 VGND VPWR sky130_fd_sc_hd__tapvpwrvgnd_1
XTAP_TAPCELL_ROW_48_971 VGND VPWR sky130_fd_sc_hd__tapvpwrvgnd_1
XFILLER_64_294 VGND VGND VPWR VPWR sky130_fd_sc_hd__fill_1
X_8773_ _8773_/CLK _8773_/D load_slew740/X VGND VGND VPWR VPWR _8773_/Q sky130_fd_sc_hd__dfrtp_2
XFILLER_24_147 VGND VGND VPWR VPWR sky130_fd_sc_hd__decap_3
XFILLER_40_607 VGND VGND VPWR VPWR sky130_fd_sc_hd__fill_1
X_7724_ _8382_/CLK _7724_/D fanout677/X VGND VGND VPWR VPWR _7724_/Q sky130_fd_sc_hd__dfrtp_2
X_5985_ _5985_/A VGND VGND VPWR VPWR _8060_/D sky130_fd_sc_hd__buf_1
XFILLER_33_681 VGND VGND VPWR VPWR sky130_fd_sc_hd__decap_3
X_4936_ _4936_/A _4936_/B VGND VGND VPWR VPWR _4937_/A sky130_fd_sc_hd__and2_2
XFILLER_20_320 VGND VGND VPWR VPWR sky130_fd_sc_hd__decap_3
X_7655_ _8637_/CLK _7655_/D fanout595/A VGND VGND VPWR VPWR _7655_/Q sky130_fd_sc_hd__dfrtp_2
X_4867_ _7455_/A VGND VGND VPWR VPWR _4904_/S sky130_fd_sc_hd__buf_2
X_3818_ _8624_/Q _3816_/X _3817_/X _8543_/Q VGND VGND VPWR VPWR _3818_/X sky130_fd_sc_hd__o22a_2
Xclkbuf_5_23__f_CLK clkbuf_4_11_0_CLK/X VGND VGND VPWR VPWR clkload8/A sky130_fd_sc_hd__clkbuf_16
X_7586_ _8658_/CLK _7586_/D load_slew515/X VGND VGND VPWR VPWR _7586_/Q sky130_fd_sc_hd__dfrtp_2
X_6606_ _4841_/X _8353_/Q _6612_/S VGND VGND VPWR VPWR _6607_/A sky130_fd_sc_hd__mux2_2
XFILLER_21_36 VGND VGND VPWR VPWR sky130_fd_sc_hd__decap_3
X_6537_ _4703_/X _8320_/Q _6549_/S VGND VGND VPWR VPWR _6538_/A sky130_fd_sc_hd__mux2_2
X_4798_ _4798_/A _4818_/B VGND VGND VPWR VPWR _4799_/A sky130_fd_sc_hd__and2_2
XFILLER_106_414 VGND VGND VPWR VPWR sky130_fd_sc_hd__decap_3
XFILLER_134_701 VGND VGND VPWR VPWR sky130_fd_sc_hd__decap_3
XFILLER_21_69 VGND VGND VPWR VPWR sky130_fd_sc_hd__decap_3
XTAP_TAPCELL_ROW_95_1623 VGND VPWR sky130_fd_sc_hd__tapvpwrvgnd_1
X_3749_ _3749_/A VGND VGND VPWR VPWR _3762_/A sky130_fd_sc_hd__clkbuf_1
XFILLER_106_436 VGND VGND VPWR VPWR sky130_fd_sc_hd__decap_3
XFILLER_133_211 VGND VGND VPWR VPWR sky130_fd_sc_hd__decap_3
XFILLER_134_734 VGND VGND VPWR VPWR sky130_fd_sc_hd__decap_3
X_6468_ _4908_/X _8288_/Q _6482_/S VGND VGND VPWR VPWR _6469_/A sky130_fd_sc_hd__mux2_2
XFILLER_133_255 VGND VGND VPWR VPWR sky130_fd_sc_hd__decap_3
XFILLER_134_778 VGND VGND VPWR VPWR sky130_fd_sc_hd__decap_3
XFILLER_79_309 VGND VGND VPWR VPWR sky130_fd_sc_hd__decap_3
Xoutput150 _4537_/X VGND VGND VPWR VPWR rdata[67] sky130_fd_sc_hd__clkdlybuf4s25_1
Xoutput161 _4654_/X VGND VGND VPWR VPWR rdata[77] sky130_fd_sc_hd__clkdlybuf4s25_1
X_8207_ _8757_/CLK _8207_/D load_slew742/X VGND VGND VPWR VPWR _8207_/Q sky130_fd_sc_hd__dfrtp_2
X_6399_ _6399_/A VGND VGND VPWR VPWR _8255_/D sky130_fd_sc_hd__buf_2
X_5419_ _7759_/Q _4768_/A _5419_/S VGND VGND VPWR VPWR _5420_/A sky130_fd_sc_hd__mux2_2
XFILLER_0_725 VGND VGND VPWR VPWR sky130_fd_sc_hd__decap_3
XFILLER_0_747 VGND VGND VPWR VPWR sky130_fd_sc_hd__decap_3
XFILLER_114_480 VGND VGND VPWR VPWR sky130_fd_sc_hd__decap_3
XFILLER_133_299 VGND VGND VPWR VPWR sky130_fd_sc_hd__decap_3
X_8138_ _8786_/CLK _8138_/D load_slew667/X VGND VGND VPWR VPWR _8138_/Q sky130_fd_sc_hd__dfrtp_2
XFILLER_0_769 VGND VGND VPWR VPWR sky130_fd_sc_hd__decap_3
X_8069_ _8795_/CLK _8069_/D fanout601/X VGND VGND VPWR VPWR _8069_/Q sky130_fd_sc_hd__dfrtp_2
XFILLER_16_604 VGND VGND VPWR VPWR sky130_fd_sc_hd__decap_3
XFILLER_46_44 VGND VGND VPWR VPWR sky130_fd_sc_hd__decap_3
XFILLER_83_570 VGND VGND VPWR VPWR sky130_fd_sc_hd__fill_2
XFILLER_15_125 VGND VGND VPWR VPWR sky130_fd_sc_hd__decap_3
XFILLER_71_721 VGND VGND VPWR VPWR sky130_fd_sc_hd__decap_3
XTAP_TAPCELL_ROW_104_1752 VGND VPWR sky130_fd_sc_hd__tapvpwrvgnd_1
XTAP_TAPCELL_ROW_26_654 VGND VPWR sky130_fd_sc_hd__tapvpwrvgnd_1
XFILLER_102_83 VGND VGND VPWR VPWR sky130_fd_sc_hd__fill_1
XFILLER_43_478 VGND VGND VPWR VPWR sky130_fd_sc_hd__decap_3
XFILLER_129_517 VGND VGND VPWR VPWR sky130_fd_sc_hd__decap_3
XFILLER_24_692 VGND VGND VPWR VPWR sky130_fd_sc_hd__decap_3
XFILLER_62_76 VGND VGND VPWR VPWR sky130_fd_sc_hd__decap_3
XFILLER_7_27 VGND VGND VPWR VPWR sky130_fd_sc_hd__decap_3
XFILLER_11_386 VGND VGND VPWR VPWR sky130_fd_sc_hd__decap_3
XFILLER_124_200 VGND VGND VPWR VPWR sky130_fd_sc_hd__decap_3
XFILLER_125_723 VGND VGND VPWR VPWR sky130_fd_sc_hd__fill_2
XTAP_TAPCELL_ROW_133_2148 VGND VPWR sky130_fd_sc_hd__tapvpwrvgnd_1
XTAP_TAPCELL_ROW_133_2159 VGND VPWR sky130_fd_sc_hd__tapvpwrvgnd_1
XFILLER_78_320 VGND VGND VPWR VPWR sky130_fd_sc_hd__decap_3
XFILLER_87_51 VGND VGND VPWR VPWR sky130_fd_sc_hd__decap_3
XFILLER_39_729 VGND VGND VPWR VPWR sky130_fd_sc_hd__decap_3
XFILLER_16_6 VGND VGND VPWR VPWR sky130_fd_sc_hd__decap_3
XFILLER_47_740 VGND VGND VPWR VPWR sky130_fd_sc_hd__decap_3
XFILLER_93_378 VGND VGND VPWR VPWR sky130_fd_sc_hd__fill_2
XTAP_TAPCELL_ROW_66_1213 VGND VPWR sky130_fd_sc_hd__tapvpwrvgnd_1
XFILLER_61_275 VGND VGND VPWR VPWR sky130_fd_sc_hd__decap_3
X_5770_ _7924_/Q _4782_/A _5784_/S VGND VGND VPWR VPWR _5771_/A sky130_fd_sc_hd__mux2_2
X_4721_ _4721_/A VGND VGND VPWR VPWR _7504_/D sky130_fd_sc_hd__buf_1
X_7440_ _7440_/A VGND VGND VPWR VPWR _8776_/D sky130_fd_sc_hd__buf_1
X_4652_ _8040_/Q _4652_/A2 _4652_/B1 _7959_/Q VGND VGND VPWR VPWR _4652_/X sky130_fd_sc_hd__o22a_2
Xinput30 wdata[34] VGND VGND VPWR VPWR _4748_/A sky130_fd_sc_hd__clkdlybuf4s25_1
XFILLER_116_701 VGND VGND VPWR VPWR sky130_fd_sc_hd__decap_3
XFILLER_128_572 VGND VGND VPWR VPWR sky130_fd_sc_hd__decap_3
Xhold803 _7968_/Q VGND VGND VPWR VPWR hold803/X sky130_fd_sc_hd__dlygate4sd3_1
Xinput41 wdata[44] VGND VGND VPWR VPWR _4790_/A sky130_fd_sc_hd__clkdlybuf4s25_1
Xinput52 wdata[54] VGND VGND VPWR VPWR _4832_/A sky130_fd_sc_hd__clkdlybuf4s25_1
Xinput63 wdata[64] VGND VGND VPWR VPWR _4874_/A sky130_fd_sc_hd__clkdlybuf4s25_1
X_7371_ _7371_/A VGND VGND VPWR VPWR _8743_/D sky130_fd_sc_hd__buf_1
X_4583_ _4617_/B1 _4582_/X _4617_/A1 VGND VGND VPWR VPWR _4583_/X sky130_fd_sc_hd__a21o_2
XTAP_TAPCELL_ROW_77_1364 VGND VPWR sky130_fd_sc_hd__tapvpwrvgnd_1
Xhold814 _7979_/Q VGND VGND VPWR VPWR hold814/X sky130_fd_sc_hd__dlygate4sd3_1
Xhold825 _8629_/Q VGND VGND VPWR VPWR hold825/X sky130_fd_sc_hd__dlygate4sd3_1
Xhold836 _8624_/Q VGND VGND VPWR VPWR hold836/X sky130_fd_sc_hd__dlygate4sd3_1
Xinput74 wdata[74] VGND VGND VPWR VPWR _4916_/A sky130_fd_sc_hd__clkdlybuf4s25_1
X_6322_ _6322_/A VGND VGND VPWR VPWR _8218_/D sky130_fd_sc_hd__buf_2
XFILLER_131_715 VGND VGND VPWR VPWR sky130_fd_sc_hd__decap_3
XFILLER_88_106 VGND VGND VPWR VPWR sky130_fd_sc_hd__fill_1
XTAP_TAPCELL_ROW_77_1375 VGND VPWR sky130_fd_sc_hd__tapvpwrvgnd_1
Xhold847 _8701_/Q VGND VGND VPWR VPWR hold847/X sky130_fd_sc_hd__dlygate4sd3_1
Xhold858 _8644_/Q VGND VGND VPWR VPWR hold858/X sky130_fd_sc_hd__dlygate4sd3_1
Xhold869 _7972_/Q VGND VGND VPWR VPWR hold869/X sky130_fd_sc_hd__dlygate4sd3_1
X_6253_ _6253_/A VGND VGND VPWR VPWR _8186_/D sky130_fd_sc_hd__buf_6
XFILLER_103_417 VGND VGND VPWR VPWR sky130_fd_sc_hd__decap_3
XFILLER_130_203 VGND VGND VPWR VPWR sky130_fd_sc_hd__decap_3
XFILLER_131_759 VGND VGND VPWR VPWR sky130_fd_sc_hd__decap_3
X_5204_ _5204_/A VGND VGND VPWR VPWR _7657_/D sky130_fd_sc_hd__buf_1
XFILLER_130_236 VGND VGND VPWR VPWR sky130_fd_sc_hd__decap_3
XTAP_TAPCELL_ROW_90_1553 VGND VPWR sky130_fd_sc_hd__tapvpwrvgnd_1
Xload_slew750 fanout749/X VGND VGND VPWR VPWR load_slew750/X sky130_fd_sc_hd__clkbuf_4
X_6184_ _5027_/X _8154_/Q _6184_/S VGND VGND VPWR VPWR _6185_/A sky130_fd_sc_hd__mux2_4
XFILLER_111_461 VGND VGND VPWR VPWR sky130_fd_sc_hd__decap_3
XFILLER_29_206 VGND VGND VPWR VPWR sky130_fd_sc_hd__decap_3
XFILLER_97_673 VGND VGND VPWR VPWR sky130_fd_sc_hd__decap_3
XTAP_TAPCELL_ROW_4_349 VGND VPWR sky130_fd_sc_hd__tapvpwrvgnd_1
X_5135_ _4891_/X _7626_/Q _5137_/S VGND VGND VPWR VPWR _5136_/A sky130_fd_sc_hd__mux2_2
XFILLER_123_49 VGND VGND VPWR VPWR sky130_fd_sc_hd__decap_3
XFILLER_96_194 VGND VGND VPWR VPWR sky130_fd_sc_hd__fill_2
X_5066_ _4753_/X _7593_/Q _5074_/S VGND VGND VPWR VPWR _5067_/A sky130_fd_sc_hd__mux2_2
XFILLER_44_209 VGND VGND VPWR VPWR sky130_fd_sc_hd__decap_3
X_4017_ _7740_/Q _7821_/Q _7902_/Q _7983_/Q _3719_/C _4017_/S1 VGND VGND VPWR VPWR
+ _4017_/X sky130_fd_sc_hd__mux4_2
XFILLER_25_401 VGND VGND VPWR VPWR sky130_fd_sc_hd__decap_3
XFILLER_65_570 VGND VGND VPWR VPWR sky130_fd_sc_hd__decap_3
XFILLER_16_47 VGND VGND VPWR VPWR sky130_fd_sc_hd__decap_3
XFILLER_52_253 VGND VGND VPWR VPWR sky130_fd_sc_hd__decap_3
XFILLER_40_404 VGND VGND VPWR VPWR sky130_fd_sc_hd__fill_1
XFILLER_80_584 VGND VGND VPWR VPWR sky130_fd_sc_hd__decap_3
XFILLER_80_595 VGND VGND VPWR VPWR sky130_fd_sc_hd__decap_3
XTAP_TAPCELL_ROW_23_613 VGND VPWR sky130_fd_sc_hd__tapvpwrvgnd_1
X_8756_ _8756_/CLK _8756_/D load_slew722/X VGND VGND VPWR VPWR _8756_/Q sky130_fd_sc_hd__dfrtp_2
X_5968_ _8053_/Q _7177_/A VGND VGND VPWR VPWR _5968_/X sky130_fd_sc_hd__and2_2
XFILLER_12_139 VGND VGND VPWR VPWR sky130_fd_sc_hd__fill_1
X_7707_ _8770_/CLK _7707_/D fanout549/X VGND VGND VPWR VPWR _7707_/Q sky130_fd_sc_hd__dfrtp_2
X_4919_ _4919_/A VGND VGND VPWR VPWR _7551_/D sky130_fd_sc_hd__buf_1
XFILLER_21_673 VGND VGND VPWR VPWR sky130_fd_sc_hd__decap_3
XFILLER_32_35 VGND VGND VPWR VPWR sky130_fd_sc_hd__decap_3
X_8687_ _8687_/CLK _8687_/D fanout577/X VGND VGND VPWR VPWR _8687_/Q sky130_fd_sc_hd__dfrtp_2
X_5899_ _5906_/A1 _5906_/A2 _4740_/X _5906_/B1 hold837/X VGND VGND VPWR VPWR _7995_/D
+ sky130_fd_sc_hd__a32o_2
XFILLER_120_6 VGND VGND VPWR VPWR sky130_fd_sc_hd__fill_1
X_7638_ _8782_/CLK _7638_/D load_slew649/X VGND VGND VPWR VPWR _7638_/Q sky130_fd_sc_hd__dfrtp_2
XFILLER_119_561 VGND VGND VPWR VPWR sky130_fd_sc_hd__fill_1
X_7569_ _8794_/CLK _7569_/D fanout581/X VGND VGND VPWR VPWR _7569_/Q sky130_fd_sc_hd__dfrtp_2
XFILLER_134_531 VGND VGND VPWR VPWR sky130_fd_sc_hd__fill_1
XFILLER_134_542 VGND VGND VPWR VPWR sky130_fd_sc_hd__decap_3
XFILLER_4_327 VGND VGND VPWR VPWR sky130_fd_sc_hd__decap_3
XFILLER_107_778 VGND VGND VPWR VPWR sky130_fd_sc_hd__decap_3
XFILLER_122_704 VGND VGND VPWR VPWR sky130_fd_sc_hd__fill_1
XFILLER_134_575 VGND VGND VPWR VPWR sky130_fd_sc_hd__fill_2
XFILLER_79_106 VGND VGND VPWR VPWR sky130_fd_sc_hd__decap_3
XFILLER_121_225 VGND VGND VPWR VPWR sky130_fd_sc_hd__fill_2
XFILLER_122_726 VGND VGND VPWR VPWR sky130_fd_sc_hd__decap_3
XFILLER_0_533 VGND VGND VPWR VPWR sky130_fd_sc_hd__fill_1
XFILLER_88_651 VGND VGND VPWR VPWR sky130_fd_sc_hd__decap_3
XFILLER_102_472 VGND VGND VPWR VPWR sky130_fd_sc_hd__decap_3
XFILLER_121_269 VGND VGND VPWR VPWR sky130_fd_sc_hd__decap_3
XFILLER_130_781 VGND VGND VPWR VPWR sky130_fd_sc_hd__decap_3
XFILLER_87_172 VGND VGND VPWR VPWR sky130_fd_sc_hd__decap_3
XFILLER_94_109 VGND VGND VPWR VPWR sky130_fd_sc_hd__decap_3
XFILLER_48_548 VGND VGND VPWR VPWR sky130_fd_sc_hd__fill_1
XFILLER_57_76 VGND VGND VPWR VPWR sky130_fd_sc_hd__decap_3
XFILLER_28_250 VGND VGND VPWR VPWR sky130_fd_sc_hd__fill_2
XFILLER_113_60 VGND VGND VPWR VPWR sky130_fd_sc_hd__fill_2
XFILLER_90_315 VGND VGND VPWR VPWR sky130_fd_sc_hd__decap_3
XFILLER_44_776 VGND VGND VPWR VPWR sky130_fd_sc_hd__decap_3
XFILLER_16_489 VGND VGND VPWR VPWR sky130_fd_sc_hd__fill_1
XFILLER_43_264 VGND VGND VPWR VPWR sky130_fd_sc_hd__fill_1
XFILLER_71_584 VGND VGND VPWR VPWR sky130_fd_sc_hd__decap_3
XFILLER_12_640 VGND VGND VPWR VPWR sky130_fd_sc_hd__decap_3
XFILLER_8_622 VGND VGND VPWR VPWR sky130_fd_sc_hd__decap_3
XTAP_TAPCELL_ROW_61_1143 VGND VPWR sky130_fd_sc_hd__tapvpwrvgnd_1
XFILLER_7_110 VGND VGND VPWR VPWR sky130_fd_sc_hd__fill_2
XFILLER_7_143 VGND VGND VPWR VPWR sky130_fd_sc_hd__fill_2
XFILLER_8_666 VGND VGND VPWR VPWR sky130_fd_sc_hd__decap_3
XTAP_TAPCELL_ROW_117_1932 VGND VPWR sky130_fd_sc_hd__tapvpwrvgnd_1
XFILLER_8_699 VGND VGND VPWR VPWR sky130_fd_sc_hd__fill_1
XFILLER_125_553 VGND VGND VPWR VPWR sky130_fd_sc_hd__decap_3
XFILLER_113_748 VGND VGND VPWR VPWR sky130_fd_sc_hd__decap_3
XFILLER_125_597 VGND VGND VPWR VPWR sky130_fd_sc_hd__decap_3
XFILLER_98_83 VGND VGND VPWR VPWR sky130_fd_sc_hd__fill_1
XFILLER_112_247 VGND VGND VPWR VPWR sky130_fd_sc_hd__decap_3
XFILLER_3_393 VGND VGND VPWR VPWR sky130_fd_sc_hd__decap_3
XFILLER_78_161 VGND VGND VPWR VPWR sky130_fd_sc_hd__decap_3
XTAP_TAPCELL_ROW_72_1294 VGND VPWR sky130_fd_sc_hd__tapvpwrvgnd_1
XFILLER_120_291 VGND VGND VPWR VPWR sky130_fd_sc_hd__decap_3
XFILLER_14_3 VGND VGND VPWR VPWR sky130_fd_sc_hd__decap_3
XFILLER_39_548 VGND VGND VPWR VPWR sky130_fd_sc_hd__decap_3
XFILLER_94_654 VGND VGND VPWR VPWR sky130_fd_sc_hd__decap_3
XFILLER_26_209 VGND VGND VPWR VPWR sky130_fd_sc_hd__decap_3
XFILLER_94_687 VGND VGND VPWR VPWR sky130_fd_sc_hd__fill_1
XTAP_TAPCELL_ROW_1_308 VGND VPWR sky130_fd_sc_hd__tapvpwrvgnd_1
X_6940_ _4815_/X _8509_/Q _6958_/S VGND VGND VPWR VPWR _6941_/A sky130_fd_sc_hd__mux2_4
XFILLER_81_337 VGND VGND VPWR VPWR sky130_fd_sc_hd__decap_3
XFILLER_19_294 VGND VGND VPWR VPWR sky130_fd_sc_hd__decap_3
X_6871_ _6871_/A VGND VGND VPWR VPWR _8476_/D sky130_fd_sc_hd__buf_6
XFILLER_34_253 VGND VGND VPWR VPWR sky130_fd_sc_hd__fill_2
XFILLER_34_264 VGND VGND VPWR VPWR sky130_fd_sc_hd__decap_3
XFILLER_50_724 VGND VGND VPWR VPWR sky130_fd_sc_hd__decap_3
X_8610_ _8772_/CLK _8610_/D fanout736/X VGND VGND VPWR VPWR _8610_/Q sky130_fd_sc_hd__dfrtp_2
X_5822_ _7949_/Q _4887_/A _5826_/S VGND VGND VPWR VPWR _5823_/A sky130_fd_sc_hd__mux2_2
XFILLER_34_297 VGND VGND VPWR VPWR sky130_fd_sc_hd__fill_1
X_8541_ _8622_/CLK _8541_/D fanout685/X VGND VGND VPWR VPWR _8541_/Q sky130_fd_sc_hd__dfrtp_2
X_5753_ _5753_/A0 _4749_/A _5763_/S VGND VGND VPWR VPWR _5754_/A sky130_fd_sc_hd__mux2_2
X_4704_ _4703_/X _7500_/Q _4736_/S VGND VGND VPWR VPWR _4705_/A sky130_fd_sc_hd__mux2_2
XTAP_TAPCELL_ROW_79_1404 VGND VPWR sky130_fd_sc_hd__tapvpwrvgnd_1
X_8472_ _8796_/CLK _8472_/D wire707/X VGND VGND VPWR VPWR _8472_/Q sky130_fd_sc_hd__dfrtp_2
X_5684_ _7883_/Q _4953_/A _5700_/S VGND VGND VPWR VPWR _5685_/A sky130_fd_sc_hd__mux2_2
XFILLER_135_306 VGND VGND VPWR VPWR sky130_fd_sc_hd__fill_2
X_7423_ _7423_/A VGND VGND VPWR VPWR _8768_/D sky130_fd_sc_hd__buf_1
X_4635_ _4629_/X _4631_/X _4633_/X _4634_/X VGND VGND VPWR VPWR _4635_/X sky130_fd_sc_hd__a22o_2
X_7354_ _7354_/A VGND VGND VPWR VPWR _8735_/D sky130_fd_sc_hd__buf_1
X_4566_ _8610_/Q _4600_/A2 _4565_/X _4569_/A wire326/A VGND VGND VPWR VPWR _4566_/X
+ sky130_fd_sc_hd__o221a_2
XTAP_TAPCELL_ROW_9_419 VGND VPWR sky130_fd_sc_hd__tapvpwrvgnd_1
X_6305_ _6305_/A VGND VGND VPWR VPWR _8211_/D sky130_fd_sc_hd__buf_6
XFILLER_103_225 VGND VGND VPWR VPWR sky130_fd_sc_hd__decap_3
XFILLER_131_523 VGND VGND VPWR VPWR sky130_fd_sc_hd__decap_3
X_7285_ _7285_/A VGND VGND VPWR VPWR _8702_/D sky130_fd_sc_hd__buf_1
X_4497_ _7783_/Q _7864_/Q _4497_/S VGND VGND VPWR VPWR _4498_/B sky130_fd_sc_hd__mux2_2
XFILLER_131_556 VGND VGND VPWR VPWR sky130_fd_sc_hd__decap_3
XFILLER_131_567 VGND VGND VPWR VPWR sky130_fd_sc_hd__decap_3
XFILLER_134_15 VGND VGND VPWR VPWR sky130_fd_sc_hd__decap_3
X_6236_ _6236_/A VGND VGND VPWR VPWR _8178_/D sky130_fd_sc_hd__buf_6
XFILLER_134_59 VGND VGND VPWR VPWR sky130_fd_sc_hd__decap_3
X_6167_ _6167_/A VGND VGND VPWR VPWR _8145_/D sky130_fd_sc_hd__buf_6
XFILLER_57_334 VGND VGND VPWR VPWR sky130_fd_sc_hd__fill_2
XFILLER_85_632 VGND VGND VPWR VPWR sky130_fd_sc_hd__decap_3
Xload_slew591 fanout590/X VGND VGND VPWR VPWR load_slew591/X sky130_fd_sc_hd__buf_4
X_5118_ _5118_/A VGND VGND VPWR VPWR _5137_/S sky130_fd_sc_hd__buf_2
XFILLER_27_24 VGND VGND VPWR VPWR sky130_fd_sc_hd__decap_3
X_6098_ _8114_/Q _4856_/A _6116_/S VGND VGND VPWR VPWR _6099_/A sky130_fd_sc_hd__mux2_2
XFILLER_27_57 VGND VGND VPWR VPWR sky130_fd_sc_hd__decap_3
XFILLER_38_581 VGND VGND VPWR VPWR sky130_fd_sc_hd__decap_3
XFILLER_85_698 VGND VGND VPWR VPWR sky130_fd_sc_hd__decap_3
X_5049_ _7063_/A0 _7585_/Q _5053_/S VGND VGND VPWR VPWR _5050_/A sky130_fd_sc_hd__mux2_2
XFILLER_41_724 VGND VGND VPWR VPWR sky130_fd_sc_hd__decap_3
XTAP_TAPCELL_ROW_101_1700 VGND VPWR sky130_fd_sc_hd__tapvpwrvgnd_1
XFILLER_13_426 VGND VGND VPWR VPWR sky130_fd_sc_hd__decap_3
XFILLER_41_735 VGND VGND VPWR VPWR sky130_fd_sc_hd__decap_3
XFILLER_43_34 VGND VGND VPWR VPWR sky130_fd_sc_hd__decap_3
XTAP_TAPCELL_ROW_101_1711 VGND VPWR sky130_fd_sc_hd__tapvpwrvgnd_1
XTAP_TAPCELL_ROW_36_793 VGND VPWR sky130_fd_sc_hd__tapvpwrvgnd_1
X_8739_ _8739_/CLK _8739_/D fanout508/X VGND VGND VPWR VPWR _8739_/Q sky130_fd_sc_hd__dfrtp_2
XFILLER_5_614 VGND VGND VPWR VPWR sky130_fd_sc_hd__fill_2
XFILLER_107_520 VGND VGND VPWR VPWR sky130_fd_sc_hd__fill_1
XFILLER_5_647 VGND VGND VPWR VPWR sky130_fd_sc_hd__decap_3
XTAP_TAPCELL_ROW_130_2107 VGND VPWR sky130_fd_sc_hd__tapvpwrvgnd_1
XFILLER_107_542 VGND VGND VPWR VPWR sky130_fd_sc_hd__fill_2
XFILLER_107_564 VGND VGND VPWR VPWR sky130_fd_sc_hd__decap_3
XFILLER_134_350 VGND VGND VPWR VPWR sky130_fd_sc_hd__decap_3
XFILLER_4_135 VGND VGND VPWR VPWR sky130_fd_sc_hd__fill_1
XTAP_TAPCELL_ROW_130_2118 VGND VPWR sky130_fd_sc_hd__tapvpwrvgnd_1
XFILLER_134_383 VGND VGND VPWR VPWR sky130_fd_sc_hd__decap_3
XFILLER_122_545 VGND VGND VPWR VPWR sky130_fd_sc_hd__decap_3
XTAP_TAPCELL_ROW_112_1862 VGND VPWR sky130_fd_sc_hd__tapvpwrvgnd_1
XFILLER_110_729 VGND VGND VPWR VPWR sky130_fd_sc_hd__decap_3
XFILLER_122_589 VGND VGND VPWR VPWR sky130_fd_sc_hd__decap_3
XFILLER_68_75 VGND VGND VPWR VPWR sky130_fd_sc_hd__decap_3
XFILLER_88_470 VGND VGND VPWR VPWR sky130_fd_sc_hd__fill_2
XFILLER_48_312 VGND VGND VPWR VPWR sky130_fd_sc_hd__decap_3
XFILLER_124_81 VGND VGND VPWR VPWR sky130_fd_sc_hd__decap_3
XFILLER_75_142 VGND VGND VPWR VPWR sky130_fd_sc_hd__decap_3
XFILLER_17_732 VGND VGND VPWR VPWR sky130_fd_sc_hd__decap_3
XFILLER_29_570 VGND VGND VPWR VPWR sky130_fd_sc_hd__decap_3
XFILLER_63_315 VGND VGND VPWR VPWR sky130_fd_sc_hd__decap_3
XFILLER_63_337 VGND VGND VPWR VPWR sky130_fd_sc_hd__decap_3
XFILLER_84_85 VGND VGND VPWR VPWR sky130_fd_sc_hd__fill_1
XFILLER_91_657 VGND VGND VPWR VPWR sky130_fd_sc_hd__decap_3
XFILLER_16_253 VGND VGND VPWR VPWR sky130_fd_sc_hd__fill_2
XFILLER_31_201 VGND VGND VPWR VPWR sky130_fd_sc_hd__fill_2
XFILLER_44_573 VGND VGND VPWR VPWR sky130_fd_sc_hd__decap_3
XFILLER_129_111 VGND VGND VPWR VPWR sky130_fd_sc_hd__fill_1
XFILLER_129_122 VGND VGND VPWR VPWR sky130_fd_sc_hd__decap_3
XFILLER_31_278 VGND VGND VPWR VPWR sky130_fd_sc_hd__fill_2
XTAP_TAPCELL_ROW_14_487 VGND VPWR sky130_fd_sc_hd__tapvpwrvgnd_1
XFILLER_129_155 VGND VGND VPWR VPWR sky130_fd_sc_hd__decap_3
XFILLER_129_199 VGND VGND VPWR VPWR sky130_fd_sc_hd__decap_3
XFILLER_8_485 VGND VGND VPWR VPWR sky130_fd_sc_hd__decap_3
X_4420_ _8111_/Q _8192_/Q _4446_/S VGND VGND VPWR VPWR _4420_/X sky130_fd_sc_hd__mux2_2
XFILLER_132_309 VGND VGND VPWR VPWR sky130_fd_sc_hd__decap_3
XFILLER_99_746 VGND VGND VPWR VPWR sky130_fd_sc_hd__decap_3
XTAP_TAPCELL_ROW_74_1323 VGND VPWR sky130_fd_sc_hd__tapvpwrvgnd_1
XTAP_TAPCELL_ROW_74_1334 VGND VPWR sky130_fd_sc_hd__tapvpwrvgnd_1
X_4351_ _4681_/A _4349_/X _4350_/X VGND VGND VPWR VPWR _4351_/X sky130_fd_sc_hd__o21a_2
XFILLER_101_707 VGND VGND VPWR VPWR sky130_fd_sc_hd__decap_3
XFILLER_98_245 VGND VGND VPWR VPWR sky130_fd_sc_hd__decap_3
Xfanout409 fanout414/X VGND VGND VPWR VPWR _4272_/S sky130_fd_sc_hd__clkdlybuf4s25_1
X_7070_ _4731_/X _8570_/Q _7088_/S VGND VGND VPWR VPWR _7071_/A sky130_fd_sc_hd__mux2_2
X_4282_ _7927_/Q _4600_/A2 _4281_/X _4681_/A _4684_/B2 VGND VGND VPWR VPWR _4282_/X
+ sky130_fd_sc_hd__o221a_2
XFILLER_101_729 VGND VGND VPWR VPWR sky130_fd_sc_hd__decap_3
XFILLER_113_567 VGND VGND VPWR VPWR sky130_fd_sc_hd__fill_2
XFILLER_113_578 VGND VGND VPWR VPWR sky130_fd_sc_hd__decap_3
XFILLER_86_418 VGND VGND VPWR VPWR sky130_fd_sc_hd__fill_2
X_6021_ _6021_/A VGND VGND VPWR VPWR _8077_/D sky130_fd_sc_hd__buf_2
XFILLER_100_239 VGND VGND VPWR VPWR sky130_fd_sc_hd__decap_3
XFILLER_66_120 VGND VGND VPWR VPWR sky130_fd_sc_hd__fill_2
XFILLER_104_29 VGND VGND VPWR VPWR sky130_fd_sc_hd__fill_1
XFILLER_67_676 VGND VGND VPWR VPWR sky130_fd_sc_hd__fill_1
XFILLER_54_315 VGND VGND VPWR VPWR sky130_fd_sc_hd__decap_3
XFILLER_66_164 VGND VGND VPWR VPWR sky130_fd_sc_hd__fill_2
XFILLER_67_698 VGND VGND VPWR VPWR sky130_fd_sc_hd__decap_3
X_7972_ _8387_/CLK _7972_/D load_slew655/X VGND VGND VPWR VPWR _7972_/Q sky130_fd_sc_hd__dfrtp_2
XFILLER_66_197 VGND VGND VPWR VPWR sky130_fd_sc_hd__fill_2
XFILLER_82_657 VGND VGND VPWR VPWR sky130_fd_sc_hd__decap_3
XFILLER_82_679 VGND VGND VPWR VPWR sky130_fd_sc_hd__fill_1
X_6923_ _4782_/X _8501_/Q _6937_/S VGND VGND VPWR VPWR _6924_/A sky130_fd_sc_hd__mux2_4
XFILLER_35_551 VGND VGND VPWR VPWR sky130_fd_sc_hd__decap_3
XTAP_TAPCELL_ROW_85_1485 VGND VPWR sky130_fd_sc_hd__tapvpwrvgnd_1
XFILLER_23_757 VGND VGND VPWR VPWR sky130_fd_sc_hd__decap_3
XFILLER_62_381 VGND VGND VPWR VPWR sky130_fd_sc_hd__decap_3
X_6854_ _6854_/A VGND VGND VPWR VPWR _8468_/D sky130_fd_sc_hd__buf_6
XFILLER_13_15 VGND VGND VPWR VPWR sky130_fd_sc_hd__decap_3
XFILLER_23_779 VGND VGND VPWR VPWR sky130_fd_sc_hd__decap_3
XTAP_TAPCELL_ROW_33_752 VGND VPWR sky130_fd_sc_hd__tapvpwrvgnd_1
X_3997_ _7900_/Q _4642_/A2 _3996_/X _3993_/A _4000_/A VGND VGND VPWR VPWR _3997_/X
+ sky130_fd_sc_hd__o221a_2
X_6785_ _6785_/A VGND VGND VPWR VPWR _8436_/D sky130_fd_sc_hd__buf_2
X_5805_ _7941_/Q _4853_/A _5805_/S VGND VGND VPWR VPWR _5806_/A sky130_fd_sc_hd__mux2_2
XFILLER_129_15 VGND VGND VPWR VPWR sky130_fd_sc_hd__decap_3
XFILLER_13_48 VGND VGND VPWR VPWR sky130_fd_sc_hd__decap_3
X_8524_ _8684_/CLK _8524_/D load_slew560/X VGND VGND VPWR VPWR _8524_/Q sky130_fd_sc_hd__dfrtp_2
X_5736_ _7908_/Q _4715_/A _5742_/S VGND VGND VPWR VPWR _5737_/A sky130_fd_sc_hd__mux2_2
XFILLER_108_306 VGND VGND VPWR VPWR sky130_fd_sc_hd__fill_2
XFILLER_129_48 VGND VGND VPWR VPWR sky130_fd_sc_hd__decap_3
X_8455_ _8779_/CLK _8455_/D fanout753/X VGND VGND VPWR VPWR _8455_/Q sky130_fd_sc_hd__dfrtp_2
X_5667_ _7876_/Q _4921_/A _5675_/S VGND VGND VPWR VPWR _5668_/A sky130_fd_sc_hd__mux2_2
XFILLER_108_328 VGND VGND VPWR VPWR sky130_fd_sc_hd__fill_2
XFILLER_135_103 VGND VGND VPWR VPWR sky130_fd_sc_hd__decap_3
XFILLER_135_125 VGND VGND VPWR VPWR sky130_fd_sc_hd__decap_3
X_7406_ _7406_/A VGND VGND VPWR VPWR _8760_/D sky130_fd_sc_hd__buf_1
X_4618_ _4673_/S _4609_/X _4612_/X _4615_/X _4617_/X VGND VGND VPWR VPWR _4618_/X
+ sky130_fd_sc_hd__o32a_2
XFILLER_135_147 VGND VGND VPWR VPWR sky130_fd_sc_hd__decap_3
XFILLER_135_169 VGND VGND VPWR VPWR sky130_fd_sc_hd__decap_3
X_8386_ _8545_/CLK _8386_/D fanout660/X VGND VGND VPWR VPWR _8386_/Q sky130_fd_sc_hd__dfrtp_2
X_5598_ _7843_/Q _4782_/A _5612_/S VGND VGND VPWR VPWR _5599_/A sky130_fd_sc_hd__mux2_2
XFILLER_104_501 VGND VGND VPWR VPWR sky130_fd_sc_hd__decap_3
XFILLER_1_105 VGND VGND VPWR VPWR sky130_fd_sc_hd__decap_3
XFILLER_1_116 VGND VGND VPWR VPWR sky130_fd_sc_hd__decap_3
XFILLER_2_628 VGND VGND VPWR VPWR sky130_fd_sc_hd__decap_3
Xmax_cap171 _7269_/X VGND VGND VPWR VPWR _7280_/A3 sky130_fd_sc_hd__buf_2
X_7337_ _7337_/A VGND VGND VPWR VPWR _8727_/D sky130_fd_sc_hd__buf_1
X_4549_ _8032_/Q _3969_/X _4548_/X VGND VGND VPWR VPWR _4549_/X sky130_fd_sc_hd__o21a_2
XFILLER_116_394 VGND VGND VPWR VPWR sky130_fd_sc_hd__decap_3
XFILLER_89_256 VGND VGND VPWR VPWR sky130_fd_sc_hd__decap_3
Xmax_cap193 _5857_/X VGND VGND VPWR VPWR _5865_/B1 sky130_fd_sc_hd__clkbuf_2
Xmax_cap182 _5934_/X VGND VGND VPWR VPWR _5944_/A2 sky130_fd_sc_hd__clkbuf_2
X_7268_ _7267_/X _4895_/X _7256_/X _7257_/X hold796/X VGND VGND VPWR VPWR _8690_/D
+ sky130_fd_sc_hd__a32o_2
X_6219_ _6219_/A VGND VGND VPWR VPWR _8170_/D sky130_fd_sc_hd__buf_6
XFILLER_131_386 VGND VGND VPWR VPWR sky130_fd_sc_hd__decap_3
XFILLER_57_120 VGND VGND VPWR VPWR sky130_fd_sc_hd__decap_3
X_7199_ _7189_/X _5015_/X _7201_/A3 wire207/X hold787/X VGND VGND VPWR VPWR _8637_/D
+ sky130_fd_sc_hd__a32o_2
XFILLER_38_67 VGND VGND VPWR VPWR sky130_fd_sc_hd__decap_3
XFILLER_57_153 VGND VGND VPWR VPWR sky130_fd_sc_hd__decap_3
XFILLER_58_654 VGND VGND VPWR VPWR sky130_fd_sc_hd__decap_3
XFILLER_38_89 VGND VGND VPWR VPWR sky130_fd_sc_hd__fill_1
XFILLER_58_687 VGND VGND VPWR VPWR sky130_fd_sc_hd__decap_3
XFILLER_73_635 VGND VGND VPWR VPWR sky130_fd_sc_hd__fill_1
XFILLER_85_473 VGND VGND VPWR VPWR sky130_fd_sc_hd__fill_2
XFILLER_45_337 VGND VGND VPWR VPWR sky130_fd_sc_hd__fill_1
XFILLER_73_679 VGND VGND VPWR VPWR sky130_fd_sc_hd__decap_3
XFILLER_13_223 VGND VGND VPWR VPWR sky130_fd_sc_hd__fill_1
XFILLER_14_757 VGND VGND VPWR VPWR sky130_fd_sc_hd__fill_1
XFILLER_53_370 VGND VGND VPWR VPWR sky130_fd_sc_hd__fill_1
XFILLER_54_88 VGND VGND VPWR VPWR sky130_fd_sc_hd__decap_3
XFILLER_81_690 VGND VGND VPWR VPWR sky130_fd_sc_hd__decap_3
XFILLER_110_50 VGND VGND VPWR VPWR sky130_fd_sc_hd__decap_3
XFILLER_14_779 VGND VGND VPWR VPWR sky130_fd_sc_hd__decap_3
XFILLER_110_94 VGND VGND VPWR VPWR sky130_fd_sc_hd__decap_3
XFILLER_13_278 VGND VGND VPWR VPWR sky130_fd_sc_hd__fill_2
XFILLER_41_598 VGND VGND VPWR VPWR sky130_fd_sc_hd__decap_3
XFILLER_70_32 VGND VGND VPWR VPWR sky130_fd_sc_hd__fill_2
XFILLER_70_43 VGND VGND VPWR VPWR sky130_fd_sc_hd__decap_3
XFILLER_127_615 VGND VGND VPWR VPWR sky130_fd_sc_hd__fill_1
XTAP_TAPCELL_ROW_11_446 VGND VPWR sky130_fd_sc_hd__tapvpwrvgnd_1
XFILLER_126_103 VGND VGND VPWR VPWR sky130_fd_sc_hd__decap_3
XFILLER_127_626 VGND VGND VPWR VPWR sky130_fd_sc_hd__decap_3
XFILLER_127_648 VGND VGND VPWR VPWR sky130_fd_sc_hd__decap_3
Xclkload19 _8483_/CLK VGND VGND VPWR VPWR clkload19/X sky130_fd_sc_hd__clkbuf_4
XFILLER_114_309 VGND VGND VPWR VPWR sky130_fd_sc_hd__decap_3
XFILLER_135_681 VGND VGND VPWR VPWR sky130_fd_sc_hd__decap_3
XFILLER_134_180 VGND VGND VPWR VPWR sky130_fd_sc_hd__decap_3
XFILLER_1_650 VGND VGND VPWR VPWR sky130_fd_sc_hd__decap_3
XTAP_TAPCELL_ROW_56_1075 VGND VPWR sky130_fd_sc_hd__tapvpwrvgnd_1
XFILLER_122_386 VGND VGND VPWR VPWR sky130_fd_sc_hd__decap_3
XFILLER_135_91 VGND VGND VPWR VPWR sky130_fd_sc_hd__decap_3
XFILLER_1_694 VGND VGND VPWR VPWR sky130_fd_sc_hd__decap_3
XFILLER_49_610 VGND VGND VPWR VPWR sky130_fd_sc_hd__decap_3
XFILLER_95_237 VGND VGND VPWR VPWR sky130_fd_sc_hd__decap_3
XFILLER_48_120 VGND VGND VPWR VPWR sky130_fd_sc_hd__decap_3
XFILLER_49_654 VGND VGND VPWR VPWR sky130_fd_sc_hd__fill_2
XFILLER_49_676 VGND VGND VPWR VPWR sky130_fd_sc_hd__decap_3
XFILLER_36_315 VGND VGND VPWR VPWR sky130_fd_sc_hd__fill_1
XFILLER_48_164 VGND VGND VPWR VPWR sky130_fd_sc_hd__decap_3
XFILLER_95_95 VGND VGND VPWR VPWR sky130_fd_sc_hd__decap_3
XFILLER_36_337 VGND VGND VPWR VPWR sky130_fd_sc_hd__decap_3
XFILLER_91_443 VGND VGND VPWR VPWR sky130_fd_sc_hd__decap_3
XTAP_TAPCELL_ROW_19_557 VGND VPWR sky130_fd_sc_hd__tapvpwrvgnd_1
XFILLER_17_551 VGND VGND VPWR VPWR sky130_fd_sc_hd__decap_3
XFILLER_91_487 VGND VGND VPWR VPWR sky130_fd_sc_hd__decap_3
X_3920_ _3993_/A _3920_/B VGND VGND VPWR VPWR _3920_/X sky130_fd_sc_hd__or2_2
XFILLER_32_543 VGND VGND VPWR VPWR sky130_fd_sc_hd__decap_3
XFILLER_32_576 VGND VGND VPWR VPWR sky130_fd_sc_hd__decap_3
X_3851_ _8627_/Q _3767_/A _3817_/A _8546_/Q _3831_/A VGND VGND VPWR VPWR _3851_/X
+ sky130_fd_sc_hd__o221a_2
XTAP_TAPCELL_ROW_30_711 VGND VPWR sky130_fd_sc_hd__tapvpwrvgnd_1
X_3782_ _8704_/Q _8785_/Q _3824_/S VGND VGND VPWR VPWR _3783_/B sky130_fd_sc_hd__mux2_2
Xclkbuf_5_4__f_CLK clkbuf_4_2_0_CLK/X VGND VGND VPWR VPWR clkbuf_5_4__f_CLK/X sky130_fd_sc_hd__clkbuf_16
X_6570_ _4769_/X _8336_/Q _6570_/S VGND VGND VPWR VPWR _6571_/A sky130_fd_sc_hd__mux2_2
XFILLER_9_750 VGND VGND VPWR VPWR sky130_fd_sc_hd__decap_3
X_5521_ _5521_/A VGND VGND VPWR VPWR _7806_/D sky130_fd_sc_hd__buf_1
XFILLER_8_271 VGND VGND VPWR VPWR sky130_fd_sc_hd__decap_3
XFILLER_9_783 VGND VGND VPWR VPWR sky130_fd_sc_hd__fill_1
XFILLER_9_794 VGND VGND VPWR VPWR sky130_fd_sc_hd__decap_3
X_8240_ _8645_/CLK _8240_/D load_slew501/X VGND VGND VPWR VPWR _8240_/Q sky130_fd_sc_hd__dfrtp_2
X_5452_ _5452_/A VGND VGND VPWR VPWR _7774_/D sky130_fd_sc_hd__buf_1
XFILLER_132_106 VGND VGND VPWR VPWR sky130_fd_sc_hd__decap_3
XFILLER_133_629 VGND VGND VPWR VPWR sky130_fd_sc_hd__decap_3
XFILLER_99_521 VGND VGND VPWR VPWR sky130_fd_sc_hd__decap_3
X_8171_ _8739_/CLK _8171_/D load_slew509/X VGND VGND VPWR VPWR _8171_/Q sky130_fd_sc_hd__dfrtp_2
X_5383_ _5383_/A VGND VGND VPWR VPWR _7741_/D sky130_fd_sc_hd__buf_1
X_4403_ _4415_/A _4403_/B VGND VGND VPWR VPWR _4403_/X sky130_fd_sc_hd__or2_2
XFILLER_126_692 VGND VGND VPWR VPWR sky130_fd_sc_hd__decap_3
XFILLER_132_139 VGND VGND VPWR VPWR sky130_fd_sc_hd__fill_1
XFILLER_5_60 VGND VGND VPWR VPWR sky130_fd_sc_hd__decap_3
X_7122_ _4837_/X _8595_/Q _7130_/S VGND VGND VPWR VPWR _7123_/A sky130_fd_sc_hd__mux2_2
X_4334_ _7769_/Q _7850_/Q _7931_/Q _8012_/Q _4247_/S _4344_/A VGND VGND VPWR VPWR
+ _4335_/B sky130_fd_sc_hd__mux4_2
XFILLER_5_93 VGND VGND VPWR VPWR sky130_fd_sc_hd__decap_3
XFILLER_87_705 VGND VGND VPWR VPWR sky130_fd_sc_hd__fill_2
X_7053_ _4691_/X _8562_/Q _7067_/S VGND VGND VPWR VPWR _7054_/A sky130_fd_sc_hd__mux2_2
X_6004_ _6004_/A VGND VGND VPWR VPWR _8069_/D sky130_fd_sc_hd__buf_1
X_4265_ _4336_/C1 _4259_/X _4264_/X VGND VGND VPWR VPWR _4265_/X sky130_fd_sc_hd__o21a_2
XFILLER_101_559 VGND VGND VPWR VPWR sky130_fd_sc_hd__fill_1
X_4196_ _4030_/S _4192_/X _4194_/X _4195_/X VGND VGND VPWR VPWR _4196_/X sky130_fd_sc_hd__a22o_2
XFILLER_39_175 VGND VGND VPWR VPWR sky130_fd_sc_hd__fill_1
XFILLER_95_782 VGND VGND VPWR VPWR sky130_fd_sc_hd__fill_2
XTAP_TAPCELL_ROW_38_822 VGND VPWR sky130_fd_sc_hd__tapvpwrvgnd_1
XTAP_TAPCELL_ROW_87_1514 VGND VPWR sky130_fd_sc_hd__tapvpwrvgnd_1
XFILLER_131_27 VGND VGND VPWR VPWR sky130_fd_sc_hd__decap_3
XFILLER_55_668 VGND VGND VPWR VPWR sky130_fd_sc_hd__decap_3
XFILLER_94_281 VGND VGND VPWR VPWR sky130_fd_sc_hd__decap_3
XFILLER_42_318 VGND VGND VPWR VPWR sky130_fd_sc_hd__decap_3
XFILLER_70_616 VGND VGND VPWR VPWR sky130_fd_sc_hd__decap_3
X_7955_ _8778_/CLK _7955_/D fanout732/A VGND VGND VPWR VPWR _7955_/Q sky130_fd_sc_hd__dfrtp_2
XFILLER_23_532 VGND VGND VPWR VPWR sky130_fd_sc_hd__decap_3
X_7886_ _8623_/CLK _7886_/D load_slew678/X VGND VGND VPWR VPWR _7886_/Q sky130_fd_sc_hd__dfrtp_2
X_6906_ _4749_/X _8493_/Q _6916_/S VGND VGND VPWR VPWR _6907_/A sky130_fd_sc_hd__mux2_4
XFILLER_24_47 VGND VGND VPWR VPWR sky130_fd_sc_hd__decap_3
X_6837_ _4953_/X _8460_/Q _6853_/S VGND VGND VPWR VPWR _6838_/A sky130_fd_sc_hd__mux2_4
XFILLER_11_727 VGND VGND VPWR VPWR sky130_fd_sc_hd__fill_1
XFILLER_11_738 VGND VGND VPWR VPWR sky130_fd_sc_hd__decap_3
XFILLER_23_576 VGND VGND VPWR VPWR sky130_fd_sc_hd__decap_3
XFILLER_50_362 VGND VGND VPWR VPWR sky130_fd_sc_hd__fill_2
XFILLER_109_604 VGND VGND VPWR VPWR sky130_fd_sc_hd__decap_3
XFILLER_10_237 VGND VGND VPWR VPWR sky130_fd_sc_hd__decap_3
XFILLER_10_259 VGND VGND VPWR VPWR sky130_fd_sc_hd__decap_3
XFILLER_7_709 VGND VGND VPWR VPWR sky130_fd_sc_hd__decap_3
Xwire618 wire618/A VGND VGND VPWR VPWR wire618/X sky130_fd_sc_hd__clkbuf_4
X_8507_ _8669_/CLK _8507_/D load_slew645/X VGND VGND VPWR VPWR _8507_/Q sky130_fd_sc_hd__dfrtp_2
X_6768_ _8428_/Q _4814_/A _6786_/S VGND VGND VPWR VPWR _6769_/A sky130_fd_sc_hd__mux2_2
XFILLER_109_637 VGND VGND VPWR VPWR sky130_fd_sc_hd__fill_2
XFILLER_109_648 VGND VGND VPWR VPWR sky130_fd_sc_hd__decap_3
XFILLER_40_24 VGND VGND VPWR VPWR sky130_fd_sc_hd__decap_3
XTAP_TAPCELL_ROW_98_1665 VGND VPWR sky130_fd_sc_hd__tapvpwrvgnd_1
X_6699_ _6699_/A VGND VGND VPWR VPWR _8395_/D sky130_fd_sc_hd__buf_2
X_5719_ _7900_/Q _5023_/A _5721_/S VGND VGND VPWR VPWR _5720_/A sky130_fd_sc_hd__mux2_2
XFILLER_108_147 VGND VGND VPWR VPWR sky130_fd_sc_hd__decap_3
X_8438_ _8766_/CLK _8438_/D wire600/X VGND VGND VPWR VPWR _8438_/Q sky130_fd_sc_hd__dfrtp_2
X_8369_ _8757_/CLK _8369_/D load_slew742/X VGND VGND VPWR VPWR _8369_/Q sky130_fd_sc_hd__dfrtp_2
XFILLER_104_320 VGND VGND VPWR VPWR sky130_fd_sc_hd__decap_3
XFILLER_132_640 VGND VGND VPWR VPWR sky130_fd_sc_hd__decap_3
XFILLER_49_11 VGND VGND VPWR VPWR sky130_fd_sc_hd__decap_3
XFILLER_132_651 VGND VGND VPWR VPWR sky130_fd_sc_hd__decap_3
XFILLER_2_469 VGND VGND VPWR VPWR sky130_fd_sc_hd__fill_1
XFILLER_131_161 VGND VGND VPWR VPWR sky130_fd_sc_hd__decap_3
XFILLER_131_172 VGND VGND VPWR VPWR sky130_fd_sc_hd__decap_3
XFILLER_132_684 VGND VGND VPWR VPWR sky130_fd_sc_hd__decap_3
Xfanout751 fanout753/X VGND VGND VPWR VPWR fanout751/X sky130_fd_sc_hd__clkdlybuf4s25_1
XFILLER_1_18 VGND VGND VPWR VPWR sky130_fd_sc_hd__decap_3
XFILLER_58_451 VGND VGND VPWR VPWR sky130_fd_sc_hd__decap_3
XFILLER_86_760 VGND VGND VPWR VPWR sky130_fd_sc_hd__decap_3
XFILLER_93_708 VGND VGND VPWR VPWR sky130_fd_sc_hd__fill_1
XFILLER_93_719 VGND VGND VPWR VPWR sky130_fd_sc_hd__decap_3
XFILLER_18_315 VGND VGND VPWR VPWR sky130_fd_sc_hd__fill_1
XFILLER_46_613 VGND VGND VPWR VPWR sky130_fd_sc_hd__decap_3
XFILLER_65_32 VGND VGND VPWR VPWR sky130_fd_sc_hd__decap_3
XTAP_TAPCELL_ROW_125_2039 VGND VPWR sky130_fd_sc_hd__tapvpwrvgnd_1
XFILLER_46_668 VGND VGND VPWR VPWR sky130_fd_sc_hd__decap_3
XFILLER_58_495 VGND VGND VPWR VPWR sky130_fd_sc_hd__decap_3
XFILLER_73_421 VGND VGND VPWR VPWR sky130_fd_sc_hd__decap_3
XFILLER_73_443 VGND VGND VPWR VPWR sky130_fd_sc_hd__fill_1
XFILLER_85_281 VGND VGND VPWR VPWR sky130_fd_sc_hd__fill_2
XFILLER_61_627 VGND VGND VPWR VPWR sky130_fd_sc_hd__decap_3
XFILLER_121_60 VGND VGND VPWR VPWR sky130_fd_sc_hd__decap_3
XFILLER_61_649 VGND VGND VPWR VPWR sky130_fd_sc_hd__decap_3
XFILLER_81_20 VGND VGND VPWR VPWR sky130_fd_sc_hd__decap_3
XTAP_TAPCELL_ROW_107_1794 VGND VPWR sky130_fd_sc_hd__tapvpwrvgnd_1
XTAP_TAPCELL_ROW_16_516 VGND VPWR sky130_fd_sc_hd__tapvpwrvgnd_1
XFILLER_14_587 VGND VGND VPWR VPWR sky130_fd_sc_hd__fill_1
XTAP_TAPCELL_ROW_120_1972 VGND VPWR sky130_fd_sc_hd__tapvpwrvgnd_1
XFILLER_14_80 VGND VGND VPWR VPWR sky130_fd_sc_hd__decap_3
XFILLER_10_760 VGND VGND VPWR VPWR sky130_fd_sc_hd__decap_3
XFILLER_14_91 VGND VGND VPWR VPWR sky130_fd_sc_hd__decap_3
XFILLER_10_793 VGND VGND VPWR VPWR sky130_fd_sc_hd__decap_3
XFILLER_127_445 VGND VGND VPWR VPWR sky130_fd_sc_hd__decap_3
XFILLER_127_467 VGND VGND VPWR VPWR sky130_fd_sc_hd__decap_3
XFILLER_6_731 VGND VGND VPWR VPWR sky130_fd_sc_hd__decap_3
XTAP_TAPCELL_ROW_58_1104 VGND VPWR sky130_fd_sc_hd__tapvpwrvgnd_1
XFILLER_115_629 VGND VGND VPWR VPWR sky130_fd_sc_hd__decap_3
XFILLER_6_775 VGND VGND VPWR VPWR sky130_fd_sc_hd__decap_3
XFILLER_114_139 VGND VGND VPWR VPWR sky130_fd_sc_hd__fill_1
XFILLER_5_296 VGND VGND VPWR VPWR sky130_fd_sc_hd__decap_3
XFILLER_122_150 VGND VGND VPWR VPWR sky130_fd_sc_hd__fill_1
XFILLER_123_673 VGND VGND VPWR VPWR sky130_fd_sc_hd__decap_3
XFILLER_69_727 VGND VGND VPWR VPWR sky130_fd_sc_hd__fill_1
XFILLER_110_312 VGND VGND VPWR VPWR sky130_fd_sc_hd__fill_2
XFILLER_110_323 VGND VGND VPWR VPWR sky130_fd_sc_hd__fill_1
XFILLER_122_172 VGND VGND VPWR VPWR sky130_fd_sc_hd__decap_3
XFILLER_110_345 VGND VGND VPWR VPWR sky130_fd_sc_hd__decap_3
XFILLER_77_760 VGND VGND VPWR VPWR sky130_fd_sc_hd__decap_3
XFILLER_96_579 VGND VGND VPWR VPWR sky130_fd_sc_hd__decap_3
X_4050_ _4046_/X _4049_/X _4112_/S VGND VGND VPWR VPWR _4051_/A sky130_fd_sc_hd__mux2_2
XFILLER_37_602 VGND VGND VPWR VPWR sky130_fd_sc_hd__decap_3
XFILLER_37_624 VGND VGND VPWR VPWR sky130_fd_sc_hd__decap_3
XFILLER_77_782 VGND VGND VPWR VPWR sky130_fd_sc_hd__fill_2
XFILLER_83_207 VGND VGND VPWR VPWR sky130_fd_sc_hd__decap_3
Xinput6 wdata[12] VGND VGND VPWR VPWR input6/X sky130_fd_sc_hd__clkdlybuf4s25_1
XFILLER_37_635 VGND VGND VPWR VPWR sky130_fd_sc_hd__decap_3
XFILLER_76_292 VGND VGND VPWR VPWR sky130_fd_sc_hd__decap_3
XFILLER_92_752 VGND VGND VPWR VPWR sky130_fd_sc_hd__decap_3
XTAP_TAPCELL_ROW_69_1255 VGND VPWR sky130_fd_sc_hd__tapvpwrvgnd_1
XFILLER_37_679 VGND VGND VPWR VPWR sky130_fd_sc_hd__decap_3
XFILLER_64_465 VGND VGND VPWR VPWR sky130_fd_sc_hd__fill_1
XFILLER_91_262 VGND VGND VPWR VPWR sky130_fd_sc_hd__decap_3
XFILLER_45_690 VGND VGND VPWR VPWR sky130_fd_sc_hd__decap_3
XFILLER_91_284 VGND VGND VPWR VPWR sky130_fd_sc_hd__decap_3
X_7740_ _8803_/CLK _7740_/D wire547/A VGND VGND VPWR VPWR _7740_/Q sky130_fd_sc_hd__dfrtp_2
X_4952_ _4952_/A _4984_/B VGND VGND VPWR VPWR _4953_/A sky130_fd_sc_hd__and2_2
XTAP_TAPCELL_ROW_82_1444 VGND VPWR sky130_fd_sc_hd__tapvpwrvgnd_1
X_3903_ _8065_/Q _8146_/Q _4494_/S VGND VGND VPWR VPWR _3903_/X sky130_fd_sc_hd__mux2_2
X_7671_ _8410_/CLK _7671_/D load_slew526/X VGND VGND VPWR VPWR _7671_/Q sky130_fd_sc_hd__dfrtp_2
X_4883_ _4883_/A VGND VGND VPWR VPWR _4883_/X sky130_fd_sc_hd__buf_1
X_3834_ _8059_/Q _8140_/Q _8221_/Q _8302_/Q _3778_/S _3835_/S1 VGND VGND VPWR VPWR
+ _3834_/X sky130_fd_sc_hd__mux4_2
X_6622_ _6622_/A VGND VGND VPWR VPWR _8360_/D sky130_fd_sc_hd__buf_2
XFILLER_20_557 VGND VGND VPWR VPWR sky130_fd_sc_hd__decap_3
XTAP_TAPCELL_ROW_43_891 VGND VPWR sky130_fd_sc_hd__tapvpwrvgnd_1
X_3765_ _3835_/S1 _3761_/X _3764_/X VGND VGND VPWR VPWR _3765_/X sky130_fd_sc_hd__o21a_2
X_6553_ _6553_/A VGND VGND VPWR VPWR _8327_/D sky130_fd_sc_hd__buf_2
XFILLER_9_591 VGND VGND VPWR VPWR sky130_fd_sc_hd__decap_3
X_6484_ _4941_/X _8296_/Q _6484_/S VGND VGND VPWR VPWR _6485_/A sky130_fd_sc_hd__mux2_2
X_5504_ _5504_/A VGND VGND VPWR VPWR _7799_/D sky130_fd_sc_hd__buf_1
XFILLER_10_27 VGND VGND VPWR VPWR sky130_fd_sc_hd__fill_1
XFILLER_133_426 VGND VGND VPWR VPWR sky130_fd_sc_hd__decap_3
X_8223_ _8547_/CLK _8223_/D fanout650/X VGND VGND VPWR VPWR _8223_/Q sky130_fd_sc_hd__dfrtp_2
X_5435_ _5435_/A VGND VGND VPWR VPWR _7766_/D sky130_fd_sc_hd__buf_1
XFILLER_10_38 VGND VGND VPWR VPWR sky130_fd_sc_hd__decap_3
XFILLER_114_640 VGND VGND VPWR VPWR sky130_fd_sc_hd__fill_1
XFILLER_126_27 VGND VGND VPWR VPWR sky130_fd_sc_hd__fill_1
XFILLER_126_38 VGND VGND VPWR VPWR sky130_fd_sc_hd__decap_3
XFILLER_87_502 VGND VGND VPWR VPWR sky130_fd_sc_hd__fill_2
XFILLER_99_340 VGND VGND VPWR VPWR sky130_fd_sc_hd__decap_3
XTAP_TAPCELL_ROW_93_1595 VGND VPWR sky130_fd_sc_hd__tapvpwrvgnd_1
X_8154_ _8335_/CLK _8154_/D load_slew541/X VGND VGND VPWR VPWR _8154_/Q sky130_fd_sc_hd__dfrtp_2
X_5366_ _5366_/A VGND VGND VPWR VPWR _7733_/D sky130_fd_sc_hd__buf_1
XFILLER_113_172 VGND VGND VPWR VPWR sky130_fd_sc_hd__decap_3
X_8085_ _8733_/CLK _8085_/D fanout485/X VGND VGND VPWR VPWR _8085_/Q sky130_fd_sc_hd__dfrtp_2
X_7105_ _4803_/X hold931/X _7109_/S VGND VGND VPWR VPWR _7106_/A sky130_fd_sc_hd__mux2_1
X_5297_ _5297_/A VGND VGND VPWR VPWR _7701_/D sky130_fd_sc_hd__buf_1
X_4317_ _8750_/Q _7525_/Q _4320_/S VGND VGND VPWR VPWR _4317_/X sky130_fd_sc_hd__mux2_2
XFILLER_19_36 VGND VGND VPWR VPWR sky130_fd_sc_hd__decap_3
XFILLER_59_248 VGND VGND VPWR VPWR sky130_fd_sc_hd__decap_3
Xclkbuf_4_10_0_CLK clkbuf_0_CLK/X VGND VGND VPWR VPWR clkbuf_4_10_0_CLK/X sky130_fd_sc_hd__clkbuf_8
X_7036_ _5007_/X hold927/X _7046_/S VGND VGND VPWR VPWR _7037_/A sky130_fd_sc_hd__mux2_1
X_4248_ _8582_/Q _4436_/B1 _4247_/X _4330_/A _4252_/A VGND VGND VPWR VPWR _4248_/X
+ sky130_fd_sc_hd__o221a_2
XFILLER_19_69 VGND VGND VPWR VPWR sky130_fd_sc_hd__decap_3
XFILLER_74_229 VGND VGND VPWR VPWR sky130_fd_sc_hd__decap_3
XFILLER_67_281 VGND VGND VPWR VPWR sky130_fd_sc_hd__decap_3
X_4179_ _8089_/Q _8170_/Q _8251_/Q _8332_/Q _4183_/S _4096_/A VGND VGND VPWR VPWR
+ _4179_/X sky130_fd_sc_hd__mux4_2
XFILLER_27_145 VGND VGND VPWR VPWR sky130_fd_sc_hd__decap_3
XFILLER_28_668 VGND VGND VPWR VPWR sky130_fd_sc_hd__decap_3
XFILLER_82_240 VGND VGND VPWR VPWR sky130_fd_sc_hd__fill_2
XFILLER_82_262 VGND VGND VPWR VPWR sky130_fd_sc_hd__fill_2
XFILLER_35_57 VGND VGND VPWR VPWR sky130_fd_sc_hd__decap_3
XFILLER_70_413 VGND VGND VPWR VPWR sky130_fd_sc_hd__decap_3
XFILLER_70_424 VGND VGND VPWR VPWR sky130_fd_sc_hd__decap_3
X_7938_ _8019_/CLK _7938_/D load_slew714/X VGND VGND VPWR VPWR _7938_/Q sky130_fd_sc_hd__dfrtp_2
XFILLER_70_457 VGND VGND VPWR VPWR sky130_fd_sc_hd__fill_1
X_7869_ _8608_/CLK _7869_/D wire552/X VGND VGND VPWR VPWR _7869_/Q sky130_fd_sc_hd__dfrtp_2
XFILLER_128_209 VGND VGND VPWR VPWR sky130_fd_sc_hd__decap_3
XPHY_EDGE_ROW_14_Right_14 VGND VGND VPWR VPWR sky130_fd_sc_hd__decap_3
XFILLER_129_3 VGND VGND VPWR VPWR sky130_fd_sc_hd__decap_3
XFILLER_7_517 VGND VGND VPWR VPWR sky130_fd_sc_hd__decap_3
XTAP_TAPCELL_ROW_21_585 VGND VPWR sky130_fd_sc_hd__tapvpwrvgnd_1
XFILLER_3_712 VGND VGND VPWR VPWR sky130_fd_sc_hd__decap_3
XTAP_TAPCELL_ROW_135_2190 VGND VPWR sky130_fd_sc_hd__tapvpwrvgnd_1
XFILLER_124_448 VGND VGND VPWR VPWR sky130_fd_sc_hd__decap_3
XFILLER_105_662 VGND VGND VPWR VPWR sky130_fd_sc_hd__decap_3
XFILLER_105_673 VGND VGND VPWR VPWR sky130_fd_sc_hd__decap_3
XFILLER_3_756 VGND VGND VPWR VPWR sky130_fd_sc_hd__decap_3
XFILLER_78_502 VGND VGND VPWR VPWR sky130_fd_sc_hd__decap_3
XFILLER_120_621 VGND VGND VPWR VPWR sky130_fd_sc_hd__fill_2
XFILLER_120_632 VGND VGND VPWR VPWR sky130_fd_sc_hd__decap_3
XFILLER_132_492 VGND VGND VPWR VPWR sky130_fd_sc_hd__decap_3
XPHY_EDGE_ROW_23_Right_23 VGND VGND VPWR VPWR sky130_fd_sc_hd__decap_3
XTAP_TAPCELL_ROW_53_1034 VGND VPWR sky130_fd_sc_hd__tapvpwrvgnd_1
XFILLER_66_719 VGND VGND VPWR VPWR sky130_fd_sc_hd__decap_3
XFILLER_93_505 VGND VGND VPWR VPWR sky130_fd_sc_hd__decap_3
XFILLER_120_687 VGND VGND VPWR VPWR sky130_fd_sc_hd__decap_3
XFILLER_19_613 VGND VGND VPWR VPWR sky130_fd_sc_hd__decap_3
XFILLER_76_64 VGND VGND VPWR VPWR sky130_fd_sc_hd__fill_2
XTAP_TAPCELL_ROW_109_1812 VGND VPWR sky130_fd_sc_hd__tapvpwrvgnd_1
Xfanout581 fanout585/X VGND VGND VPWR VPWR fanout581/X sky130_fd_sc_hd__clkdlybuf4s25_1
Xfanout592 fanout594/X VGND VGND VPWR VPWR fanout592/X sky130_fd_sc_hd__clkdlybuf4s25_1
XFILLER_18_101 VGND VGND VPWR VPWR sky130_fd_sc_hd__decap_3
XFILLER_46_421 VGND VGND VPWR VPWR sky130_fd_sc_hd__decap_3
XFILLER_74_741 VGND VGND VPWR VPWR sky130_fd_sc_hd__decap_3
XFILLER_93_549 VGND VGND VPWR VPWR sky130_fd_sc_hd__fill_2
XTAP_TAPCELL_ROW_109_1823 VGND VPWR sky130_fd_sc_hd__tapvpwrvgnd_1
XFILLER_34_616 VGND VGND VPWR VPWR sky130_fd_sc_hd__decap_3
XFILLER_74_763 VGND VGND VPWR VPWR sky130_fd_sc_hd__decap_3
XFILLER_46_498 VGND VGND VPWR VPWR sky130_fd_sc_hd__fill_1
XTAP_TAPCELL_ROW_29_696 VGND VPWR sky130_fd_sc_hd__tapvpwrvgnd_1
XFILLER_33_137 VGND VGND VPWR VPWR sky130_fd_sc_hd__fill_2
XFILLER_61_468 VGND VGND VPWR VPWR sky130_fd_sc_hd__decap_3
XPHY_EDGE_ROW_32_Right_32 VGND VGND VPWR VPWR sky130_fd_sc_hd__decap_3
XFILLER_14_351 VGND VGND VPWR VPWR sky130_fd_sc_hd__fill_1
XFILLER_42_660 VGND VGND VPWR VPWR sky130_fd_sc_hd__fill_1
XFILLER_42_682 VGND VGND VPWR VPWR sky130_fd_sc_hd__decap_3
XTAP_TAPCELL_ROW_64_1185 VGND VPWR sky130_fd_sc_hd__tapvpwrvgnd_1
XFILLER_128_710 VGND VGND VPWR VPWR sky130_fd_sc_hd__decap_3
XTAP_TAPCELL_ROW_40_850 VGND VPWR sky130_fd_sc_hd__tapvpwrvgnd_1
XFILLER_127_231 VGND VGND VPWR VPWR sky130_fd_sc_hd__decap_3
XFILLER_128_743 VGND VGND VPWR VPWR sky130_fd_sc_hd__decap_3
XFILLER_128_787 VGND VGND VPWR VPWR sky130_fd_sc_hd__decap_3
XPHY_EDGE_ROW_133_Left_269 VGND VGND VPWR VPWR sky130_fd_sc_hd__decap_3
X_5220_ _7665_/Q _4715_/X _5226_/S VGND VGND VPWR VPWR _5221_/A sky130_fd_sc_hd__mux2_2
XFILLER_102_109 VGND VGND VPWR VPWR sky130_fd_sc_hd__decap_3
XFILLER_130_418 VGND VGND VPWR VPWR sky130_fd_sc_hd__fill_2
XFILLER_44_3 VGND VGND VPWR VPWR sky130_fd_sc_hd__decap_3
XPHY_EDGE_ROW_41_Right_41 VGND VGND VPWR VPWR sky130_fd_sc_hd__decap_3
XFILLER_123_470 VGND VGND VPWR VPWR sky130_fd_sc_hd__decap_3
XFILLER_69_513 VGND VGND VPWR VPWR sky130_fd_sc_hd__decap_3
XFILLER_96_321 VGND VGND VPWR VPWR sky130_fd_sc_hd__decap_3
X_5151_ _5151_/A VGND VGND VPWR VPWR _7633_/D sky130_fd_sc_hd__buf_1
XFILLER_111_632 VGND VGND VPWR VPWR sky130_fd_sc_hd__decap_3
XFILLER_111_654 VGND VGND VPWR VPWR sky130_fd_sc_hd__decap_3
X_5082_ _5082_/A VGND VGND VPWR VPWR _7600_/D sky130_fd_sc_hd__buf_1
X_4102_ _8325_/Q _3750_/X _3752_/X _8244_/Q _3890_/X VGND VGND VPWR VPWR _4102_/X
+ sky130_fd_sc_hd__o221a_2
XFILLER_110_164 VGND VGND VPWR VPWR sky130_fd_sc_hd__decap_3
XFILLER_111_676 VGND VGND VPWR VPWR sky130_fd_sc_hd__fill_2
XFILLER_2_50 VGND VGND VPWR VPWR sky130_fd_sc_hd__decap_3
XFILLER_56_229 VGND VGND VPWR VPWR sky130_fd_sc_hd__fill_1
XFILLER_84_527 VGND VGND VPWR VPWR sky130_fd_sc_hd__fill_2
XFILLER_96_365 VGND VGND VPWR VPWR sky130_fd_sc_hd__decap_3
XFILLER_96_398 VGND VGND VPWR VPWR sky130_fd_sc_hd__fill_1
X_4033_ _7742_/Q _7823_/Q _4035_/S VGND VGND VPWR VPWR _4033_/X sky130_fd_sc_hd__mux2_2
XFILLER_2_83 VGND VGND VPWR VPWR sky130_fd_sc_hd__fill_1
XFILLER_2_94 VGND VGND VPWR VPWR sky130_fd_sc_hd__decap_3
XFILLER_77_590 VGND VGND VPWR VPWR sky130_fd_sc_hd__decap_3
XFILLER_25_605 VGND VGND VPWR VPWR sky130_fd_sc_hd__decap_3
XFILLER_37_465 VGND VGND VPWR VPWR sky130_fd_sc_hd__decap_3
XFILLER_64_251 VGND VGND VPWR VPWR sky130_fd_sc_hd__fill_1
XFILLER_65_785 VGND VGND VPWR VPWR sky130_fd_sc_hd__decap_3
XTAP_TAPCELL_ROW_48_961 VGND VPWR sky130_fd_sc_hd__tapvpwrvgnd_1
XFILLER_18_690 VGND VGND VPWR VPWR sky130_fd_sc_hd__decap_3
XFILLER_24_126 VGND VGND VPWR VPWR sky130_fd_sc_hd__decap_3
XFILLER_25_649 VGND VGND VPWR VPWR sky130_fd_sc_hd__decap_3
XPHY_EDGE_ROW_50_Right_50 VGND VGND VPWR VPWR sky130_fd_sc_hd__decap_3
X_8772_ _8772_/CLK _8772_/D load_slew720/X VGND VGND VPWR VPWR _8772_/Q sky130_fd_sc_hd__dfrtp_2
X_7723_ _8786_/CLK _7723_/D load_slew667/X VGND VGND VPWR VPWR _7723_/Q sky130_fd_sc_hd__dfrtp_2
X_5984_ _8060_/Q _4972_/A _5990_/S VGND VGND VPWR VPWR _5985_/A sky130_fd_sc_hd__mux2_2
XFILLER_33_671 VGND VGND VPWR VPWR sky130_fd_sc_hd__fill_1
X_4935_ _4935_/A VGND VGND VPWR VPWR _7555_/D sky130_fd_sc_hd__buf_1
XFILLER_32_170 VGND VGND VPWR VPWR sky130_fd_sc_hd__decap_3
XFILLER_33_693 VGND VGND VPWR VPWR sky130_fd_sc_hd__decap_3
X_7654_ _8799_/CLK _7654_/D fanout601/X VGND VGND VPWR VPWR _7654_/Q sky130_fd_sc_hd__dfrtp_2
X_4866_ _4866_/A VGND VGND VPWR VPWR _4866_/X sky130_fd_sc_hd__buf_1
XFILLER_119_710 VGND VGND VPWR VPWR sky130_fd_sc_hd__decap_3
XFILLER_119_732 VGND VGND VPWR VPWR sky130_fd_sc_hd__decap_3
XFILLER_20_365 VGND VGND VPWR VPWR sky130_fd_sc_hd__fill_2
X_3817_ _3817_/A VGND VGND VPWR VPWR _3817_/X sky130_fd_sc_hd__clkbuf_2
X_7585_ _8328_/CLK _7585_/D wire476/X VGND VGND VPWR VPWR _7585_/Q sky130_fd_sc_hd__dfrtp_2
X_6605_ _6605_/A VGND VGND VPWR VPWR _8352_/D sky130_fd_sc_hd__buf_2
X_4797_ _4797_/A VGND VGND VPWR VPWR _7522_/D sky130_fd_sc_hd__buf_1
XFILLER_21_15 VGND VGND VPWR VPWR sky130_fd_sc_hd__decap_3
X_3748_ _3825_/A _3748_/B VGND VGND VPWR VPWR _3748_/X sky130_fd_sc_hd__or2_2
X_6536_ _6536_/A VGND VGND VPWR VPWR _8319_/D sky130_fd_sc_hd__buf_2
XFILLER_115_9 VGND VGND VPWR VPWR sky130_fd_sc_hd__decap_3
XFILLER_118_253 VGND VGND VPWR VPWR sky130_fd_sc_hd__decap_3
XFILLER_134_713 VGND VGND VPWR VPWR sky130_fd_sc_hd__decap_3
XFILLER_21_48 VGND VGND VPWR VPWR sky130_fd_sc_hd__decap_3
XTAP_TAPCELL_ROW_95_1624 VGND VPWR sky130_fd_sc_hd__tapvpwrvgnd_1
XFILLER_133_223 VGND VGND VPWR VPWR sky130_fd_sc_hd__fill_1
XFILLER_133_234 VGND VGND VPWR VPWR sky130_fd_sc_hd__decap_3
XFILLER_134_746 VGND VGND VPWR VPWR sky130_fd_sc_hd__decap_3
XFILLER_134_757 VGND VGND VPWR VPWR sky130_fd_sc_hd__decap_3
X_6467_ _6467_/A VGND VGND VPWR VPWR _8287_/D sky130_fd_sc_hd__buf_2
XFILLER_0_704 VGND VGND VPWR VPWR sky130_fd_sc_hd__decap_3
XFILLER_133_267 VGND VGND VPWR VPWR sky130_fd_sc_hd__decap_3
Xoutput140 _4445_/X VGND VGND VPWR VPWR rdata[58] sky130_fd_sc_hd__clkdlybuf4s25_1
Xoutput151 _4546_/X VGND VGND VPWR VPWR rdata[68] sky130_fd_sc_hd__clkdlybuf4s25_1
X_8206_ _8698_/CLK _8206_/D fanout744/X VGND VGND VPWR VPWR _8206_/Q sky130_fd_sc_hd__dfrtp_2
X_6398_ _4769_/X hold950/X _6398_/S VGND VGND VPWR VPWR _6399_/A sky130_fd_sc_hd__mux2_1
X_5418_ _5418_/A VGND VGND VPWR VPWR _7758_/D sky130_fd_sc_hd__buf_1
XFILLER_121_429 VGND VGND VPWR VPWR sky130_fd_sc_hd__decap_3
XFILLER_99_181 VGND VGND VPWR VPWR sky130_fd_sc_hd__decap_3
Xoutput162 _4666_/X VGND VGND VPWR VPWR rdata[78] sky130_fd_sc_hd__clkdlybuf4s25_1
X_8137_ _8621_/CLK _8137_/D fanout681/X VGND VGND VPWR VPWR _8137_/Q sky130_fd_sc_hd__dfrtp_2
X_5349_ _5349_/A VGND VGND VPWR VPWR _7725_/D sky130_fd_sc_hd__buf_1
XFILLER_102_632 VGND VGND VPWR VPWR sky130_fd_sc_hd__decap_3
XFILLER_102_665 VGND VGND VPWR VPWR sky130_fd_sc_hd__decap_3
XFILLER_75_505 VGND VGND VPWR VPWR sky130_fd_sc_hd__decap_3
X_8068_ _8680_/CLK _8068_/D wire693/X VGND VGND VPWR VPWR _8068_/Q sky130_fd_sc_hd__dfrtp_2
XFILLER_28_421 VGND VGND VPWR VPWR sky130_fd_sc_hd__decap_3
X_7019_ _4973_/X _8546_/Q _7025_/S VGND VGND VPWR VPWR _7020_/A sky130_fd_sc_hd__mux2_2
XFILLER_16_616 VGND VGND VPWR VPWR sky130_fd_sc_hd__decap_3
XFILLER_46_56 VGND VGND VPWR VPWR sky130_fd_sc_hd__decap_3
XFILLER_56_752 VGND VGND VPWR VPWR sky130_fd_sc_hd__decap_3
XFILLER_56_774 VGND VGND VPWR VPWR sky130_fd_sc_hd__decap_3
XFILLER_55_273 VGND VGND VPWR VPWR sky130_fd_sc_hd__decap_3
XFILLER_55_284 VGND VGND VPWR VPWR sky130_fd_sc_hd__decap_3
XFILLER_71_711 VGND VGND VPWR VPWR sky130_fd_sc_hd__fill_1
XFILLER_71_744 VGND VGND VPWR VPWR sky130_fd_sc_hd__decap_3
XTAP_TAPCELL_ROW_104_1742 VGND VPWR sky130_fd_sc_hd__tapvpwrvgnd_1
XTAP_TAPCELL_ROW_26_655 VGND VPWR sky130_fd_sc_hd__tapvpwrvgnd_1
XFILLER_24_671 VGND VGND VPWR VPWR sky130_fd_sc_hd__decap_3
XFILLER_70_287 VGND VGND VPWR VPWR sky130_fd_sc_hd__fill_1
XTAP_TAPCELL_ROW_104_1753 VGND VPWR sky130_fd_sc_hd__tapvpwrvgnd_1
XFILLER_11_343 VGND VGND VPWR VPWR sky130_fd_sc_hd__fill_2
XFILLER_11_354 VGND VGND VPWR VPWR sky130_fd_sc_hd__decap_3
XFILLER_129_529 VGND VGND VPWR VPWR sky130_fd_sc_hd__decap_3
XFILLER_7_39 VGND VGND VPWR VPWR sky130_fd_sc_hd__decap_3
Xwire234 _7215_/X VGND VGND VPWR VPWR wire234/X sky130_fd_sc_hd__clkbuf_4
XFILLER_7_369 VGND VGND VPWR VPWR sky130_fd_sc_hd__fill_2
XTAP_TAPCELL_ROW_133_2149 VGND VPWR sky130_fd_sc_hd__tapvpwrvgnd_1
XFILLER_112_407 VGND VGND VPWR VPWR sky130_fd_sc_hd__decap_3
XFILLER_11_81 VGND VGND VPWR VPWR sky130_fd_sc_hd__decap_3
XFILLER_97_107 VGND VGND VPWR VPWR sky130_fd_sc_hd__decap_3
XFILLER_127_81 VGND VGND VPWR VPWR sky130_fd_sc_hd__decap_3
XFILLER_30_9 VGND VGND VPWR VPWR sky130_fd_sc_hd__decap_3
XFILLER_3_575 VGND VGND VPWR VPWR sky130_fd_sc_hd__decap_3
XFILLER_3_586 VGND VGND VPWR VPWR sky130_fd_sc_hd__decap_3
XFILLER_105_492 VGND VGND VPWR VPWR sky130_fd_sc_hd__decap_3
XFILLER_78_332 VGND VGND VPWR VPWR sky130_fd_sc_hd__decap_3
XFILLER_87_63 VGND VGND VPWR VPWR sky130_fd_sc_hd__decap_3
XFILLER_66_516 VGND VGND VPWR VPWR sky130_fd_sc_hd__decap_3
XFILLER_78_365 VGND VGND VPWR VPWR sky130_fd_sc_hd__decap_3
XFILLER_78_376 VGND VGND VPWR VPWR sky130_fd_sc_hd__fill_1
XTAP_TAPCELL_ROW_6_380 VGND VPWR sky130_fd_sc_hd__tapvpwrvgnd_1
XFILLER_120_495 VGND VGND VPWR VPWR sky130_fd_sc_hd__decap_3
XFILLER_93_324 VGND VGND VPWR VPWR sky130_fd_sc_hd__decap_3
XFILLER_93_346 VGND VGND VPWR VPWR sky130_fd_sc_hd__decap_3
XFILLER_47_774 VGND VGND VPWR VPWR sky130_fd_sc_hd__fill_1
XFILLER_81_508 VGND VGND VPWR VPWR sky130_fd_sc_hd__decap_3
XFILLER_34_424 VGND VGND VPWR VPWR sky130_fd_sc_hd__decap_3
XFILLER_46_262 VGND VGND VPWR VPWR sky130_fd_sc_hd__decap_3
XFILLER_47_785 VGND VGND VPWR VPWR sky130_fd_sc_hd__decap_3
XFILLER_74_571 VGND VGND VPWR VPWR sky130_fd_sc_hd__fill_2
XTAP_TAPCELL_ROW_45_920 VGND VPWR sky130_fd_sc_hd__tapvpwrvgnd_1
XTAP_TAPCELL_ROW_66_1214 VGND VPWR sky130_fd_sc_hd__tapvpwrvgnd_1
XFILLER_34_446 VGND VGND VPWR VPWR sky130_fd_sc_hd__decap_3
XFILLER_62_744 VGND VGND VPWR VPWR sky130_fd_sc_hd__decap_3
XFILLER_15_682 VGND VGND VPWR VPWR sky130_fd_sc_hd__decap_3
X_4720_ _7063_/A0 _4720_/A1 _4736_/S VGND VGND VPWR VPWR _4721_/A sky130_fd_sc_hd__mux2_2
X_4651_ _4651_/A _4651_/B VGND VGND VPWR VPWR _4651_/X sky130_fd_sc_hd__or2_2
Xinput20 wdata[25] VGND VGND VPWR VPWR _4710_/A sky130_fd_sc_hd__clkdlybuf4s25_1
Xinput31 wdata[35] VGND VGND VPWR VPWR _4752_/A sky130_fd_sc_hd__clkdlybuf4s25_1
XFILLER_128_551 VGND VGND VPWR VPWR sky130_fd_sc_hd__decap_3
Xinput42 wdata[45] VGND VGND VPWR VPWR _4794_/A sky130_fd_sc_hd__clkdlybuf4s25_1
Xinput53 wdata[55] VGND VGND VPWR VPWR _4836_/A sky130_fd_sc_hd__clkdlybuf4s25_1
Xinput64 wdata[65] VGND VGND VPWR VPWR _4878_/A sky130_fd_sc_hd__clkdlybuf4s25_1
X_7370_ _8743_/Q _4776_/A _7386_/S VGND VGND VPWR VPWR _7371_/A sky130_fd_sc_hd__mux2_2
X_4582_ _8449_/Q _8530_/Q _8611_/Q _8692_/Q _4579_/S _4621_/A VGND VGND VPWR VPWR
+ _4582_/X sky130_fd_sc_hd__mux4_2
XFILLER_115_223 VGND VGND VPWR VPWR sky130_fd_sc_hd__fill_1
XFILLER_128_584 VGND VGND VPWR VPWR sky130_fd_sc_hd__decap_3
XFILLER_128_595 VGND VGND VPWR VPWR sky130_fd_sc_hd__decap_3
XTAP_TAPCELL_ROW_77_1365 VGND VPWR sky130_fd_sc_hd__tapvpwrvgnd_1
Xhold804 _8005_/Q VGND VGND VPWR VPWR hold804/X sky130_fd_sc_hd__dlygate4sd3_1
Xhold815 _7973_/Q VGND VGND VPWR VPWR hold815/X sky130_fd_sc_hd__dlygate4sd3_1
Xhold826 _8020_/Q VGND VGND VPWR VPWR hold826/X sky130_fd_sc_hd__dlygate4sd3_1
Xhold837 _7995_/Q VGND VGND VPWR VPWR hold837/X sky130_fd_sc_hd__dlygate4sd3_1
Xinput75 wdata[75] VGND VGND VPWR VPWR _4920_/A sky130_fd_sc_hd__clkdlybuf4s25_1
X_6321_ _4957_/X _8218_/Q _6335_/S VGND VGND VPWR VPWR _6322_/A sky130_fd_sc_hd__mux2_2
XFILLER_115_245 VGND VGND VPWR VPWR sky130_fd_sc_hd__decap_3
XTAP_TAPCELL_ROW_77_1376 VGND VPWR sky130_fd_sc_hd__tapvpwrvgnd_1
Xhold848 _8032_/Q VGND VGND VPWR VPWR hold848/X sky130_fd_sc_hd__dlygate4sd3_1
Xhold859 _8691_/Q VGND VGND VPWR VPWR hold859/X sky130_fd_sc_hd__dlygate4sd3_1
X_6252_ _4819_/X _8186_/Q _6268_/S VGND VGND VPWR VPWR _6253_/A sky130_fd_sc_hd__mux2_4
XFILLER_130_215 VGND VGND VPWR VPWR sky130_fd_sc_hd__decap_3
XFILLER_131_727 VGND VGND VPWR VPWR sky130_fd_sc_hd__fill_1
XFILLER_131_738 VGND VGND VPWR VPWR sky130_fd_sc_hd__decap_3
XFILLER_88_118 VGND VGND VPWR VPWR sky130_fd_sc_hd__fill_1
X_6183_ _6183_/A VGND VGND VPWR VPWR _8153_/D sky130_fd_sc_hd__buf_6
X_5203_ _5203_/A0 _5023_/X _5205_/S VGND VGND VPWR VPWR _5204_/A sky130_fd_sc_hd__mux2_2
XFILLER_130_248 VGND VGND VPWR VPWR sky130_fd_sc_hd__decap_3
XFILLER_130_259 VGND VGND VPWR VPWR sky130_fd_sc_hd__decap_3
XFILLER_69_332 VGND VGND VPWR VPWR sky130_fd_sc_hd__fill_1
XTAP_TAPCELL_ROW_90_1554 VGND VPWR sky130_fd_sc_hd__tapvpwrvgnd_1
Xload_slew740 fanout739/X VGND VGND VPWR VPWR load_slew740/X sky130_fd_sc_hd__buf_4
X_5134_ _5134_/A VGND VGND VPWR VPWR _7625_/D sky130_fd_sc_hd__buf_1
XFILLER_111_473 VGND VGND VPWR VPWR sky130_fd_sc_hd__fill_2
XFILLER_123_17 VGND VGND VPWR VPWR sky130_fd_sc_hd__decap_3
XFILLER_57_516 VGND VGND VPWR VPWR sky130_fd_sc_hd__decap_3
XFILLER_69_387 VGND VGND VPWR VPWR sky130_fd_sc_hd__decap_3
XFILLER_111_484 VGND VGND VPWR VPWR sky130_fd_sc_hd__fill_2
XFILLER_57_538 VGND VGND VPWR VPWR sky130_fd_sc_hd__fill_1
X_5065_ _5065_/A VGND VGND VPWR VPWR _7592_/D sky130_fd_sc_hd__buf_1
XFILLER_38_763 VGND VGND VPWR VPWR sky130_fd_sc_hd__decap_3
XFILLER_38_774 VGND VGND VPWR VPWR sky130_fd_sc_hd__decap_3
X_4016_ _8722_/Q _8803_/Q _7578_/Q _7659_/Q _3719_/C _4017_/S1 VGND VGND VPWR VPWR
+ _4016_/X sky130_fd_sc_hd__mux4_2
XFILLER_16_15 VGND VGND VPWR VPWR sky130_fd_sc_hd__decap_3
XFILLER_25_413 VGND VGND VPWR VPWR sky130_fd_sc_hd__fill_1
XFILLER_37_284 VGND VGND VPWR VPWR sky130_fd_sc_hd__decap_3
XFILLER_53_722 VGND VGND VPWR VPWR sky130_fd_sc_hd__decap_3
XFILLER_65_582 VGND VGND VPWR VPWR sky130_fd_sc_hd__decap_3
XFILLER_16_59 VGND VGND VPWR VPWR sky130_fd_sc_hd__decap_3
XFILLER_25_435 VGND VGND VPWR VPWR sky130_fd_sc_hd__decap_3
XFILLER_52_276 VGND VGND VPWR VPWR sky130_fd_sc_hd__decap_3
XTAP_TAPCELL_ROW_23_614 VGND VPWR sky130_fd_sc_hd__tapvpwrvgnd_1
X_8755_ _8757_/CLK _8755_/D fanout715/X VGND VGND VPWR VPWR _8755_/Q sky130_fd_sc_hd__dfrtp_2
X_5967_ _8052_/Q _3716_/B _6658_/B _5966_/X VGND VGND VPWR VPWR _8052_/D sky130_fd_sc_hd__a22o_2
XFILLER_40_449 VGND VGND VPWR VPWR sky130_fd_sc_hd__decap_3
XFILLER_52_298 VGND VGND VPWR VPWR sky130_fd_sc_hd__decap_3
X_8686_ _8689_/CLK _8686_/D load_slew558/X VGND VGND VPWR VPWR _8686_/Q sky130_fd_sc_hd__dfrtp_2
X_7706_ _8684_/CLK _7706_/D load_slew558/X VGND VGND VPWR VPWR _7706_/Q sky130_fd_sc_hd__dfrtp_2
X_4918_ _4917_/X _4918_/A1 _7453_/S VGND VGND VPWR VPWR _4919_/A sky130_fd_sc_hd__mux2_2
X_7637_ _8781_/CLK _7637_/D load_slew750/X VGND VGND VPWR VPWR _7637_/Q sky130_fd_sc_hd__dfrtp_2
X_5898_ _5894_/X _5895_/X _4735_/X _5896_/X hold807/X VGND VGND VPWR VPWR _7994_/D
+ sky130_fd_sc_hd__a32o_2
X_4849_ _4849_/A VGND VGND VPWR VPWR _4849_/X sky130_fd_sc_hd__buf_1
XFILLER_20_195 VGND VGND VPWR VPWR sky130_fd_sc_hd__fill_1
X_7568_ _8712_/CLK _7568_/D load_slew589/X VGND VGND VPWR VPWR _7568_/Q sky130_fd_sc_hd__dfrtp_2
XFILLER_106_201 VGND VGND VPWR VPWR sky130_fd_sc_hd__decap_3
XFILLER_107_724 VGND VGND VPWR VPWR sky130_fd_sc_hd__decap_3
XFILLER_107_746 VGND VGND VPWR VPWR sky130_fd_sc_hd__decap_3
XFILLER_113_6 VGND VGND VPWR VPWR sky130_fd_sc_hd__decap_3
XFILLER_134_510 VGND VGND VPWR VPWR sky130_fd_sc_hd__fill_1
XFILLER_4_339 VGND VGND VPWR VPWR sky130_fd_sc_hd__decap_3
X_7499_ _8724_/CLK _7499_/D load_slew503/X VGND VGND VPWR VPWR _7499_/Q sky130_fd_sc_hd__dfrtp_2
X_6519_ _6519_/A VGND VGND VPWR VPWR _8311_/D sky130_fd_sc_hd__buf_2
XFILLER_134_554 VGND VGND VPWR VPWR sky130_fd_sc_hd__decap_3
XFILLER_122_749 VGND VGND VPWR VPWR sky130_fd_sc_hd__decap_3
XFILLER_134_598 VGND VGND VPWR VPWR sky130_fd_sc_hd__decap_3
XFILLER_88_641 VGND VGND VPWR VPWR sky130_fd_sc_hd__decap_3
XFILLER_130_760 VGND VGND VPWR VPWR sky130_fd_sc_hd__decap_3
XFILLER_57_44 VGND VGND VPWR VPWR sky130_fd_sc_hd__decap_3
XFILLER_75_302 VGND VGND VPWR VPWR sky130_fd_sc_hd__decap_3
XFILLER_87_151 VGND VGND VPWR VPWR sky130_fd_sc_hd__decap_3
XFILLER_130_793 VGND VGND VPWR VPWR sky130_fd_sc_hd__decap_3
XFILLER_87_184 VGND VGND VPWR VPWR sky130_fd_sc_hd__decap_3
XFILLER_29_741 VGND VGND VPWR VPWR sky130_fd_sc_hd__fill_1
XFILLER_29_763 VGND VGND VPWR VPWR sky130_fd_sc_hd__decap_3
XFILLER_57_88 VGND VGND VPWR VPWR sky130_fd_sc_hd__decap_3
XFILLER_63_508 VGND VGND VPWR VPWR sky130_fd_sc_hd__fill_2
XFILLER_75_379 VGND VGND VPWR VPWR sky130_fd_sc_hd__decap_3
XFILLER_44_733 VGND VGND VPWR VPWR sky130_fd_sc_hd__decap_3
XFILLER_56_593 VGND VGND VPWR VPWR sky130_fd_sc_hd__decap_3
XFILLER_90_338 VGND VGND VPWR VPWR sky130_fd_sc_hd__decap_3
XFILLER_113_83 VGND VGND VPWR VPWR sky130_fd_sc_hd__decap_3
XFILLER_73_54 VGND VGND VPWR VPWR sky130_fd_sc_hd__fill_2
XFILLER_83_390 VGND VGND VPWR VPWR sky130_fd_sc_hd__fill_2
XFILLER_73_87 VGND VGND VPWR VPWR sky130_fd_sc_hd__decap_3
XFILLER_31_449 VGND VGND VPWR VPWR sky130_fd_sc_hd__fill_2
XFILLER_129_326 VGND VGND VPWR VPWR sky130_fd_sc_hd__decap_3
XFILLER_8_601 VGND VGND VPWR VPWR sky130_fd_sc_hd__decap_3
XTAP_TAPCELL_ROW_61_1144 VGND VPWR sky130_fd_sc_hd__tapvpwrvgnd_1
XFILLER_11_162 VGND VGND VPWR VPWR sky130_fd_sc_hd__decap_3
XFILLER_129_337 VGND VGND VPWR VPWR sky130_fd_sc_hd__decap_3
XFILLER_129_359 VGND VGND VPWR VPWR sky130_fd_sc_hd__decap_3
XFILLER_8_634 VGND VGND VPWR VPWR sky130_fd_sc_hd__decap_3
XFILLER_8_645 VGND VGND VPWR VPWR sky130_fd_sc_hd__decap_3
XFILLER_7_166 VGND VGND VPWR VPWR sky130_fd_sc_hd__fill_2
XFILLER_8_678 VGND VGND VPWR VPWR sky130_fd_sc_hd__decap_3
XTAP_TAPCELL_ROW_117_1933 VGND VPWR sky130_fd_sc_hd__tapvpwrvgnd_1
XFILLER_22_80 VGND VGND VPWR VPWR sky130_fd_sc_hd__decap_3
XFILLER_22_91 VGND VGND VPWR VPWR sky130_fd_sc_hd__fill_2
XFILLER_113_727 VGND VGND VPWR VPWR sky130_fd_sc_hd__fill_1
XFILLER_98_416 VGND VGND VPWR VPWR sky130_fd_sc_hd__decap_3
XFILLER_112_226 VGND VGND VPWR VPWR sky130_fd_sc_hd__decap_3
XFILLER_79_641 VGND VGND VPWR VPWR sky130_fd_sc_hd__fill_2
XTAP_TAPCELL_ROW_72_1295 VGND VPWR sky130_fd_sc_hd__tapvpwrvgnd_1
XFILLER_120_270 VGND VGND VPWR VPWR sky130_fd_sc_hd__decap_3
XFILLER_121_782 VGND VGND VPWR VPWR sky130_fd_sc_hd__fill_2
XFILLER_78_173 VGND VGND VPWR VPWR sky130_fd_sc_hd__decap_3
XFILLER_66_368 VGND VGND VPWR VPWR sky130_fd_sc_hd__decap_3
XTAP_TAPCELL_ROW_1_309 VGND VPWR sky130_fd_sc_hd__tapvpwrvgnd_1
XFILLER_93_165 VGND VGND VPWR VPWR sky130_fd_sc_hd__decap_3
XFILLER_62_552 VGND VGND VPWR VPWR sky130_fd_sc_hd__decap_3
X_6870_ _5019_/X _8476_/Q _6874_/S VGND VGND VPWR VPWR _6871_/A sky130_fd_sc_hd__mux2_4
XFILLER_34_276 VGND VGND VPWR VPWR sky130_fd_sc_hd__decap_3
X_5821_ _5821_/A VGND VGND VPWR VPWR _7948_/D sky130_fd_sc_hd__buf_1
XFILLER_15_490 VGND VGND VPWR VPWR sky130_fd_sc_hd__decap_3
X_8540_ _8789_/CLK _8540_/D wire680/X VGND VGND VPWR VPWR _8540_/Q sky130_fd_sc_hd__dfrtp_2
X_5752_ _5752_/A VGND VGND VPWR VPWR _7915_/D sky130_fd_sc_hd__buf_1
X_4703_ _4703_/A VGND VGND VPWR VPWR _4703_/X sky130_fd_sc_hd__buf_1
XTAP_TAPCELL_ROW_79_1405 VGND VPWR sky130_fd_sc_hd__tapvpwrvgnd_1
X_8471_ _8477_/CLK _8471_/D fanout607/X VGND VGND VPWR VPWR _8471_/Q sky130_fd_sc_hd__dfrtp_2
X_5683_ _5683_/A VGND VGND VPWR VPWR _7882_/D sky130_fd_sc_hd__buf_1
XFILLER_135_318 VGND VGND VPWR VPWR sky130_fd_sc_hd__fill_1
XFILLER_8_71 VGND VGND VPWR VPWR sky130_fd_sc_hd__decap_3
X_7422_ _8768_/Q _4882_/A _7428_/S VGND VGND VPWR VPWR _7423_/A sky130_fd_sc_hd__mux2_2
X_4634_ _7715_/Q _4634_/A2 _3752_/X _7634_/Q _4682_/C1 VGND VGND VPWR VPWR _4634_/X
+ sky130_fd_sc_hd__o221a_2
X_7353_ _8735_/Q _4744_/A _7365_/S VGND VGND VPWR VPWR _7354_/A sky130_fd_sc_hd__mux2_2
X_4565_ _8448_/Q _8529_/Q _4568_/S VGND VGND VPWR VPWR _4565_/X sky130_fd_sc_hd__mux2_2
X_6304_ _4925_/X _8211_/Q _6310_/S VGND VGND VPWR VPWR _6305_/A sky130_fd_sc_hd__mux2_4
XFILLER_116_576 VGND VGND VPWR VPWR sky130_fd_sc_hd__decap_3
XPHY_EDGE_ROW_4_Right_4 VGND VGND VPWR VPWR sky130_fd_sc_hd__decap_3
X_7284_ _8702_/Q input3/X _7302_/S VGND VGND VPWR VPWR _7285_/A sky130_fd_sc_hd__mux2_2
X_4496_ _4496_/A1 _4494_/X _4495_/X VGND VGND VPWR VPWR _4496_/X sky130_fd_sc_hd__o21a_2
XFILLER_103_248 VGND VGND VPWR VPWR sky130_fd_sc_hd__decap_3
XFILLER_131_535 VGND VGND VPWR VPWR sky130_fd_sc_hd__decap_3
XFILLER_89_449 VGND VGND VPWR VPWR sky130_fd_sc_hd__decap_3
X_6235_ _4787_/X _8178_/Q _6247_/S VGND VGND VPWR VPWR _6236_/A sky130_fd_sc_hd__mux2_4
XFILLER_131_579 VGND VGND VPWR VPWR sky130_fd_sc_hd__decap_3
XFILLER_134_27 VGND VGND VPWR VPWR sky130_fd_sc_hd__fill_1
XFILLER_134_38 VGND VGND VPWR VPWR sky130_fd_sc_hd__decap_3
XFILLER_69_140 VGND VGND VPWR VPWR sky130_fd_sc_hd__decap_3
X_6166_ _4989_/X _8145_/Q _6184_/S VGND VGND VPWR VPWR _6167_/A sky130_fd_sc_hd__mux2_4
XFILLER_111_281 VGND VGND VPWR VPWR sky130_fd_sc_hd__decap_3
XFILLER_85_644 VGND VGND VPWR VPWR sky130_fd_sc_hd__decap_3
Xload_slew570 fanout569/X VGND VGND VPWR VPWR load_slew570/X sky130_fd_sc_hd__buf_4
X_6097_ _6097_/A VGND VGND VPWR VPWR _6116_/S sky130_fd_sc_hd__buf_2
X_5117_ _5117_/A VGND VGND VPWR VPWR _7617_/D sky130_fd_sc_hd__buf_1
XFILLER_27_36 VGND VGND VPWR VPWR sky130_fd_sc_hd__decap_3
XFILLER_85_666 VGND VGND VPWR VPWR sky130_fd_sc_hd__decap_3
X_5048_ _5048_/A VGND VGND VPWR VPWR _7584_/D sky130_fd_sc_hd__buf_1
XFILLER_27_69 VGND VGND VPWR VPWR sky130_fd_sc_hd__decap_3
XFILLER_25_221 VGND VGND VPWR VPWR sky130_fd_sc_hd__decap_3
XFILLER_26_766 VGND VGND VPWR VPWR sky130_fd_sc_hd__decap_3
XFILLER_53_541 VGND VGND VPWR VPWR sky130_fd_sc_hd__decap_3
XFILLER_25_254 VGND VGND VPWR VPWR sky130_fd_sc_hd__decap_3
XFILLER_41_703 VGND VGND VPWR VPWR sky130_fd_sc_hd__fill_1
XFILLER_53_574 VGND VGND VPWR VPWR sky130_fd_sc_hd__decap_3
XFILLER_13_438 VGND VGND VPWR VPWR sky130_fd_sc_hd__decap_3
XFILLER_13_449 VGND VGND VPWR VPWR sky130_fd_sc_hd__decap_3
XFILLER_40_213 VGND VGND VPWR VPWR sky130_fd_sc_hd__fill_1
XFILLER_40_235 VGND VGND VPWR VPWR sky130_fd_sc_hd__decap_3
XTAP_TAPCELL_ROW_101_1701 VGND VPWR sky130_fd_sc_hd__tapvpwrvgnd_1
XTAP_TAPCELL_ROW_101_1712 VGND VPWR sky130_fd_sc_hd__tapvpwrvgnd_1
XTAP_TAPCELL_ROW_36_794 VGND VPWR sky130_fd_sc_hd__tapvpwrvgnd_1
X_8738_ _8739_/CLK _8738_/D load_slew511/X VGND VGND VPWR VPWR _8738_/Q sky130_fd_sc_hd__dfrtp_2
X_6999_ _6999_/A VGND VGND VPWR VPWR _8537_/D sky130_fd_sc_hd__buf_6
XFILLER_43_57 VGND VGND VPWR VPWR sky130_fd_sc_hd__decap_3
X_8669_ _8669_/CLK _8669_/D fanout643/X VGND VGND VPWR VPWR _8669_/Q sky130_fd_sc_hd__dfrtp_2
XFILLER_126_307 VGND VGND VPWR VPWR sky130_fd_sc_hd__fill_1
XFILLER_126_318 VGND VGND VPWR VPWR sky130_fd_sc_hd__decap_3
XFILLER_111_3 VGND VGND VPWR VPWR sky130_fd_sc_hd__decap_3
XFILLER_4_103 VGND VGND VPWR VPWR sky130_fd_sc_hd__fill_2
XFILLER_5_626 VGND VGND VPWR VPWR sky130_fd_sc_hd__decap_3
XTAP_TAPCELL_ROW_130_2108 VGND VPWR sky130_fd_sc_hd__tapvpwrvgnd_1
XFILLER_5_659 VGND VGND VPWR VPWR sky130_fd_sc_hd__decap_3
XTAP_TAPCELL_ROW_130_2119 VGND VPWR sky130_fd_sc_hd__tapvpwrvgnd_1
XFILLER_108_61 VGND VGND VPWR VPWR sky130_fd_sc_hd__decap_3
XFILLER_134_362 VGND VGND VPWR VPWR sky130_fd_sc_hd__fill_2
XFILLER_4_18 VGND VGND VPWR VPWR sky130_fd_sc_hd__decap_3
XFILLER_4_29 VGND VGND VPWR VPWR sky130_fd_sc_hd__decap_3
XFILLER_134_395 VGND VGND VPWR VPWR sky130_fd_sc_hd__decap_3
XFILLER_68_32 VGND VGND VPWR VPWR sky130_fd_sc_hd__decap_3
XTAP_TAPCELL_ROW_112_1863 VGND VPWR sky130_fd_sc_hd__tapvpwrvgnd_1
XFILLER_48_368 VGND VGND VPWR VPWR sky130_fd_sc_hd__decap_3
XFILLER_75_154 VGND VGND VPWR VPWR sky130_fd_sc_hd__decap_3
XFILLER_29_582 VGND VGND VPWR VPWR sky130_fd_sc_hd__decap_3
XFILLER_76_688 VGND VGND VPWR VPWR sky130_fd_sc_hd__decap_3
XFILLER_76_699 VGND VGND VPWR VPWR sky130_fd_sc_hd__fill_1
XFILLER_91_614 VGND VGND VPWR VPWR sky130_fd_sc_hd__fill_2
XFILLER_16_232 VGND VGND VPWR VPWR sky130_fd_sc_hd__decap_3
XFILLER_17_744 VGND VGND VPWR VPWR sky130_fd_sc_hd__decap_3
XFILLER_91_647 VGND VGND VPWR VPWR sky130_fd_sc_hd__fill_2
XFILLER_91_669 VGND VGND VPWR VPWR sky130_fd_sc_hd__decap_3
XFILLER_90_179 VGND VGND VPWR VPWR sky130_fd_sc_hd__decap_3
XFILLER_16_298 VGND VGND VPWR VPWR sky130_fd_sc_hd__fill_2
XFILLER_44_596 VGND VGND VPWR VPWR sky130_fd_sc_hd__decap_3
XFILLER_71_382 VGND VGND VPWR VPWR sky130_fd_sc_hd__decap_3
XFILLER_71_393 VGND VGND VPWR VPWR sky130_fd_sc_hd__decap_3
XFILLER_129_134 VGND VGND VPWR VPWR sky130_fd_sc_hd__decap_3
XFILLER_12_460 VGND VGND VPWR VPWR sky130_fd_sc_hd__decap_3
XTAP_TAPCELL_ROW_14_488 VGND VPWR sky130_fd_sc_hd__tapvpwrvgnd_1
XFILLER_129_167 VGND VGND VPWR VPWR sky130_fd_sc_hd__fill_1
XFILLER_12_493 VGND VGND VPWR VPWR sky130_fd_sc_hd__decap_3
XFILLER_76_6 VGND VGND VPWR VPWR sky130_fd_sc_hd__decap_3
XFILLER_129_178 VGND VGND VPWR VPWR sky130_fd_sc_hd__decap_3
X_4350_ _7690_/Q _4350_/A2 _4436_/B1 _7609_/Q _3791_/A VGND VGND VPWR VPWR _4350_/X
+ sky130_fd_sc_hd__o221a_2
XFILLER_113_513 VGND VGND VPWR VPWR sky130_fd_sc_hd__fill_2
XFILLER_125_351 VGND VGND VPWR VPWR sky130_fd_sc_hd__fill_1
XFILLER_125_373 VGND VGND VPWR VPWR sky130_fd_sc_hd__decap_3
XFILLER_98_213 VGND VGND VPWR VPWR sky130_fd_sc_hd__fill_2
XFILLER_99_725 VGND VGND VPWR VPWR sky130_fd_sc_hd__decap_3
XTAP_TAPCELL_ROW_74_1324 VGND VPWR sky130_fd_sc_hd__tapvpwrvgnd_1
XTAP_TAPCELL_ROW_74_1335 VGND VPWR sky130_fd_sc_hd__tapvpwrvgnd_1
XFILLER_4_681 VGND VGND VPWR VPWR sky130_fd_sc_hd__decap_3
X_4281_ _7765_/Q _7846_/Q _4327_/S VGND VGND VPWR VPWR _4281_/X sky130_fd_sc_hd__mux2_2
XFILLER_3_191 VGND VGND VPWR VPWR sky130_fd_sc_hd__fill_1
X_6020_ _8077_/Q _4702_/A _6032_/S VGND VGND VPWR VPWR _6021_/A sky130_fd_sc_hd__mux2_2
XFILLER_100_218 VGND VGND VPWR VPWR sky130_fd_sc_hd__decap_3
XFILLER_39_335 VGND VGND VPWR VPWR sky130_fd_sc_hd__fill_1
XFILLER_67_666 VGND VGND VPWR VPWR sky130_fd_sc_hd__decap_3
XFILLER_94_430 VGND VGND VPWR VPWR sky130_fd_sc_hd__fill_2
XFILLER_94_452 VGND VGND VPWR VPWR sky130_fd_sc_hd__decap_3
XFILLER_27_519 VGND VGND VPWR VPWR sky130_fd_sc_hd__decap_3
XFILLER_54_327 VGND VGND VPWR VPWR sky130_fd_sc_hd__decap_3
XFILLER_81_113 VGND VGND VPWR VPWR sky130_fd_sc_hd__decap_3
XFILLER_82_614 VGND VGND VPWR VPWR sky130_fd_sc_hd__fill_1
X_7971_ _8545_/CLK _7971_/D fanout660/X VGND VGND VPWR VPWR _7971_/Q sky130_fd_sc_hd__dfrtp_2
X_6922_ _6922_/A VGND VGND VPWR VPWR _8500_/D sky130_fd_sc_hd__buf_6
XFILLER_120_29 VGND VGND VPWR VPWR sky130_fd_sc_hd__fill_1
X_6853_ _4985_/X _8468_/Q _6853_/S VGND VGND VPWR VPWR _6854_/A sky130_fd_sc_hd__mux2_4
XFILLER_50_533 VGND VGND VPWR VPWR sky130_fd_sc_hd__decap_3
XFILLER_90_691 VGND VGND VPWR VPWR sky130_fd_sc_hd__decap_3
XTAP_TAPCELL_ROW_85_1486 VGND VPWR sky130_fd_sc_hd__tapvpwrvgnd_1
X_5804_ _5804_/A VGND VGND VPWR VPWR _7940_/D sky130_fd_sc_hd__buf_1
XTAP_TAPCELL_ROW_33_753 VGND VPWR sky130_fd_sc_hd__tapvpwrvgnd_1
X_3996_ _7738_/Q _7819_/Q _3996_/S VGND VGND VPWR VPWR _3996_/X sky130_fd_sc_hd__mux2_2
X_6784_ _8436_/Q _4848_/A _6786_/S VGND VGND VPWR VPWR _6785_/A sky130_fd_sc_hd__mux2_2
XFILLER_13_27 VGND VGND VPWR VPWR sky130_fd_sc_hd__decap_3
X_8523_ _8685_/CLK _8523_/D wire574/X VGND VGND VPWR VPWR _8523_/Q sky130_fd_sc_hd__dfrtp_2
X_5735_ _5735_/A VGND VGND VPWR VPWR _7907_/D sky130_fd_sc_hd__buf_1
XFILLER_129_27 VGND VGND VPWR VPWR sky130_fd_sc_hd__decap_3
XFILLER_30_290 VGND VGND VPWR VPWR sky130_fd_sc_hd__decap_3
XFILLER_31_791 VGND VGND VPWR VPWR sky130_fd_sc_hd__decap_3
X_8454_ _8778_/CLK _8454_/D fanout732/X VGND VGND VPWR VPWR _8454_/Q sky130_fd_sc_hd__dfrtp_2
X_5666_ _5666_/A VGND VGND VPWR VPWR _7875_/D sky130_fd_sc_hd__buf_1
X_7405_ _8760_/Q _4848_/A _7407_/S VGND VGND VPWR VPWR _7406_/A sky130_fd_sc_hd__mux2_2
X_4617_ _4617_/A1 _4616_/X _4617_/B1 VGND VGND VPWR VPWR _4617_/X sky130_fd_sc_hd__a21o_2
XFILLER_135_137 VGND VGND VPWR VPWR sky130_fd_sc_hd__decap_3
XFILLER_135_159 VGND VGND VPWR VPWR sky130_fd_sc_hd__fill_1
Xclkbuf_leaf_144_CLK clkbuf_leaf_1_CLK/A VGND VGND VPWR VPWR _8736_/CLK sky130_fd_sc_hd__clkbuf_8
X_8385_ _8790_/CLK _8385_/D load_slew673/X VGND VGND VPWR VPWR _8385_/Q sky130_fd_sc_hd__dfrtp_2
X_5597_ _5597_/A VGND VGND VPWR VPWR _7842_/D sky130_fd_sc_hd__buf_1
XFILLER_2_607 VGND VGND VPWR VPWR sky130_fd_sc_hd__decap_3
X_7336_ _8727_/Q _4710_/A _7344_/S VGND VGND VPWR VPWR _7337_/A sky130_fd_sc_hd__mux2_2
X_4548_ _7951_/Q _3800_/X _4547_/X _4503_/A _4522_/S VGND VGND VPWR VPWR _4548_/X
+ sky130_fd_sc_hd__o221a_2
XFILLER_8_9 VGND VGND VPWR VPWR sky130_fd_sc_hd__decap_3
Xmax_cap194 _5853_/X VGND VGND VPWR VPWR _5867_/A2 sky130_fd_sc_hd__clkbuf_2
Xmax_cap183 _5922_/X VGND VGND VPWR VPWR _5932_/B1 sky130_fd_sc_hd__buf_2
Xmax_cap172 _7256_/X VGND VGND VPWR VPWR _7266_/A3 sky130_fd_sc_hd__buf_2
X_7267_ _7267_/A VGND VGND VPWR VPWR _7267_/X sky130_fd_sc_hd__clkbuf_2
X_4479_ _3732_/X _4470_/X _4473_/X _4478_/X VGND VGND VPWR VPWR _4479_/X sky130_fd_sc_hd__o31a_2
XFILLER_131_343 VGND VGND VPWR VPWR sky130_fd_sc_hd__decap_3
XFILLER_89_268 VGND VGND VPWR VPWR sky130_fd_sc_hd__decap_3
X_6218_ _4753_/X _8170_/Q _6226_/S VGND VGND VPWR VPWR _6219_/A sky130_fd_sc_hd__mux2_4
XFILLER_58_611 VGND VGND VPWR VPWR sky130_fd_sc_hd__fill_1
XFILLER_98_780 VGND VGND VPWR VPWR sky130_fd_sc_hd__decap_3
X_7198_ _7189_/X _5011_/X _7201_/A3 wire207/X hold913/X VGND VGND VPWR VPWR _8636_/D
+ sky130_fd_sc_hd__a32o_2
XFILLER_38_46 VGND VGND VPWR VPWR sky130_fd_sc_hd__decap_3
XFILLER_38_79 VGND VGND VPWR VPWR sky130_fd_sc_hd__decap_3
XFILLER_85_441 VGND VGND VPWR VPWR sky130_fd_sc_hd__decap_3
X_6149_ _4957_/X _8137_/Q _6163_/S VGND VGND VPWR VPWR _6150_/A sky130_fd_sc_hd__mux2_4
XFILLER_18_519 VGND VGND VPWR VPWR sky130_fd_sc_hd__decap_3
XPHY_EDGE_ROW_79_Right_79 VGND VGND VPWR VPWR sky130_fd_sc_hd__decap_3
XTAP_TAPCELL_ROW_127_2070 VGND VPWR sky130_fd_sc_hd__tapvpwrvgnd_1
XFILLER_73_669 VGND VGND VPWR VPWR sky130_fd_sc_hd__decap_3
XFILLER_14_747 VGND VGND VPWR VPWR sky130_fd_sc_hd__decap_3
XFILLER_26_585 VGND VGND VPWR VPWR sky130_fd_sc_hd__decap_3
XFILLER_41_511 VGND VGND VPWR VPWR sky130_fd_sc_hd__fill_1
XFILLER_41_533 VGND VGND VPWR VPWR sky130_fd_sc_hd__fill_2
XFILLER_53_382 VGND VGND VPWR VPWR sky130_fd_sc_hd__fill_1
XFILLER_54_78 VGND VGND VPWR VPWR sky130_fd_sc_hd__decap_3
XFILLER_110_62 VGND VGND VPWR VPWR sky130_fd_sc_hd__decap_3
XFILLER_110_73 VGND VGND VPWR VPWR sky130_fd_sc_hd__decap_3
XFILLER_21_290 VGND VGND VPWR VPWR sky130_fd_sc_hd__fill_2
XTAP_TAPCELL_ROW_11_447 VGND VPWR sky130_fd_sc_hd__tapvpwrvgnd_1
XFILLER_126_115 VGND VGND VPWR VPWR sky130_fd_sc_hd__decap_3
XFILLER_5_401 VGND VGND VPWR VPWR sky130_fd_sc_hd__fill_2
XPHY_EDGE_ROW_88_Right_88 VGND VGND VPWR VPWR sky130_fd_sc_hd__decap_3
XFILLER_107_340 VGND VGND VPWR VPWR sky130_fd_sc_hd__decap_3
XFILLER_119_60 VGND VGND VPWR VPWR sky130_fd_sc_hd__decap_3
XFILLER_126_137 VGND VGND VPWR VPWR sky130_fd_sc_hd__decap_3
XFILLER_126_148 VGND VGND VPWR VPWR sky130_fd_sc_hd__fill_1
XFILLER_135_660 VGND VGND VPWR VPWR sky130_fd_sc_hd__decap_3
Xclkbuf_leaf_135_CLK clkload1/A VGND VGND VPWR VPWR _8734_/CLK sky130_fd_sc_hd__clkbuf_8
XFILLER_134_192 VGND VGND VPWR VPWR sky130_fd_sc_hd__decap_3
XFILLER_135_693 VGND VGND VPWR VPWR sky130_fd_sc_hd__decap_3
XFILLER_110_505 VGND VGND VPWR VPWR sky130_fd_sc_hd__decap_3
XFILLER_1_662 VGND VGND VPWR VPWR sky130_fd_sc_hd__decap_3
XFILLER_96_728 VGND VGND VPWR VPWR sky130_fd_sc_hd__decap_3
XTAP_TAPCELL_ROW_56_1076 VGND VPWR sky130_fd_sc_hd__tapvpwrvgnd_1
XFILLER_135_81 VGND VGND VPWR VPWR sky130_fd_sc_hd__decap_3
XFILLER_1_673 VGND VGND VPWR VPWR sky130_fd_sc_hd__decap_3
XFILLER_95_216 VGND VGND VPWR VPWR sky130_fd_sc_hd__fill_1
XFILLER_0_194 VGND VGND VPWR VPWR sky130_fd_sc_hd__fill_2
XFILLER_76_430 VGND VGND VPWR VPWR sky130_fd_sc_hd__decap_3
XFILLER_95_63 VGND VGND VPWR VPWR sky130_fd_sc_hd__decap_3
XPHY_EDGE_ROW_97_Right_97 VGND VGND VPWR VPWR sky130_fd_sc_hd__decap_3
XFILLER_48_176 VGND VGND VPWR VPWR sky130_fd_sc_hd__decap_3
XFILLER_49_688 VGND VGND VPWR VPWR sky130_fd_sc_hd__decap_3
XFILLER_76_474 VGND VGND VPWR VPWR sky130_fd_sc_hd__fill_2
XFILLER_36_349 VGND VGND VPWR VPWR sky130_fd_sc_hd__decap_3
XFILLER_63_113 VGND VGND VPWR VPWR sky130_fd_sc_hd__decap_3
XFILLER_91_455 VGND VGND VPWR VPWR sky130_fd_sc_hd__decap_3
XFILLER_51_308 VGND VGND VPWR VPWR sky130_fd_sc_hd__fill_2
XTAP_TAPCELL_ROW_19_558 VGND VPWR sky130_fd_sc_hd__tapvpwrvgnd_1
XFILLER_32_533 VGND VGND VPWR VPWR sky130_fd_sc_hd__fill_1
XFILLER_44_382 VGND VGND VPWR VPWR sky130_fd_sc_hd__decap_3
XFILLER_91_499 VGND VGND VPWR VPWR sky130_fd_sc_hd__fill_1
X_3850_ _8384_/Q _8465_/Q _3861_/S VGND VGND VPWR VPWR _3850_/X sky130_fd_sc_hd__mux2_2
XFILLER_13_780 VGND VGND VPWR VPWR sky130_fd_sc_hd__decap_3
XTAP_TAPCELL_ROW_30_712 VGND VPWR sky130_fd_sc_hd__tapvpwrvgnd_1
X_3781_ _4685_/A1 _3765_/X _3772_/X _3780_/X VGND VGND VPWR VPWR _3781_/X sky130_fd_sc_hd__o31a_2
XFILLER_118_605 VGND VGND VPWR VPWR sky130_fd_sc_hd__decap_3
XFILLER_13_791 VGND VGND VPWR VPWR sky130_fd_sc_hd__decap_3
XFILLER_9_762 VGND VGND VPWR VPWR sky130_fd_sc_hd__decap_3
X_5520_ _7806_/Q _4969_/A _5528_/S VGND VGND VPWR VPWR _5521_/A sky130_fd_sc_hd__mux2_2
X_5451_ _7774_/Q _4832_/A _5461_/S VGND VGND VPWR VPWR _5452_/A sky130_fd_sc_hd__mux2_2
XFILLER_132_118 VGND VGND VPWR VPWR sky130_fd_sc_hd__decap_3
XFILLER_99_500 VGND VGND VPWR VPWR sky130_fd_sc_hd__decap_3
XFILLER_99_511 VGND VGND VPWR VPWR sky130_fd_sc_hd__fill_1
Xclkbuf_leaf_126_CLK clkbuf_leaf_91_CLK/A VGND VGND VPWR VPWR _8793_/CLK sky130_fd_sc_hd__clkbuf_8
X_8170_ _8743_/CLK _8170_/D wire519/X VGND VGND VPWR VPWR _8170_/Q sky130_fd_sc_hd__dfrtp_2
X_5382_ _7741_/Q _5035_/A _5398_/S VGND VGND VPWR VPWR _5383_/A sky130_fd_sc_hd__mux2_2
X_4402_ _8433_/Q _8514_/Q _4402_/S VGND VGND VPWR VPWR _4403_/B sky130_fd_sc_hd__mux2_2
XFILLER_125_181 VGND VGND VPWR VPWR sky130_fd_sc_hd__decap_3
XFILLER_5_72 VGND VGND VPWR VPWR sky130_fd_sc_hd__decap_3
X_7121_ _7121_/A VGND VGND VPWR VPWR _8594_/D sky130_fd_sc_hd__buf_2
X_4333_ _8751_/Q _7526_/Q _7607_/Q _7688_/Q _4247_/S _4344_/A VGND VGND VPWR VPWR
+ _4333_/X sky130_fd_sc_hd__mux4_2
XFILLER_101_505 VGND VGND VPWR VPWR sky130_fd_sc_hd__fill_2
XFILLER_99_588 VGND VGND VPWR VPWR sky130_fd_sc_hd__decap_3
X_7052_ _7052_/A VGND VGND VPWR VPWR _8561_/D sky130_fd_sc_hd__buf_2
X_4264_ _4261_/X _4262_/X _4263_/X _4252_/A _4617_/B1 VGND VGND VPWR VPWR _4264_/X
+ sky130_fd_sc_hd__a221o_2
XFILLER_86_216 VGND VGND VPWR VPWR sky130_fd_sc_hd__decap_3
XFILLER_86_227 VGND VGND VPWR VPWR sky130_fd_sc_hd__fill_2
XFILLER_86_238 VGND VGND VPWR VPWR sky130_fd_sc_hd__fill_1
X_6003_ _8069_/Q input9/X _6011_/S VGND VGND VPWR VPWR _6004_/A sky130_fd_sc_hd__mux2_2
X_4195_ _8658_/Q _4195_/A2 _4600_/A2 _8577_/Q _3955_/A VGND VGND VPWR VPWR _4195_/X
+ sky130_fd_sc_hd__o221a_2
XFILLER_82_400 VGND VGND VPWR VPWR sky130_fd_sc_hd__decap_3
XFILLER_95_794 VGND VGND VPWR VPWR sky130_fd_sc_hd__fill_2
XTAP_TAPCELL_ROW_87_1504 VGND VPWR sky130_fd_sc_hd__tapvpwrvgnd_1
XTAP_TAPCELL_ROW_87_1515 VGND VPWR sky130_fd_sc_hd__tapvpwrvgnd_1
XFILLER_131_39 VGND VGND VPWR VPWR sky130_fd_sc_hd__decap_3
XFILLER_82_433 VGND VGND VPWR VPWR sky130_fd_sc_hd__decap_3
XPHY_EDGE_ROW_19_Left_155 VGND VGND VPWR VPWR sky130_fd_sc_hd__decap_3
XTAP_TAPCELL_ROW_38_823 VGND VPWR sky130_fd_sc_hd__tapvpwrvgnd_1
X_7954_ _8693_/CLK _7954_/D load_slew738/X VGND VGND VPWR VPWR _7954_/Q sky130_fd_sc_hd__dfrtp_2
XFILLER_82_466 VGND VGND VPWR VPWR sky130_fd_sc_hd__fill_1
X_6905_ _6905_/A VGND VGND VPWR VPWR _8492_/D sky130_fd_sc_hd__buf_6
XFILLER_23_511 VGND VGND VPWR VPWR sky130_fd_sc_hd__decap_3
XFILLER_24_15 VGND VGND VPWR VPWR sky130_fd_sc_hd__decap_3
X_7885_ _8627_/CLK _7885_/D load_slew667/X VGND VGND VPWR VPWR _7885_/Q sky130_fd_sc_hd__dfrtp_2
XFILLER_35_393 VGND VGND VPWR VPWR sky130_fd_sc_hd__fill_1
X_6836_ _6836_/A VGND VGND VPWR VPWR _8459_/D sky130_fd_sc_hd__buf_6
XFILLER_23_588 VGND VGND VPWR VPWR sky130_fd_sc_hd__decap_3
XFILLER_24_59 VGND VGND VPWR VPWR sky130_fd_sc_hd__decap_3
X_6767_ _6830_/S VGND VGND VPWR VPWR _6786_/S sky130_fd_sc_hd__buf_2
XFILLER_10_249 VGND VGND VPWR VPWR sky130_fd_sc_hd__decap_3
X_3979_ _4467_/A1 _3968_/X _3972_/X _3975_/X _3978_/X VGND VGND VPWR VPWR _3979_/X
+ sky130_fd_sc_hd__o32a_2
X_8506_ _8668_/CLK _8506_/D wire638/X VGND VGND VPWR VPWR _8506_/Q sky130_fd_sc_hd__dfrtp_2
X_5718_ _5718_/A VGND VGND VPWR VPWR _7899_/D sky130_fd_sc_hd__buf_1
XPHY_EDGE_ROW_28_Left_164 VGND VGND VPWR VPWR sky130_fd_sc_hd__decap_3
X_6698_ _8395_/Q _5018_/A _6702_/S VGND VGND VPWR VPWR _6699_/A sky130_fd_sc_hd__mux2_2
XTAP_TAPCELL_ROW_98_1666 VGND VPWR sky130_fd_sc_hd__tapvpwrvgnd_1
X_8437_ _8518_/CLK _8437_/D load_slew704/X VGND VGND VPWR VPWR _8437_/Q sky130_fd_sc_hd__dfrtp_2
X_5649_ _5649_/A VGND VGND VPWR VPWR _7867_/D sky130_fd_sc_hd__buf_1
XFILLER_105_800 VGND VGND VPWR VPWR sky130_fd_sc_hd__decap_3
XFILLER_117_671 VGND VGND VPWR VPWR sky130_fd_sc_hd__fill_1
Xclkbuf_leaf_117_CLK clkbuf_5_16__f_CLK/X VGND VGND VPWR VPWR _7923_/CLK sky130_fd_sc_hd__clkbuf_8
X_8368_ _8699_/CLK _8368_/D fanout725/X VGND VGND VPWR VPWR _8368_/Q sky130_fd_sc_hd__dfrtp_2
XFILLER_6_6 VGND VGND VPWR VPWR sky130_fd_sc_hd__decap_3
X_7319_ _8719_/Q _5018_/A _7323_/S VGND VGND VPWR VPWR _7320_/A sky130_fd_sc_hd__mux2_2
XFILLER_131_140 VGND VGND VPWR VPWR sky130_fd_sc_hd__decap_3
XFILLER_132_663 VGND VGND VPWR VPWR sky130_fd_sc_hd__decap_3
XFILLER_49_23 VGND VGND VPWR VPWR sky130_fd_sc_hd__decap_3
X_8299_ _8621_/CLK _8299_/D fanout681/X VGND VGND VPWR VPWR _8299_/Q sky130_fd_sc_hd__dfrtp_2
XFILLER_104_398 VGND VGND VPWR VPWR sky130_fd_sc_hd__fill_1
XFILLER_131_184 VGND VGND VPWR VPWR sky130_fd_sc_hd__decap_3
XFILLER_132_696 VGND VGND VPWR VPWR sky130_fd_sc_hd__decap_3
Xfanout730 fanout732/A VGND VGND VPWR VPWR fanout730/X sky130_fd_sc_hd__clkdlybuf4s25_1
Xfanout741 fanout744/X VGND VGND VPWR VPWR fanout741/X sky130_fd_sc_hd__clkdlybuf4s25_1
XFILLER_77_249 VGND VGND VPWR VPWR sky130_fd_sc_hd__fill_1
XPHY_EDGE_ROW_130_Right_130 VGND VGND VPWR VPWR sky130_fd_sc_hd__decap_3
XFILLER_46_625 VGND VGND VPWR VPWR sky130_fd_sc_hd__decap_3
XFILLER_58_463 VGND VGND VPWR VPWR sky130_fd_sc_hd__fill_2
XFILLER_58_474 VGND VGND VPWR VPWR sky130_fd_sc_hd__fill_2
XFILLER_58_485 VGND VGND VPWR VPWR sky130_fd_sc_hd__fill_1
XPHY_EDGE_ROW_37_Left_173 VGND VGND VPWR VPWR sky130_fd_sc_hd__decap_3
XFILLER_45_113 VGND VGND VPWR VPWR sky130_fd_sc_hd__fill_1
XFILLER_61_617 VGND VGND VPWR VPWR sky130_fd_sc_hd__fill_2
XFILLER_121_50 VGND VGND VPWR VPWR sky130_fd_sc_hd__decap_3
XFILLER_60_127 VGND VGND VPWR VPWR sky130_fd_sc_hd__fill_2
XFILLER_73_499 VGND VGND VPWR VPWR sky130_fd_sc_hd__decap_3
XTAP_TAPCELL_ROW_107_1784 VGND VPWR sky130_fd_sc_hd__tapvpwrvgnd_1
XTAP_TAPCELL_ROW_107_1795 VGND VPWR sky130_fd_sc_hd__tapvpwrvgnd_1
XTAP_TAPCELL_ROW_16_517 VGND VPWR sky130_fd_sc_hd__tapvpwrvgnd_1
XFILLER_14_566 VGND VGND VPWR VPWR sky130_fd_sc_hd__decap_3
XFILLER_26_393 VGND VGND VPWR VPWR sky130_fd_sc_hd__decap_3
XFILLER_53_190 VGND VGND VPWR VPWR sky130_fd_sc_hd__fill_1
XFILLER_81_32 VGND VGND VPWR VPWR sky130_fd_sc_hd__decap_3
XFILLER_41_352 VGND VGND VPWR VPWR sky130_fd_sc_hd__decap_3
XTAP_TAPCELL_ROW_120_1973 VGND VPWR sky130_fd_sc_hd__tapvpwrvgnd_1
XPHY_EDGE_ROW_46_Left_182 VGND VGND VPWR VPWR sky130_fd_sc_hd__decap_3
XFILLER_10_772 VGND VGND VPWR VPWR sky130_fd_sc_hd__decap_3
XFILLER_6_710 VGND VGND VPWR VPWR sky130_fd_sc_hd__decap_3
XFILLER_6_743 VGND VGND VPWR VPWR sky130_fd_sc_hd__decap_3
XTAP_TAPCELL_ROW_58_1105 VGND VPWR sky130_fd_sc_hd__tapvpwrvgnd_1
XFILLER_127_479 VGND VGND VPWR VPWR sky130_fd_sc_hd__decap_3
XFILLER_6_787 VGND VGND VPWR VPWR sky130_fd_sc_hd__decap_3
Xclkbuf_leaf_108_CLK clkload7/A VGND VGND VPWR VPWR _8788_/CLK sky130_fd_sc_hd__clkbuf_8
XFILLER_5_275 VGND VGND VPWR VPWR sky130_fd_sc_hd__fill_1
XFILLER_107_192 VGND VGND VPWR VPWR sky130_fd_sc_hd__decap_3
XFILLER_123_641 VGND VGND VPWR VPWR sky130_fd_sc_hd__decap_3
XFILLER_68_216 VGND VGND VPWR VPWR sky130_fd_sc_hd__decap_3
XFILLER_110_357 VGND VGND VPWR VPWR sky130_fd_sc_hd__fill_2
XFILLER_49_441 VGND VGND VPWR VPWR sky130_fd_sc_hd__decap_3
XFILLER_68_249 VGND VGND VPWR VPWR sky130_fd_sc_hd__decap_3
XFILLER_96_558 VGND VGND VPWR VPWR sky130_fd_sc_hd__decap_3
XPHY_EDGE_ROW_55_Left_191 VGND VGND VPWR VPWR sky130_fd_sc_hd__decap_3
XFILLER_37_614 VGND VGND VPWR VPWR sky130_fd_sc_hd__fill_2
XFILLER_49_452 VGND VGND VPWR VPWR sky130_fd_sc_hd__decap_3
XFILLER_49_485 VGND VGND VPWR VPWR sky130_fd_sc_hd__fill_2
XFILLER_83_219 VGND VGND VPWR VPWR sky130_fd_sc_hd__decap_3
Xinput7 wdata[13] VGND VGND VPWR VPWR input7/X sky130_fd_sc_hd__clkdlybuf4s25_1
XFILLER_76_271 VGND VGND VPWR VPWR sky130_fd_sc_hd__decap_3
XFILLER_36_168 VGND VGND VPWR VPWR sky130_fd_sc_hd__decap_3
XFILLER_52_617 VGND VGND VPWR VPWR sky130_fd_sc_hd__fill_2
XTAP_TAPCELL_ROW_69_1256 VGND VPWR sky130_fd_sc_hd__tapvpwrvgnd_1
XFILLER_17_371 VGND VGND VPWR VPWR sky130_fd_sc_hd__decap_3
XFILLER_36_179 VGND VGND VPWR VPWR sky130_fd_sc_hd__decap_3
XFILLER_45_680 VGND VGND VPWR VPWR sky130_fd_sc_hd__fill_1
XFILLER_91_296 VGND VGND VPWR VPWR sky130_fd_sc_hd__decap_3
X_4951_ _4951_/A VGND VGND VPWR VPWR _4988_/B sky130_fd_sc_hd__clkbuf_1
XFILLER_17_393 VGND VGND VPWR VPWR sky130_fd_sc_hd__decap_3
XTAP_TAPCELL_ROW_82_1434 VGND VPWR sky130_fd_sc_hd__tapvpwrvgnd_1
XTAP_TAPCELL_ROW_82_1445 VGND VPWR sky130_fd_sc_hd__tapvpwrvgnd_1
X_3902_ _3902_/A VGND VGND VPWR VPWR _3902_/X sky130_fd_sc_hd__buf_1
X_7670_ _8730_/CLK _7670_/D load_slew484/X VGND VGND VPWR VPWR _7670_/Q sky130_fd_sc_hd__dfrtp_2
X_4882_ _4882_/A _4902_/B VGND VGND VPWR VPWR _4883_/A sky130_fd_sc_hd__and2_2
X_3833_ _4685_/A1 _3827_/X _3832_/X VGND VGND VPWR VPWR _3833_/X sky130_fd_sc_hd__a21o_2
X_6621_ _4871_/X _8360_/Q _6633_/S VGND VGND VPWR VPWR _6622_/A sky130_fd_sc_hd__mux2_2
XTAP_TAPCELL_ROW_43_892 VGND VPWR sky130_fd_sc_hd__tapvpwrvgnd_1
XFILLER_118_424 VGND VGND VPWR VPWR sky130_fd_sc_hd__decap_3
X_3764_ _7964_/Q _4629_/B _4388_/B _7883_/Q _3875_/A VGND VGND VPWR VPWR _3764_/X
+ sky130_fd_sc_hd__o221a_2
X_6552_ _4731_/X _8327_/Q _6570_/S VGND VGND VPWR VPWR _6553_/A sky130_fd_sc_hd__mux2_2
X_6483_ _6483_/A VGND VGND VPWR VPWR _8295_/D sky130_fd_sc_hd__buf_2
X_5503_ _7799_/Q _4936_/A _5503_/S VGND VGND VPWR VPWR _5504_/A sky130_fd_sc_hd__mux2_2
XFILLER_133_405 VGND VGND VPWR VPWR sky130_fd_sc_hd__decap_3
X_8222_ _8709_/CLK _8222_/D fanout674/X VGND VGND VPWR VPWR _8222_/Q sky130_fd_sc_hd__dfrtp_2
X_5434_ _7766_/Q _4798_/A _5440_/S VGND VGND VPWR VPWR _5435_/A sky130_fd_sc_hd__mux2_2
XFILLER_114_630 VGND VGND VPWR VPWR sky130_fd_sc_hd__decap_3
XFILLER_133_438 VGND VGND VPWR VPWR sky130_fd_sc_hd__decap_3
XFILLER_133_449 VGND VGND VPWR VPWR sky130_fd_sc_hd__decap_3
X_8153_ _8796_/CLK _8153_/D fanout609/X VGND VGND VPWR VPWR _8153_/Q sky130_fd_sc_hd__dfrtp_2
X_7104_ _7104_/A VGND VGND VPWR VPWR _8586_/D sky130_fd_sc_hd__buf_2
X_5365_ _7733_/Q input7/X _5377_/S VGND VGND VPWR VPWR _5366_/A sky130_fd_sc_hd__mux2_2
XFILLER_114_696 VGND VGND VPWR VPWR sky130_fd_sc_hd__decap_3
XFILLER_99_396 VGND VGND VPWR VPWR sky130_fd_sc_hd__decap_3
XTAP_TAPCELL_ROW_93_1596 VGND VPWR sky130_fd_sc_hd__tapvpwrvgnd_1
X_8084_ _8493_/CLK _8084_/D load_slew480/X VGND VGND VPWR VPWR _8084_/Q sky130_fd_sc_hd__dfrtp_2
X_5296_ _7701_/Q _4866_/X _5310_/S VGND VGND VPWR VPWR _5297_/A sky130_fd_sc_hd__mux2_2
X_4316_ _3739_/B _4314_/X _4315_/X VGND VGND VPWR VPWR _4316_/X sky130_fd_sc_hd__o21a_2
XFILLER_101_335 VGND VGND VPWR VPWR sky130_fd_sc_hd__fill_1
XFILLER_19_15 VGND VGND VPWR VPWR sky130_fd_sc_hd__decap_3
X_7035_ _7035_/A VGND VGND VPWR VPWR _8553_/D sky130_fd_sc_hd__buf_2
X_4247_ _8420_/Q _8501_/Q _4247_/S VGND VGND VPWR VPWR _4247_/X sky130_fd_sc_hd__mux2_2
XFILLER_101_368 VGND VGND VPWR VPWR sky130_fd_sc_hd__decap_3
XFILLER_101_379 VGND VGND VPWR VPWR sky130_fd_sc_hd__fill_1
XFILLER_19_48 VGND VGND VPWR VPWR sky130_fd_sc_hd__decap_3
X_4178_ _7674_/Q _3750_/X _3752_/X _7593_/Q _3733_/A VGND VGND VPWR VPWR _4178_/X
+ sky130_fd_sc_hd__o221a_2
XFILLER_27_124 VGND VGND VPWR VPWR sky130_fd_sc_hd__decap_3
XFILLER_95_591 VGND VGND VPWR VPWR sky130_fd_sc_hd__decap_3
XFILLER_15_308 VGND VGND VPWR VPWR sky130_fd_sc_hd__decap_3
XFILLER_27_157 VGND VGND VPWR VPWR sky130_fd_sc_hd__decap_3
XFILLER_42_116 VGND VGND VPWR VPWR sky130_fd_sc_hd__decap_3
XFILLER_55_499 VGND VGND VPWR VPWR sky130_fd_sc_hd__decap_3
XFILLER_70_436 VGND VGND VPWR VPWR sky130_fd_sc_hd__decap_3
XFILLER_82_285 VGND VGND VPWR VPWR sky130_fd_sc_hd__decap_3
X_7937_ _8758_/CLK _7937_/D load_slew714/X VGND VGND VPWR VPWR _7937_/Q sky130_fd_sc_hd__dfrtp_2
X_7868_ _8683_/CLK _7868_/D fanout564/X VGND VGND VPWR VPWR _7868_/Q sky130_fd_sc_hd__dfrtp_2
XFILLER_11_503 VGND VGND VPWR VPWR sky130_fd_sc_hd__fill_1
X_6819_ _6819_/A VGND VGND VPWR VPWR _8452_/D sky130_fd_sc_hd__buf_2
XFILLER_11_525 VGND VGND VPWR VPWR sky130_fd_sc_hd__fill_1
XFILLER_50_193 VGND VGND VPWR VPWR sky130_fd_sc_hd__decap_3
X_7799_ _8700_/CLK _7799_/D fanout751/X VGND VGND VPWR VPWR _7799_/Q sky130_fd_sc_hd__dfrtp_2
XFILLER_51_46 VGND VGND VPWR VPWR sky130_fd_sc_hd__fill_1
XFILLER_51_57 VGND VGND VPWR VPWR sky130_fd_sc_hd__fill_1
XFILLER_7_529 VGND VGND VPWR VPWR sky130_fd_sc_hd__fill_2
XTAP_TAPCELL_ROW_21_586 VGND VPWR sky130_fd_sc_hd__tapvpwrvgnd_1
XTAP_TAPCELL_ROW_135_2180 VGND VPWR sky130_fd_sc_hd__tapvpwrvgnd_1
XTAP_TAPCELL_ROW_135_2191 VGND VPWR sky130_fd_sc_hd__tapvpwrvgnd_1
XFILLER_124_427 VGND VGND VPWR VPWR sky130_fd_sc_hd__decap_3
XFILLER_3_724 VGND VGND VPWR VPWR sky130_fd_sc_hd__decap_3
XFILLER_3_735 VGND VGND VPWR VPWR sky130_fd_sc_hd__decap_3
XFILLER_3_768 VGND VGND VPWR VPWR sky130_fd_sc_hd__decap_3
XFILLER_4_3 VGND VGND VPWR VPWR sky130_fd_sc_hd__decap_3
XFILLER_104_173 VGND VGND VPWR VPWR sky130_fd_sc_hd__decap_3
XFILLER_105_685 VGND VGND VPWR VPWR sky130_fd_sc_hd__decap_3
XFILLER_132_460 VGND VGND VPWR VPWR sky130_fd_sc_hd__decap_3
XFILLER_78_525 VGND VGND VPWR VPWR sky130_fd_sc_hd__decap_3
XTAP_TAPCELL_ROW_53_1035 VGND VPWR sky130_fd_sc_hd__tapvpwrvgnd_1
XFILLER_59_750 VGND VGND VPWR VPWR sky130_fd_sc_hd__decap_3
XFILLER_76_32 VGND VGND VPWR VPWR sky130_fd_sc_hd__decap_3
XTAP_TAPCELL_ROW_109_1813 VGND VPWR sky130_fd_sc_hd__tapvpwrvgnd_1
Xfanout571 fanout576/X VGND VGND VPWR VPWR fanout571/X sky130_fd_sc_hd__clkdlybuf4s25_1
XFILLER_19_636 VGND VGND VPWR VPWR sky130_fd_sc_hd__fill_1
XFILLER_93_539 VGND VGND VPWR VPWR sky130_fd_sc_hd__fill_2
XTAP_TAPCELL_ROW_109_1824 VGND VPWR sky130_fd_sc_hd__tapvpwrvgnd_1
XFILLER_132_71 VGND VGND VPWR VPWR sky130_fd_sc_hd__decap_3
XFILLER_18_157 VGND VGND VPWR VPWR sky130_fd_sc_hd__decap_3
XFILLER_92_53 VGND VGND VPWR VPWR sky130_fd_sc_hd__fill_2
XTAP_TAPCELL_ROW_29_697 VGND VPWR sky130_fd_sc_hd__tapvpwrvgnd_1
XFILLER_26_190 VGND VGND VPWR VPWR sky130_fd_sc_hd__decap_3
XFILLER_61_447 VGND VGND VPWR VPWR sky130_fd_sc_hd__fill_1
XFILLER_92_64 VGND VGND VPWR VPWR sky130_fd_sc_hd__decap_3
XFILLER_14_363 VGND VGND VPWR VPWR sky130_fd_sc_hd__fill_1
XFILLER_14_374 VGND VGND VPWR VPWR sky130_fd_sc_hd__decap_3
XFILLER_41_160 VGND VGND VPWR VPWR sky130_fd_sc_hd__decap_3
XFILLER_42_694 VGND VGND VPWR VPWR sky130_fd_sc_hd__decap_3
XTAP_TAPCELL_ROW_64_1186 VGND VPWR sky130_fd_sc_hd__tapvpwrvgnd_1
XFILLER_128_722 VGND VGND VPWR VPWR sky130_fd_sc_hd__decap_3
XTAP_TAPCELL_ROW_40_851 VGND VPWR sky130_fd_sc_hd__tapvpwrvgnd_1
XFILLER_127_221 VGND VGND VPWR VPWR sky130_fd_sc_hd__decap_3
XFILLER_128_755 VGND VGND VPWR VPWR sky130_fd_sc_hd__fill_1
XFILLER_128_766 VGND VGND VPWR VPWR sky130_fd_sc_hd__decap_3
XFILLER_127_243 VGND VGND VPWR VPWR sky130_fd_sc_hd__decap_3
XFILLER_127_254 VGND VGND VPWR VPWR sky130_fd_sc_hd__fill_1
XFILLER_127_276 VGND VGND VPWR VPWR sky130_fd_sc_hd__decap_3
XFILLER_128_799 VGND VGND VPWR VPWR sky130_fd_sc_hd__decap_3
XFILLER_41_90 VGND VGND VPWR VPWR sky130_fd_sc_hd__decap_3
XFILLER_6_562 VGND VGND VPWR VPWR sky130_fd_sc_hd__decap_3
XFILLER_6_595 VGND VGND VPWR VPWR sky130_fd_sc_hd__decap_3
XFILLER_111_611 VGND VGND VPWR VPWR sky130_fd_sc_hd__decap_3
XFILLER_37_3 VGND VGND VPWR VPWR sky130_fd_sc_hd__decap_3
XFILLER_69_503 VGND VGND VPWR VPWR sky130_fd_sc_hd__fill_1
X_5150_ _4921_/X hold959/X _5158_/S VGND VGND VPWR VPWR _5151_/A sky130_fd_sc_hd__mux2_2
XFILLER_111_644 VGND VGND VPWR VPWR sky130_fd_sc_hd__fill_1
XFILLER_2_790 VGND VGND VPWR VPWR sky130_fd_sc_hd__decap_3
XFILLER_69_547 VGND VGND VPWR VPWR sky130_fd_sc_hd__decap_3
XFILLER_96_333 VGND VGND VPWR VPWR sky130_fd_sc_hd__fill_2
X_5081_ _4782_/X _7600_/Q _5095_/S VGND VGND VPWR VPWR _5082_/A sky130_fd_sc_hd__mux2_2
X_4101_ _4146_/A _4101_/B VGND VGND VPWR VPWR _4101_/X sky130_fd_sc_hd__or2_2
XFILLER_111_699 VGND VGND VPWR VPWR sky130_fd_sc_hd__decap_3
XFILLER_2_62 VGND VGND VPWR VPWR sky130_fd_sc_hd__decap_3
X_4032_ _7985_/Q _4032_/B VGND VGND VPWR VPWR _4032_/X sky130_fd_sc_hd__or2_2
XFILLER_110_187 VGND VGND VPWR VPWR sky130_fd_sc_hd__decap_3
XFILLER_37_411 VGND VGND VPWR VPWR sky130_fd_sc_hd__decap_3
XFILLER_37_455 VGND VGND VPWR VPWR sky130_fd_sc_hd__fill_1
XFILLER_80_701 VGND VGND VPWR VPWR sky130_fd_sc_hd__fill_2
XTAP_TAPCELL_ROW_48_962 VGND VPWR sky130_fd_sc_hd__tapvpwrvgnd_1
XFILLER_52_414 VGND VGND VPWR VPWR sky130_fd_sc_hd__decap_3
XFILLER_80_712 VGND VGND VPWR VPWR sky130_fd_sc_hd__decap_3
X_8771_ _8771_/CLK _8771_/D fanout595/A VGND VGND VPWR VPWR _8771_/Q sky130_fd_sc_hd__dfrtp_2
X_5983_ _5983_/A VGND VGND VPWR VPWR _8059_/D sky130_fd_sc_hd__buf_1
XFILLER_52_458 VGND VGND VPWR VPWR sky130_fd_sc_hd__fill_1
X_7722_ _8785_/CLK _7722_/D load_slew678/X VGND VGND VPWR VPWR _7722_/Q sky130_fd_sc_hd__dfrtp_2
X_4934_ _4933_/X hold979/X _7453_/S VGND VGND VPWR VPWR _4935_/A sky130_fd_sc_hd__mux2_2
XFILLER_21_801 VGND VGND VPWR VPWR sky130_fd_sc_hd__decap_3
XFILLER_33_650 VGND VGND VPWR VPWR sky130_fd_sc_hd__decap_3
XFILLER_20_333 VGND VGND VPWR VPWR sky130_fd_sc_hd__decap_3
XFILLER_60_480 VGND VGND VPWR VPWR sky130_fd_sc_hd__decap_3
X_7653_ _8800_/CLK _7653_/D load_slew593/X VGND VGND VPWR VPWR _7653_/Q sky130_fd_sc_hd__dfrtp_2
X_4865_ _4865_/A _4902_/B VGND VGND VPWR VPWR _4866_/A sky130_fd_sc_hd__and2_2
X_3816_ _3939_/A VGND VGND VPWR VPWR _3816_/X sky130_fd_sc_hd__clkbuf_2
X_7584_ _8161_/CLK _7584_/D fanout578/X VGND VGND VPWR VPWR _7584_/Q sky130_fd_sc_hd__dfrtp_2
X_6604_ _4837_/X _8352_/Q _6612_/S VGND VGND VPWR VPWR _6605_/A sky130_fd_sc_hd__mux2_2
X_4796_ _4795_/X _4796_/A1 _4820_/S VGND VGND VPWR VPWR _4797_/A sky130_fd_sc_hd__mux2_2
XFILLER_21_27 VGND VGND VPWR VPWR sky130_fd_sc_hd__decap_3
X_3747_ _8054_/Q _8135_/Q _3747_/S VGND VGND VPWR VPWR _3748_/B sky130_fd_sc_hd__mux2_2
X_6535_ _4691_/X _8319_/Q _6549_/S VGND VGND VPWR VPWR _6536_/A sky130_fd_sc_hd__mux2_2
XFILLER_106_405 VGND VGND VPWR VPWR sky130_fd_sc_hd__decap_3
XFILLER_119_766 VGND VGND VPWR VPWR sky130_fd_sc_hd__decap_3
XFILLER_119_799 VGND VGND VPWR VPWR sky130_fd_sc_hd__decap_3
XTAP_TAPCELL_ROW_95_1625 VGND VPWR sky130_fd_sc_hd__tapvpwrvgnd_1
XFILLER_133_202 VGND VGND VPWR VPWR sky130_fd_sc_hd__decap_3
XFILLER_134_725 VGND VGND VPWR VPWR sky130_fd_sc_hd__decap_3
X_8205_ _8772_/CLK _8205_/D fanout719/X VGND VGND VPWR VPWR _8205_/Q sky130_fd_sc_hd__dfrtp_2
X_6466_ _4903_/X _8287_/Q _6482_/S VGND VGND VPWR VPWR _6467_/A sky130_fd_sc_hd__mux2_2
XFILLER_121_408 VGND VGND VPWR VPWR sky130_fd_sc_hd__fill_1
XFILLER_133_246 VGND VGND VPWR VPWR sky130_fd_sc_hd__decap_3
XFILLER_134_769 VGND VGND VPWR VPWR sky130_fd_sc_hd__decap_3
Xoutput130 _4337_/X VGND VGND VPWR VPWR rdata[49] sky130_fd_sc_hd__clkdlybuf4s25_1
Xoutput141 _4458_/X VGND VGND VPWR VPWR rdata[59] sky130_fd_sc_hd__clkdlybuf4s25_1
Xoutput152 _4558_/X VGND VGND VPWR VPWR rdata[69] sky130_fd_sc_hd__clkdlybuf4s25_1
X_6397_ _6397_/A VGND VGND VPWR VPWR _8254_/D sky130_fd_sc_hd__buf_2
X_5417_ _7758_/Q _4764_/A _5419_/S VGND VGND VPWR VPWR _5418_/A sky130_fd_sc_hd__mux2_2
XFILLER_0_716 VGND VGND VPWR VPWR sky130_fd_sc_hd__decap_3
XFILLER_0_738 VGND VGND VPWR VPWR sky130_fd_sc_hd__decap_3
XFILLER_133_279 VGND VGND VPWR VPWR sky130_fd_sc_hd__fill_1
XFILLER_99_160 VGND VGND VPWR VPWR sky130_fd_sc_hd__decap_3
Xoutput163 _4674_/X VGND VGND VPWR VPWR rdata[79] sky130_fd_sc_hd__clkdlybuf4s25_1
X_8136_ _8791_/CLK _8136_/D fanout658/X VGND VGND VPWR VPWR _8136_/Q sky130_fd_sc_hd__dfrtp_2
X_5348_ _7725_/Q _4968_/A _5356_/S VGND VGND VPWR VPWR _5349_/A sky130_fd_sc_hd__mux2_2
X_8067_ _8796_/CLK _8067_/D wire707/X VGND VGND VPWR VPWR _8067_/Q sky130_fd_sc_hd__dfrtp_2
XFILLER_101_143 VGND VGND VPWR VPWR sky130_fd_sc_hd__decap_3
XFILLER_102_677 VGND VGND VPWR VPWR sky130_fd_sc_hd__decap_3
XFILLER_87_388 VGND VGND VPWR VPWR sky130_fd_sc_hd__decap_3
X_7018_ _7018_/A VGND VGND VPWR VPWR _8545_/D sky130_fd_sc_hd__buf_2
X_5279_ _7693_/Q _4833_/X _5289_/S VGND VGND VPWR VPWR _5280_/A sky130_fd_sc_hd__mux2_2
XFILLER_28_444 VGND VGND VPWR VPWR sky130_fd_sc_hd__decap_3
XFILLER_15_116 VGND VGND VPWR VPWR sky130_fd_sc_hd__decap_3
XFILLER_16_639 VGND VGND VPWR VPWR sky130_fd_sc_hd__fill_2
XFILLER_28_488 VGND VGND VPWR VPWR sky130_fd_sc_hd__decap_3
XFILLER_43_403 VGND VGND VPWR VPWR sky130_fd_sc_hd__decap_3
XFILLER_102_41 VGND VGND VPWR VPWR sky130_fd_sc_hd__decap_3
XFILLER_102_63 VGND VGND VPWR VPWR sky130_fd_sc_hd__fill_2
XFILLER_15_149 VGND VGND VPWR VPWR sky130_fd_sc_hd__decap_3
XFILLER_31_609 VGND VGND VPWR VPWR sky130_fd_sc_hd__decap_3
XFILLER_55_296 VGND VGND VPWR VPWR sky130_fd_sc_hd__decap_3
XTAP_TAPCELL_ROW_104_1743 VGND VPWR sky130_fd_sc_hd__tapvpwrvgnd_1
XTAP_TAPCELL_ROW_26_656 VGND VPWR sky130_fd_sc_hd__tapvpwrvgnd_1
XTAP_TAPCELL_ROW_104_1754 VGND VPWR sky130_fd_sc_hd__tapvpwrvgnd_1
XFILLER_129_508 VGND VGND VPWR VPWR sky130_fd_sc_hd__decap_3
XFILLER_24_683 VGND VGND VPWR VPWR sky130_fd_sc_hd__decap_3
XFILLER_51_491 VGND VGND VPWR VPWR sky130_fd_sc_hd__decap_3
XFILLER_62_67 VGND VGND VPWR VPWR sky130_fd_sc_hd__decap_3
XFILLER_11_333 VGND VGND VPWR VPWR sky130_fd_sc_hd__decap_3
XFILLER_7_18 VGND VGND VPWR VPWR sky130_fd_sc_hd__decap_3
XFILLER_11_377 VGND VGND VPWR VPWR sky130_fd_sc_hd__decap_3
XFILLER_11_399 VGND VGND VPWR VPWR sky130_fd_sc_hd__fill_1
XFILLER_11_60 VGND VGND VPWR VPWR sky130_fd_sc_hd__decap_3
XFILLER_127_60 VGND VGND VPWR VPWR sky130_fd_sc_hd__decap_3
XFILLER_127_93 VGND VGND VPWR VPWR sky130_fd_sc_hd__decap_3
XFILLER_133_780 VGND VGND VPWR VPWR sky130_fd_sc_hd__decap_3
XFILLER_97_119 VGND VGND VPWR VPWR sky130_fd_sc_hd__decap_3
XFILLER_120_430 VGND VGND VPWR VPWR sky130_fd_sc_hd__decap_3
XFILLER_133_791 VGND VGND VPWR VPWR sky130_fd_sc_hd__decap_3
XFILLER_3_598 VGND VGND VPWR VPWR sky130_fd_sc_hd__decap_3
XFILLER_87_86 VGND VGND VPWR VPWR sky130_fd_sc_hd__decap_3
XFILLER_120_463 VGND VGND VPWR VPWR sky130_fd_sc_hd__decap_3
XFILLER_120_474 VGND VGND VPWR VPWR sky130_fd_sc_hd__fill_2
XFILLER_93_303 VGND VGND VPWR VPWR sky130_fd_sc_hd__decap_3
XTAP_TAPCELL_ROW_6_370 VGND VPWR sky130_fd_sc_hd__tapvpwrvgnd_1
XTAP_TAPCELL_ROW_6_381 VGND VPWR sky130_fd_sc_hd__tapvpwrvgnd_1
Xfanout390 _4636_/S1 VGND VGND VPWR VPWR _4646_/A1 sky130_fd_sc_hd__clkdlybuf4s25_1
XFILLER_46_230 VGND VGND VPWR VPWR sky130_fd_sc_hd__decap_3
XFILLER_62_701 VGND VGND VPWR VPWR sky130_fd_sc_hd__decap_3
XFILLER_93_369 VGND VGND VPWR VPWR sky130_fd_sc_hd__decap_3
XTAP_TAPCELL_ROW_45_921 VGND VPWR sky130_fd_sc_hd__tapvpwrvgnd_1
XTAP_TAPCELL_ROW_66_1215 VGND VPWR sky130_fd_sc_hd__tapvpwrvgnd_1
XFILLER_34_436 VGND VGND VPWR VPWR sky130_fd_sc_hd__fill_2
XFILLER_61_222 VGND VGND VPWR VPWR sky130_fd_sc_hd__fill_2
X_4650_ _7797_/Q _7878_/Q _4650_/S VGND VGND VPWR VPWR _4651_/B sky130_fd_sc_hd__mux2_2
XFILLER_30_686 VGND VGND VPWR VPWR sky130_fd_sc_hd__fill_1
Xinput10 wdata[16] VGND VGND VPWR VPWR _5014_/A sky130_fd_sc_hd__clkdlybuf4s25_1
Xinput21 wdata[26] VGND VGND VPWR VPWR _4714_/A sky130_fd_sc_hd__clkdlybuf4s25_1
XFILLER_128_563 VGND VGND VPWR VPWR sky130_fd_sc_hd__decap_3
Xinput32 wdata[36] VGND VGND VPWR VPWR _4756_/A sky130_fd_sc_hd__clkdlybuf4s25_1
Xinput43 wdata[46] VGND VGND VPWR VPWR _4798_/A sky130_fd_sc_hd__clkdlybuf4s25_1
Xinput54 wdata[56] VGND VGND VPWR VPWR _4840_/A sky130_fd_sc_hd__clkdlybuf4s25_1
X_6320_ _6320_/A VGND VGND VPWR VPWR _8217_/D sky130_fd_sc_hd__buf_2
X_4581_ _4581_/A1 _4579_/X _4580_/X VGND VGND VPWR VPWR _4581_/X sky130_fd_sc_hd__o21a_2
XFILLER_115_202 VGND VGND VPWR VPWR sky130_fd_sc_hd__decap_3
Xhold805 _8674_/Q VGND VGND VPWR VPWR hold805/X sky130_fd_sc_hd__dlygate4sd3_1
Xhold816 _8643_/Q VGND VGND VPWR VPWR hold816/X sky130_fd_sc_hd__dlygate4sd3_1
Xhold827 _7966_/Q VGND VGND VPWR VPWR hold827/X sky130_fd_sc_hd__dlygate4sd3_1
Xinput65 wdata[66] VGND VGND VPWR VPWR _4882_/A sky130_fd_sc_hd__clkdlybuf4s25_1
Xinput76 wdata[76] VGND VGND VPWR VPWR _4924_/A sky130_fd_sc_hd__clkdlybuf4s25_1
XFILLER_131_706 VGND VGND VPWR VPWR sky130_fd_sc_hd__decap_3
XTAP_TAPCELL_ROW_77_1366 VGND VPWR sky130_fd_sc_hd__tapvpwrvgnd_1
XTAP_TAPCELL_ROW_77_1377 VGND VPWR sky130_fd_sc_hd__tapvpwrvgnd_1
Xhold838 _7964_/Q VGND VGND VPWR VPWR hold838/X sky130_fd_sc_hd__dlygate4sd3_1
Xhold849 _7963_/Q VGND VGND VPWR VPWR hold849/X sky130_fd_sc_hd__dlygate4sd3_1
X_6251_ _6251_/A VGND VGND VPWR VPWR _8185_/D sky130_fd_sc_hd__buf_6
XFILLER_69_311 VGND VGND VPWR VPWR sky130_fd_sc_hd__decap_3
XFILLER_97_620 VGND VGND VPWR VPWR sky130_fd_sc_hd__fill_2
Xclkbuf_leaf_30_CLK clkbuf_5_9__f_CLK/X VGND VGND VPWR VPWR _8684_/CLK sky130_fd_sc_hd__clkbuf_8
X_6182_ _5023_/X _8153_/Q _6184_/S VGND VGND VPWR VPWR _6183_/A sky130_fd_sc_hd__mux2_4
X_5202_ _5202_/A VGND VGND VPWR VPWR _7656_/D sky130_fd_sc_hd__buf_1
XFILLER_123_290 VGND VGND VPWR VPWR sky130_fd_sc_hd__decap_3
XFILLER_124_791 VGND VGND VPWR VPWR sky130_fd_sc_hd__decap_3
XFILLER_130_227 VGND VGND VPWR VPWR sky130_fd_sc_hd__decap_3
XFILLER_96_130 VGND VGND VPWR VPWR sky130_fd_sc_hd__fill_1
XTAP_TAPCELL_ROW_90_1555 VGND VPWR sky130_fd_sc_hd__tapvpwrvgnd_1
X_5133_ _4887_/X _7625_/Q _5137_/S VGND VGND VPWR VPWR _5134_/A sky130_fd_sc_hd__mux2_2
XFILLER_96_141 VGND VGND VPWR VPWR sky130_fd_sc_hd__decap_3
Xload_slew752 fanout751/X VGND VGND VPWR VPWR fanout749/A sky130_fd_sc_hd__clkbuf_4
XFILLER_123_29 VGND VGND VPWR VPWR sky130_fd_sc_hd__decap_3
XFILLER_38_731 VGND VGND VPWR VPWR sky130_fd_sc_hd__decap_3
X_5064_ _4749_/X hold981/X _5074_/S VGND VGND VPWR VPWR _5065_/A sky130_fd_sc_hd__mux2_2
XFILLER_38_753 VGND VGND VPWR VPWR sky130_fd_sc_hd__decap_3
XFILLER_65_550 VGND VGND VPWR VPWR sky130_fd_sc_hd__fill_1
XFILLER_72_509 VGND VGND VPWR VPWR sky130_fd_sc_hd__fill_2
X_4015_ _3795_/X _4006_/X _4009_/X _4014_/X VGND VGND VPWR VPWR _4015_/X sky130_fd_sc_hd__o31a_2
XFILLER_65_561 VGND VGND VPWR VPWR sky130_fd_sc_hd__decap_3
XFILLER_65_594 VGND VGND VPWR VPWR sky130_fd_sc_hd__decap_3
XFILLER_16_27 VGND VGND VPWR VPWR sky130_fd_sc_hd__fill_1
XFILLER_16_38 VGND VGND VPWR VPWR sky130_fd_sc_hd__decap_3
XFILLER_25_447 VGND VGND VPWR VPWR sky130_fd_sc_hd__fill_1
XFILLER_80_553 VGND VGND VPWR VPWR sky130_fd_sc_hd__fill_1
XFILLER_40_417 VGND VGND VPWR VPWR sky130_fd_sc_hd__decap_3
XFILLER_80_575 VGND VGND VPWR VPWR sky130_fd_sc_hd__decap_3
X_8754_ _8754_/CLK _8754_/D load_slew691/X VGND VGND VPWR VPWR _8754_/Q sky130_fd_sc_hd__dfrtp_2
Xclkbuf_leaf_97_CLK clkbuf_leaf_99_CLK/A VGND VGND VPWR VPWR _8790_/CLK sky130_fd_sc_hd__clkbuf_8
X_5966_ _5961_/X _5962_/Y _5963_/X _5964_/Y _5965_/Y VGND VGND VPWR VPWR _5966_/X
+ sky130_fd_sc_hd__o2111a_2
XTAP_TAPCELL_ROW_23_615 VGND VPWR sky130_fd_sc_hd__tapvpwrvgnd_1
X_8685_ _8685_/CLK _8685_/D wire574/X VGND VGND VPWR VPWR _8685_/Q sky130_fd_sc_hd__dfrtp_2
X_7705_ _8768_/CLK _7705_/D fanout567/X VGND VGND VPWR VPWR _7705_/Q sky130_fd_sc_hd__dfrtp_2
X_5897_ _5906_/A1 _5906_/A2 _4731_/X _5906_/B1 hold770/X VGND VGND VPWR VPWR _7993_/D
+ sky130_fd_sc_hd__a32o_2
X_4917_ _4917_/A VGND VGND VPWR VPWR _4917_/X sky130_fd_sc_hd__buf_1
XFILLER_20_141 VGND VGND VPWR VPWR sky130_fd_sc_hd__decap_3
XFILLER_21_664 VGND VGND VPWR VPWR sky130_fd_sc_hd__decap_3
X_7636_ _8780_/CLK _7636_/D load_slew722/X VGND VGND VPWR VPWR _7636_/Q sky130_fd_sc_hd__dfrtp_2
X_4848_ _4848_/A _4852_/B VGND VGND VPWR VPWR _4849_/A sky130_fd_sc_hd__and2_2
XFILLER_32_59 VGND VGND VPWR VPWR sky130_fd_sc_hd__decap_3
XFILLER_119_574 VGND VGND VPWR VPWR sky130_fd_sc_hd__decap_3
X_7567_ _8387_/CLK _7567_/D load_slew655/X VGND VGND VPWR VPWR _7567_/Q sky130_fd_sc_hd__dfrtp_2
X_4779_ _4779_/A VGND VGND VPWR VPWR _7518_/D sky130_fd_sc_hd__buf_1
XFILLER_134_522 VGND VGND VPWR VPWR sky130_fd_sc_hd__decap_3
XFILLER_134_533 VGND VGND VPWR VPWR sky130_fd_sc_hd__decap_3
X_7498_ _7498_/A VGND VGND VPWR VPWR _8804_/D sky130_fd_sc_hd__buf_1
X_6518_ _5007_/X _8311_/Q _6528_/S VGND VGND VPWR VPWR _6519_/A sky130_fd_sc_hd__mux2_2
XFILLER_106_246 VGND VGND VPWR VPWR sky130_fd_sc_hd__decap_3
XFILLER_134_566 VGND VGND VPWR VPWR sky130_fd_sc_hd__decap_3
X_6449_ _4871_/X _8279_/Q _6461_/S VGND VGND VPWR VPWR _6450_/A sky130_fd_sc_hd__mux2_2
Xclkbuf_leaf_21_CLK clkbuf_5_9__f_CLK/X VGND VGND VPWR VPWR _8763_/CLK sky130_fd_sc_hd__clkbuf_8
XFILLER_121_238 VGND VGND VPWR VPWR sky130_fd_sc_hd__fill_1
X_8119_ _8769_/CLK _8119_/D load_slew550/X VGND VGND VPWR VPWR _8119_/Q sky130_fd_sc_hd__dfrtp_2
XFILLER_0_557 VGND VGND VPWR VPWR sky130_fd_sc_hd__decap_3
XFILLER_130_772 VGND VGND VPWR VPWR sky130_fd_sc_hd__decap_3
XFILLER_88_686 VGND VGND VPWR VPWR sky130_fd_sc_hd__fill_2
XFILLER_48_539 VGND VGND VPWR VPWR sky130_fd_sc_hd__decap_3
XFILLER_87_196 VGND VGND VPWR VPWR sky130_fd_sc_hd__fill_1
XFILLER_88_697 VGND VGND VPWR VPWR sky130_fd_sc_hd__decap_3
XFILLER_56_550 VGND VGND VPWR VPWR sky130_fd_sc_hd__decap_3
XTAP_TAPCELL_ROW_3_340 VGND VPWR sky130_fd_sc_hd__tapvpwrvgnd_1
XFILLER_113_51 VGND VGND VPWR VPWR sky130_fd_sc_hd__decap_3
XFILLER_16_414 VGND VGND VPWR VPWR sky130_fd_sc_hd__decap_3
XFILLER_29_797 VGND VGND VPWR VPWR sky130_fd_sc_hd__decap_3
XFILLER_44_701 VGND VGND VPWR VPWR sky130_fd_sc_hd__fill_2
XFILLER_113_95 VGND VGND VPWR VPWR sky130_fd_sc_hd__fill_1
XFILLER_71_553 VGND VGND VPWR VPWR sky130_fd_sc_hd__decap_3
XFILLER_71_564 VGND VGND VPWR VPWR sky130_fd_sc_hd__decap_3
XFILLER_73_66 VGND VGND VPWR VPWR sky130_fd_sc_hd__decap_3
Xclkbuf_leaf_88_CLK clkbuf_leaf_88_CLK/A VGND VGND VPWR VPWR _8274_/CLK sky130_fd_sc_hd__clkbuf_8
XFILLER_12_631 VGND VGND VPWR VPWR sky130_fd_sc_hd__decap_3
XFILLER_24_480 VGND VGND VPWR VPWR sky130_fd_sc_hd__decap_3
XFILLER_11_141 VGND VGND VPWR VPWR sky130_fd_sc_hd__decap_3
XFILLER_8_613 VGND VGND VPWR VPWR sky130_fd_sc_hd__decap_3
XTAP_TAPCELL_ROW_61_1145 VGND VPWR sky130_fd_sc_hd__tapvpwrvgnd_1
XFILLER_12_686 VGND VGND VPWR VPWR sky130_fd_sc_hd__decap_3
XFILLER_8_657 VGND VGND VPWR VPWR sky130_fd_sc_hd__decap_3
XTAP_TAPCELL_ROW_50_990 VGND VPWR sky130_fd_sc_hd__tapvpwrvgnd_1
XTAP_TAPCELL_ROW_117_1934 VGND VPWR sky130_fd_sc_hd__tapvpwrvgnd_1
XFILLER_98_41 VGND VGND VPWR VPWR sky130_fd_sc_hd__decap_3
XFILLER_125_588 VGND VGND VPWR VPWR sky130_fd_sc_hd__decap_3
XFILLER_98_85 VGND VGND VPWR VPWR sky130_fd_sc_hd__fill_2
XFILLER_112_238 VGND VGND VPWR VPWR sky130_fd_sc_hd__decap_3
Xclkbuf_leaf_12_CLK clkbuf_5_6__f_CLK/X VGND VGND VPWR VPWR _8646_/CLK sky130_fd_sc_hd__clkbuf_8
XFILLER_105_290 VGND VGND VPWR VPWR sky130_fd_sc_hd__decap_3
XFILLER_21_6 VGND VGND VPWR VPWR sky130_fd_sc_hd__decap_3
XFILLER_120_282 VGND VGND VPWR VPWR sky130_fd_sc_hd__decap_3
XFILLER_78_185 VGND VGND VPWR VPWR sky130_fd_sc_hd__decap_3
XFILLER_94_645 VGND VGND VPWR VPWR sky130_fd_sc_hd__decap_3
XTAP_TAPCELL_ROW_72_1296 VGND VPWR sky130_fd_sc_hd__tapvpwrvgnd_1
XFILLER_54_509 VGND VGND VPWR VPWR sky130_fd_sc_hd__fill_2
XFILLER_94_678 VGND VGND VPWR VPWR sky130_fd_sc_hd__decap_3
XFILLER_19_274 VGND VGND VPWR VPWR sky130_fd_sc_hd__decap_3
XFILLER_34_200 VGND VGND VPWR VPWR sky130_fd_sc_hd__decap_3
XFILLER_47_561 VGND VGND VPWR VPWR sky130_fd_sc_hd__decap_3
XFILLER_47_583 VGND VGND VPWR VPWR sky130_fd_sc_hd__fill_2
XFILLER_34_222 VGND VGND VPWR VPWR sky130_fd_sc_hd__fill_1
XFILLER_35_756 VGND VGND VPWR VPWR sky130_fd_sc_hd__decap_3
XFILLER_62_542 VGND VGND VPWR VPWR sky130_fd_sc_hd__fill_1
XFILLER_22_417 VGND VGND VPWR VPWR sky130_fd_sc_hd__decap_3
Xclkbuf_leaf_79_CLK clkload10/A VGND VGND VPWR VPWR _8778_/CLK sky130_fd_sc_hd__clkbuf_8
X_5820_ _7948_/Q _4883_/A _5826_/S VGND VGND VPWR VPWR _5821_/A sky130_fd_sc_hd__mux2_2
XFILLER_34_288 VGND VGND VPWR VPWR sky130_fd_sc_hd__decap_3
X_5751_ _7915_/Q _4745_/A _5763_/S VGND VGND VPWR VPWR _5752_/A sky130_fd_sc_hd__mux2_2
X_8470_ _8470_/CLK _8470_/D load_slew591/X VGND VGND VPWR VPWR _8470_/Q sky130_fd_sc_hd__dfrtp_2
X_4702_ _4702_/A _4726_/B VGND VGND VPWR VPWR _4703_/A sky130_fd_sc_hd__and2_2
XFILLER_8_50 VGND VGND VPWR VPWR sky130_fd_sc_hd__decap_3
X_7421_ _7421_/A VGND VGND VPWR VPWR _8767_/D sky130_fd_sc_hd__buf_1
X_5682_ _7882_/Q _4945_/A _5700_/S VGND VGND VPWR VPWR _5683_/A sky130_fd_sc_hd__mux2_2
XFILLER_8_83 VGND VGND VPWR VPWR sky130_fd_sc_hd__fill_1
X_4633_ _4633_/A _4633_/B VGND VGND VPWR VPWR _4633_/X sky130_fd_sc_hd__or2_2
XFILLER_118_18 VGND VGND VPWR VPWR sky130_fd_sc_hd__decap_3
X_7352_ _7352_/A VGND VGND VPWR VPWR _8734_/D sky130_fd_sc_hd__buf_1
X_4564_ _4564_/A1 _4562_/X _4563_/X VGND VGND VPWR VPWR _4564_/X sky130_fd_sc_hd__o21a_2
XFILLER_116_533 VGND VGND VPWR VPWR sky130_fd_sc_hd__fill_1
X_7283_ _7451_/S VGND VGND VPWR VPWR _7302_/S sky130_fd_sc_hd__clkbuf_2
X_6303_ _6303_/A VGND VGND VPWR VPWR _8210_/D sky130_fd_sc_hd__buf_6
XFILLER_131_503 VGND VGND VPWR VPWR sky130_fd_sc_hd__fill_1
XFILLER_131_514 VGND VGND VPWR VPWR sky130_fd_sc_hd__decap_3
X_6234_ _6234_/A VGND VGND VPWR VPWR _8177_/D sky130_fd_sc_hd__buf_6
X_4495_ _7702_/Q _4652_/A2 _4648_/B1 _7621_/Q _3819_/X VGND VGND VPWR VPWR _4495_/X
+ sky130_fd_sc_hd__o221a_2
XFILLER_131_547 VGND VGND VPWR VPWR sky130_fd_sc_hd__decap_3
XFILLER_112_750 VGND VGND VPWR VPWR sky130_fd_sc_hd__decap_3
X_6165_ _6312_/S VGND VGND VPWR VPWR _6184_/S sky130_fd_sc_hd__buf_6
XFILLER_57_314 VGND VGND VPWR VPWR sky130_fd_sc_hd__decap_3
XFILLER_69_174 VGND VGND VPWR VPWR sky130_fd_sc_hd__fill_2
XFILLER_85_612 VGND VGND VPWR VPWR sky130_fd_sc_hd__decap_3
Xload_slew582 fanout581/X VGND VGND VPWR VPWR load_slew582/X sky130_fd_sc_hd__buf_4
Xload_slew560 fanout559/X VGND VGND VPWR VPWR load_slew560/X sky130_fd_sc_hd__buf_2
X_6096_ _6096_/A VGND VGND VPWR VPWR _8113_/D sky130_fd_sc_hd__buf_1
X_5116_ _4853_/X _7617_/Q _5116_/S VGND VGND VPWR VPWR _5117_/A sky130_fd_sc_hd__mux2_2
XFILLER_27_15 VGND VGND VPWR VPWR sky130_fd_sc_hd__decap_3
XFILLER_57_358 VGND VGND VPWR VPWR sky130_fd_sc_hd__decap_3
Xload_slew593 fanout592/X VGND VGND VPWR VPWR load_slew593/X sky130_fd_sc_hd__clkbuf_4
X_5047_ _4715_/X _7584_/Q _5053_/S VGND VGND VPWR VPWR _5048_/A sky130_fd_sc_hd__mux2_2
XFILLER_26_701 VGND VGND VPWR VPWR sky130_fd_sc_hd__decap_3
XFILLER_27_48 VGND VGND VPWR VPWR sky130_fd_sc_hd__decap_3
XFILLER_38_572 VGND VGND VPWR VPWR sky130_fd_sc_hd__decap_3
XFILLER_26_734 VGND VGND VPWR VPWR sky130_fd_sc_hd__decap_3
XFILLER_26_789 VGND VGND VPWR VPWR sky130_fd_sc_hd__decap_3
XFILLER_53_553 VGND VGND VPWR VPWR sky130_fd_sc_hd__fill_2
X_6998_ _4933_/X _8537_/Q _7000_/S VGND VGND VPWR VPWR _6999_/A sky130_fd_sc_hd__mux2_4
XFILLER_25_277 VGND VGND VPWR VPWR sky130_fd_sc_hd__decap_3
XFILLER_80_383 VGND VGND VPWR VPWR sky130_fd_sc_hd__fill_2
XTAP_TAPCELL_ROW_101_1702 VGND VPWR sky130_fd_sc_hd__tapvpwrvgnd_1
XTAP_TAPCELL_ROW_101_1713 VGND VPWR sky130_fd_sc_hd__tapvpwrvgnd_1
XTAP_TAPCELL_ROW_36_795 VGND VPWR sky130_fd_sc_hd__tapvpwrvgnd_1
X_8737_ _8737_/CLK _8737_/D fanout510/X VGND VGND VPWR VPWR _8737_/Q sky130_fd_sc_hd__dfrtp_2
X_5949_ _5958_/A1 _5947_/X _4899_/X _5948_/X hold840/X VGND VGND VPWR VPWR _8033_/D
+ sky130_fd_sc_hd__a32o_2
XFILLER_40_247 VGND VGND VPWR VPWR sky130_fd_sc_hd__fill_1
X_8668_ _8668_/CLK _8668_/D load_slew636/X VGND VGND VPWR VPWR _8668_/Q sky130_fd_sc_hd__dfrtp_2
XFILLER_21_483 VGND VGND VPWR VPWR sky130_fd_sc_hd__decap_3
XFILLER_5_605 VGND VGND VPWR VPWR sky130_fd_sc_hd__decap_3
X_8599_ _8680_/CLK _8599_/D wire693/X VGND VGND VPWR VPWR _8599_/Q sky130_fd_sc_hd__dfrtp_2
X_7619_ _8689_/CLK _7619_/D load_slew558/X VGND VGND VPWR VPWR _7619_/Q sky130_fd_sc_hd__dfrtp_2
XFILLER_119_360 VGND VGND VPWR VPWR sky130_fd_sc_hd__decap_3
XFILLER_5_638 VGND VGND VPWR VPWR sky130_fd_sc_hd__decap_3
XFILLER_104_3 VGND VGND VPWR VPWR sky130_fd_sc_hd__fill_1
XFILLER_107_533 VGND VGND VPWR VPWR sky130_fd_sc_hd__decap_3
XFILLER_134_341 VGND VGND VPWR VPWR sky130_fd_sc_hd__decap_3
XFILLER_4_126 VGND VGND VPWR VPWR sky130_fd_sc_hd__decap_3
XTAP_TAPCELL_ROW_130_2109 VGND VPWR sky130_fd_sc_hd__tapvpwrvgnd_1
XFILLER_134_374 VGND VGND VPWR VPWR sky130_fd_sc_hd__decap_3
XFILLER_1_800 VGND VGND VPWR VPWR sky130_fd_sc_hd__decap_3
XTAP_TAPCELL_ROW_8_410 VGND VPWR sky130_fd_sc_hd__tapvpwrvgnd_1
XFILLER_122_525 VGND VGND VPWR VPWR sky130_fd_sc_hd__decap_3
XFILLER_122_536 VGND VGND VPWR VPWR sky130_fd_sc_hd__decap_3
XTAP_TAPCELL_ROW_112_1864 VGND VPWR sky130_fd_sc_hd__tapvpwrvgnd_1
XFILLER_103_772 VGND VGND VPWR VPWR sky130_fd_sc_hd__fill_1
XFILLER_75_111 VGND VGND VPWR VPWR sky130_fd_sc_hd__fill_1
XFILLER_124_50 VGND VGND VPWR VPWR sky130_fd_sc_hd__fill_1
XFILLER_124_72 VGND VGND VPWR VPWR sky130_fd_sc_hd__decap_3
XFILLER_84_21 VGND VGND VPWR VPWR sky130_fd_sc_hd__fill_1
XFILLER_84_32 VGND VGND VPWR VPWR sky130_fd_sc_hd__decap_3
XFILLER_124_94 VGND VGND VPWR VPWR sky130_fd_sc_hd__fill_1
XFILLER_17_701 VGND VGND VPWR VPWR sky130_fd_sc_hd__decap_3
XFILLER_16_211 VGND VGND VPWR VPWR sky130_fd_sc_hd__decap_3
XFILLER_44_531 VGND VGND VPWR VPWR sky130_fd_sc_hd__fill_1
XFILLER_44_542 VGND VGND VPWR VPWR sky130_fd_sc_hd__fill_1
XFILLER_84_98 VGND VGND VPWR VPWR sky130_fd_sc_hd__decap_3
XFILLER_90_136 VGND VGND VPWR VPWR sky130_fd_sc_hd__decap_3
Xclkbuf_leaf_1_CLK clkbuf_leaf_1_CLK/A VGND VGND VPWR VPWR _8730_/CLK sky130_fd_sc_hd__clkbuf_8
XFILLER_129_102 VGND VGND VPWR VPWR sky130_fd_sc_hd__decap_3
XFILLER_129_113 VGND VGND VPWR VPWR sky130_fd_sc_hd__decap_3
XFILLER_12_472 VGND VGND VPWR VPWR sky130_fd_sc_hd__decap_3
XFILLER_8_410 VGND VGND VPWR VPWR sky130_fd_sc_hd__decap_3
XFILLER_8_421 VGND VGND VPWR VPWR sky130_fd_sc_hd__fill_2
XTAP_TAPCELL_ROW_14_489 VGND VPWR sky130_fd_sc_hd__tapvpwrvgnd_1
XFILLER_117_308 VGND VGND VPWR VPWR sky130_fd_sc_hd__decap_3
XFILLER_129_146 VGND VGND VPWR VPWR sky130_fd_sc_hd__decap_3
XFILLER_8_443 VGND VGND VPWR VPWR sky130_fd_sc_hd__fill_2
XFILLER_8_454 VGND VGND VPWR VPWR sky130_fd_sc_hd__decap_3
XFILLER_113_503 VGND VGND VPWR VPWR sky130_fd_sc_hd__fill_1
XFILLER_4_660 VGND VGND VPWR VPWR sky130_fd_sc_hd__decap_3
XFILLER_99_737 VGND VGND VPWR VPWR sky130_fd_sc_hd__decap_3
XTAP_TAPCELL_ROW_74_1325 VGND VPWR sky130_fd_sc_hd__tapvpwrvgnd_1
XFILLER_113_547 VGND VGND VPWR VPWR sky130_fd_sc_hd__fill_1
XFILLER_4_693 VGND VGND VPWR VPWR sky130_fd_sc_hd__decap_3
XFILLER_98_236 VGND VGND VPWR VPWR sky130_fd_sc_hd__decap_3
X_4280_ _4681_/A _4278_/X _4279_/X VGND VGND VPWR VPWR _4280_/X sky130_fd_sc_hd__o21a_2
XFILLER_86_409 VGND VGND VPWR VPWR sky130_fd_sc_hd__decap_3
XFILLER_66_111 VGND VGND VPWR VPWR sky130_fd_sc_hd__decap_3
XFILLER_39_347 VGND VGND VPWR VPWR sky130_fd_sc_hd__decap_3
XFILLER_67_645 VGND VGND VPWR VPWR sky130_fd_sc_hd__decap_3
XFILLER_67_689 VGND VGND VPWR VPWR sky130_fd_sc_hd__decap_3
X_7970_ _8627_/CLK _7970_/D load_slew673/X VGND VGND VPWR VPWR _7970_/Q sky130_fd_sc_hd__dfrtp_2
XFILLER_47_380 VGND VGND VPWR VPWR sky130_fd_sc_hd__fill_2
XFILLER_47_391 VGND VGND VPWR VPWR sky130_fd_sc_hd__fill_1
XFILLER_54_339 VGND VGND VPWR VPWR sky130_fd_sc_hd__decap_3
X_6921_ _4777_/X _8500_/Q _6937_/S VGND VGND VPWR VPWR _6922_/A sky130_fd_sc_hd__mux2_4
XFILLER_120_19 VGND VGND VPWR VPWR sky130_fd_sc_hd__decap_3
XFILLER_81_169 VGND VGND VPWR VPWR sky130_fd_sc_hd__decap_3
XTAP_TAPCELL_ROW_85_1476 VGND VPWR sky130_fd_sc_hd__tapvpwrvgnd_1
X_6852_ _6852_/A VGND VGND VPWR VPWR _8467_/D sky130_fd_sc_hd__buf_6
XFILLER_23_726 VGND VGND VPWR VPWR sky130_fd_sc_hd__fill_2
XFILLER_62_361 VGND VGND VPWR VPWR sky130_fd_sc_hd__decap_3
XFILLER_90_670 VGND VGND VPWR VPWR sky130_fd_sc_hd__decap_3
XTAP_TAPCELL_ROW_85_1487 VGND VPWR sky130_fd_sc_hd__tapvpwrvgnd_1
X_5803_ _7940_/Q _4849_/A _5805_/S VGND VGND VPWR VPWR _5804_/A sky130_fd_sc_hd__mux2_2
XTAP_TAPCELL_ROW_33_754 VGND VPWR sky130_fd_sc_hd__tapvpwrvgnd_1
X_3995_ _7981_/Q _3995_/B VGND VGND VPWR VPWR _3995_/X sky130_fd_sc_hd__or2_2
X_8522_ _8684_/CLK _8522_/D load_slew560/X VGND VGND VPWR VPWR _8522_/Q sky130_fd_sc_hd__dfrtp_2
X_6783_ _6783_/A VGND VGND VPWR VPWR _8435_/D sky130_fd_sc_hd__buf_2
XFILLER_13_39 VGND VGND VPWR VPWR sky130_fd_sc_hd__decap_3
XFILLER_50_589 VGND VGND VPWR VPWR sky130_fd_sc_hd__decap_3
X_5734_ _7907_/Q _4711_/A _5742_/S VGND VGND VPWR VPWR _5735_/A sky130_fd_sc_hd__mux2_2
XFILLER_129_39 VGND VGND VPWR VPWR sky130_fd_sc_hd__decap_3
X_8453_ _8693_/CLK _8453_/D fanout743/X VGND VGND VPWR VPWR _8453_/Q sky130_fd_sc_hd__dfrtp_2
X_5665_ _7875_/Q _4917_/A _5675_/S VGND VGND VPWR VPWR _5666_/A sky130_fd_sc_hd__mux2_2
XFILLER_135_116 VGND VGND VPWR VPWR sky130_fd_sc_hd__decap_3
X_8384_ _8789_/CLK _8384_/D fanout670/X VGND VGND VPWR VPWR _8384_/Q sky130_fd_sc_hd__dfrtp_2
X_7404_ _7404_/A VGND VGND VPWR VPWR _8759_/D sky130_fd_sc_hd__buf_1
X_4616_ _8776_/Q _7551_/Q _7632_/Q _7713_/Q _4559_/S _4633_/A VGND VGND VPWR VPWR
+ _4616_/X sky130_fd_sc_hd__mux4_2
XFILLER_129_691 VGND VGND VPWR VPWR sky130_fd_sc_hd__decap_3
XPHY_EDGE_ROW_111_Right_111 VGND VGND VPWR VPWR sky130_fd_sc_hd__decap_3
X_7335_ _7335_/A VGND VGND VPWR VPWR _8726_/D sky130_fd_sc_hd__buf_1
X_5596_ _7842_/Q _4777_/A _5612_/S VGND VGND VPWR VPWR _5597_/A sky130_fd_sc_hd__mux2_2
XFILLER_116_363 VGND VGND VPWR VPWR sky130_fd_sc_hd__fill_1
XFILLER_2_619 VGND VGND VPWR VPWR sky130_fd_sc_hd__decap_3
X_4547_ _7789_/Q _7870_/Q _4554_/S VGND VGND VPWR VPWR _4547_/X sky130_fd_sc_hd__mux2_2
XFILLER_116_385 VGND VGND VPWR VPWR sky130_fd_sc_hd__decap_3
XFILLER_131_311 VGND VGND VPWR VPWR sky130_fd_sc_hd__decap_3
XFILLER_89_225 VGND VGND VPWR VPWR sky130_fd_sc_hd__decap_3
Xmax_cap184 _5921_/X VGND VGND VPWR VPWR _5932_/A2 sky130_fd_sc_hd__buf_2
Xmax_cap173 _7243_/X VGND VGND VPWR VPWR _7255_/A3 sky130_fd_sc_hd__buf_2
X_7266_ _7254_/X _4891_/X _7266_/A3 _7266_/B1 hold800/X VGND VGND VPWR VPWR _8689_/D
+ sky130_fd_sc_hd__a32o_2
X_4478_ _4462_/A _4474_/X _4477_/X _4557_/A1 VGND VGND VPWR VPWR _4478_/X sky130_fd_sc_hd__a211o_2
XFILLER_131_355 VGND VGND VPWR VPWR sky130_fd_sc_hd__decap_3
X_7197_ _7189_/X _5007_/X _7201_/A3 _7192_/X hold785/X VGND VGND VPWR VPWR _8635_/D
+ sky130_fd_sc_hd__a32o_2
X_6217_ _6217_/A VGND VGND VPWR VPWR _8169_/D sky130_fd_sc_hd__buf_6
XFILLER_131_399 VGND VGND VPWR VPWR sky130_fd_sc_hd__fill_1
X_6148_ _6148_/A VGND VGND VPWR VPWR _8136_/D sky130_fd_sc_hd__buf_6
XFILLER_100_731 VGND VGND VPWR VPWR sky130_fd_sc_hd__decap_3
XFILLER_57_177 VGND VGND VPWR VPWR sky130_fd_sc_hd__decap_3
XFILLER_58_678 VGND VGND VPWR VPWR sky130_fd_sc_hd__decap_3
XTAP_TAPCELL_ROW_127_2071 VGND VPWR sky130_fd_sc_hd__tapvpwrvgnd_1
X_6079_ _8105_/Q _4818_/A _6095_/S VGND VGND VPWR VPWR _6080_/A sky130_fd_sc_hd__mux2_2
XFILLER_72_125 VGND VGND VPWR VPWR sky130_fd_sc_hd__decap_3
XFILLER_85_497 VGND VGND VPWR VPWR sky130_fd_sc_hd__decap_3
Xclkbuf_5_29__f_CLK clkbuf_4_14_0_CLK/X VGND VGND VPWR VPWR clkload10/A sky130_fd_sc_hd__clkbuf_16
XFILLER_60_309 VGND VGND VPWR VPWR sky130_fd_sc_hd__decap_3
XFILLER_72_147 VGND VGND VPWR VPWR sky130_fd_sc_hd__decap_3
XFILLER_53_361 VGND VGND VPWR VPWR sky130_fd_sc_hd__decap_3
XFILLER_13_236 VGND VGND VPWR VPWR sky130_fd_sc_hd__decap_3
XFILLER_80_191 VGND VGND VPWR VPWR sky130_fd_sc_hd__fill_2
XFILLER_127_606 VGND VGND VPWR VPWR sky130_fd_sc_hd__decap_3
XFILLER_127_617 VGND VGND VPWR VPWR sky130_fd_sc_hd__decap_3
XFILLER_127_639 VGND VGND VPWR VPWR sky130_fd_sc_hd__decap_3
XTAP_TAPCELL_ROW_11_448 VGND VPWR sky130_fd_sc_hd__tapvpwrvgnd_1
XFILLER_126_127 VGND VGND VPWR VPWR sky130_fd_sc_hd__decap_3
XFILLER_107_374 VGND VGND VPWR VPWR sky130_fd_sc_hd__decap_3
XFILLER_134_171 VGND VGND VPWR VPWR sky130_fd_sc_hd__decap_3
XFILLER_122_344 VGND VGND VPWR VPWR sky130_fd_sc_hd__fill_1
XFILLER_1_641 VGND VGND VPWR VPWR sky130_fd_sc_hd__decap_3
XTAP_TAPCELL_ROW_56_1077 VGND VPWR sky130_fd_sc_hd__tapvpwrvgnd_1
XFILLER_110_517 VGND VGND VPWR VPWR sky130_fd_sc_hd__fill_2
XFILLER_110_539 VGND VGND VPWR VPWR sky130_fd_sc_hd__decap_3
XFILLER_135_60 VGND VGND VPWR VPWR sky130_fd_sc_hd__decap_3
XFILLER_1_685 VGND VGND VPWR VPWR sky130_fd_sc_hd__decap_3
XFILLER_89_781 VGND VGND VPWR VPWR sky130_fd_sc_hd__decap_3
XFILLER_49_667 VGND VGND VPWR VPWR sky130_fd_sc_hd__decap_3
XFILLER_95_75 VGND VGND VPWR VPWR sky130_fd_sc_hd__decap_3
XFILLER_36_306 VGND VGND VPWR VPWR sky130_fd_sc_hd__fill_2
XFILLER_64_604 VGND VGND VPWR VPWR sky130_fd_sc_hd__decap_3
XFILLER_28_91 VGND VGND VPWR VPWR sky130_fd_sc_hd__decap_3
XFILLER_48_188 VGND VGND VPWR VPWR sky130_fd_sc_hd__decap_3
XFILLER_91_434 VGND VGND VPWR VPWR sky130_fd_sc_hd__decap_3
XFILLER_17_542 VGND VGND VPWR VPWR sky130_fd_sc_hd__decap_3
XFILLER_44_350 VGND VGND VPWR VPWR sky130_fd_sc_hd__decap_3
XFILLER_63_169 VGND VGND VPWR VPWR sky130_fd_sc_hd__fill_2
XFILLER_91_478 VGND VGND VPWR VPWR sky130_fd_sc_hd__decap_3
XTAP_TAPCELL_ROW_19_559 VGND VPWR sky130_fd_sc_hd__tapvpwrvgnd_1
XFILLER_71_191 VGND VGND VPWR VPWR sky130_fd_sc_hd__decap_3
XTAP_TAPCELL_ROW_30_713 VGND VPWR sky130_fd_sc_hd__tapvpwrvgnd_1
X_3780_ _3875_/A _3773_/X _3777_/X _3779_/X _3894_/A1 VGND VGND VPWR VPWR _3780_/X
+ sky130_fd_sc_hd__a221o_2
XFILLER_9_741 VGND VGND VPWR VPWR sky130_fd_sc_hd__decap_3
XFILLER_118_617 VGND VGND VPWR VPWR sky130_fd_sc_hd__fill_2
XFILLER_8_240 VGND VGND VPWR VPWR sky130_fd_sc_hd__decap_3
XFILLER_8_262 VGND VGND VPWR VPWR sky130_fd_sc_hd__decap_3
XFILLER_9_774 VGND VGND VPWR VPWR sky130_fd_sc_hd__decap_3
XFILLER_9_785 VGND VGND VPWR VPWR sky130_fd_sc_hd__decap_3
X_5450_ _5450_/A VGND VGND VPWR VPWR _7773_/D sky130_fd_sc_hd__buf_1
XFILLER_133_609 VGND VGND VPWR VPWR sky130_fd_sc_hd__decap_3
X_4401_ _4398_/X _4399_/X _4400_/X _4605_/A1 VGND VGND VPWR VPWR _4401_/X sky130_fd_sc_hd__a22o_2
X_5381_ _5381_/A VGND VGND VPWR VPWR _7740_/D sky130_fd_sc_hd__buf_1
XFILLER_113_322 VGND VGND VPWR VPWR sky130_fd_sc_hd__decap_3
XFILLER_125_160 VGND VGND VPWR VPWR sky130_fd_sc_hd__decap_3
XFILLER_126_683 VGND VGND VPWR VPWR sky130_fd_sc_hd__decap_3
XFILLER_5_51 VGND VGND VPWR VPWR sky130_fd_sc_hd__decap_3
X_7120_ _4833_/X _8594_/Q _7130_/S VGND VGND VPWR VPWR _7121_/A sky130_fd_sc_hd__mux2_2
X_4332_ _4326_/X _4328_/X _4330_/X _4331_/X VGND VGND VPWR VPWR _4332_/X sky130_fd_sc_hd__a22o_2
XFILLER_5_84 VGND VGND VPWR VPWR sky130_fd_sc_hd__decap_3
XFILLER_87_729 VGND VGND VPWR VPWR sky130_fd_sc_hd__decap_3
X_7051_ _5036_/X _8561_/Q _7067_/S VGND VGND VPWR VPWR _7052_/A sky130_fd_sc_hd__mux2_2
X_4263_ _7763_/Q _7844_/Q _7925_/Q _8006_/Q _4260_/S _4261_/A VGND VGND VPWR VPWR
+ _4263_/X sky130_fd_sc_hd__mux4_2
XFILLER_101_528 VGND VGND VPWR VPWR sky130_fd_sc_hd__decap_3
XFILLER_113_388 VGND VGND VPWR VPWR sky130_fd_sc_hd__decap_3
X_6002_ _6002_/A VGND VGND VPWR VPWR _8068_/D sky130_fd_sc_hd__buf_1
X_4194_ _4198_/A _4194_/B VGND VGND VPWR VPWR _4194_/X sky130_fd_sc_hd__or2_2
XFILLER_39_166 VGND VGND VPWR VPWR sky130_fd_sc_hd__fill_2
XFILLER_55_615 VGND VGND VPWR VPWR sky130_fd_sc_hd__fill_1
XFILLER_95_773 VGND VGND VPWR VPWR sky130_fd_sc_hd__decap_3
XTAP_TAPCELL_ROW_87_1505 VGND VPWR sky130_fd_sc_hd__tapvpwrvgnd_1
XTAP_TAPCELL_ROW_87_1516 VGND VPWR sky130_fd_sc_hd__tapvpwrvgnd_1
XFILLER_131_18 VGND VGND VPWR VPWR sky130_fd_sc_hd__decap_3
XFILLER_27_328 VGND VGND VPWR VPWR sky130_fd_sc_hd__decap_3
XFILLER_54_114 VGND VGND VPWR VPWR sky130_fd_sc_hd__fill_1
XFILLER_55_648 VGND VGND VPWR VPWR sky130_fd_sc_hd__fill_2
XTAP_TAPCELL_ROW_38_824 VGND VPWR sky130_fd_sc_hd__tapvpwrvgnd_1
X_7953_ _8530_/CLK _7953_/D fanout739/X VGND VGND VPWR VPWR _7953_/Q sky130_fd_sc_hd__dfrtp_2
XFILLER_70_607 VGND VGND VPWR VPWR sky130_fd_sc_hd__decap_3
X_6904_ _4745_/X _8492_/Q _6916_/S VGND VGND VPWR VPWR _6905_/A sky130_fd_sc_hd__mux2_4
XFILLER_23_523 VGND VGND VPWR VPWR sky130_fd_sc_hd__decap_3
X_7884_ _8623_/CLK _7884_/D load_slew676/X VGND VGND VPWR VPWR _7884_/Q sky130_fd_sc_hd__dfrtp_2
XFILLER_24_27 VGND VGND VPWR VPWR sky130_fd_sc_hd__fill_1
XFILLER_24_38 VGND VGND VPWR VPWR sky130_fd_sc_hd__decap_3
XFILLER_62_180 VGND VGND VPWR VPWR sky130_fd_sc_hd__decap_3
X_6835_ _4945_/X _8459_/Q _6853_/S VGND VGND VPWR VPWR _6836_/A sky130_fd_sc_hd__mux2_4
XFILLER_10_206 VGND VGND VPWR VPWR sky130_fd_sc_hd__decap_3
XFILLER_11_729 VGND VGND VPWR VPWR sky130_fd_sc_hd__decap_3
XFILLER_23_567 VGND VGND VPWR VPWR sky130_fd_sc_hd__decap_3
XFILLER_50_353 VGND VGND VPWR VPWR sky130_fd_sc_hd__decap_3
X_3978_ _4617_/B1 _3977_/X _3848_/X VGND VGND VPWR VPWR _3978_/X sky130_fd_sc_hd__a21o_2
X_6766_ _6766_/A VGND VGND VPWR VPWR _8427_/D sky130_fd_sc_hd__buf_2
XFILLER_50_386 VGND VGND VPWR VPWR sky130_fd_sc_hd__decap_3
X_8505_ _8750_/CLK _8505_/D wire638/X VGND VGND VPWR VPWR _8505_/Q sky130_fd_sc_hd__dfrtp_2
X_5717_ _7899_/Q _5019_/A _5721_/S VGND VGND VPWR VPWR _5718_/A sky130_fd_sc_hd__mux2_2
XFILLER_109_617 VGND VGND VPWR VPWR sky130_fd_sc_hd__decap_3
X_6697_ _6697_/A VGND VGND VPWR VPWR _8394_/D sky130_fd_sc_hd__buf_2
XFILLER_108_138 VGND VGND VPWR VPWR sky130_fd_sc_hd__fill_2
XFILLER_40_37 VGND VGND VPWR VPWR sky130_fd_sc_hd__fill_1
XTAP_TAPCELL_ROW_98_1667 VGND VPWR sky130_fd_sc_hd__tapvpwrvgnd_1
X_8436_ _8679_/CLK _8436_/D fanout697/X VGND VGND VPWR VPWR _8436_/Q sky130_fd_sc_hd__dfrtp_2
X_5648_ _7867_/Q _4883_/A _5654_/S VGND VGND VPWR VPWR _5649_/A sky130_fd_sc_hd__mux2_2
X_8367_ _8694_/CLK _8367_/D load_slew720/X VGND VGND VPWR VPWR _8367_/Q sky130_fd_sc_hd__dfrtp_2
X_5579_ _7834_/Q _4745_/A _5591_/S VGND VGND VPWR VPWR _5580_/A sky130_fd_sc_hd__mux2_2
XFILLER_123_119 VGND VGND VPWR VPWR sky130_fd_sc_hd__fill_2
XFILLER_132_631 VGND VGND VPWR VPWR sky130_fd_sc_hd__decap_3
X_8298_ _8786_/CLK _8298_/D load_slew667/X VGND VGND VPWR VPWR _8298_/Q sky130_fd_sc_hd__dfrtp_2
X_7318_ _7318_/A VGND VGND VPWR VPWR _8718_/D sky130_fd_sc_hd__buf_1
XFILLER_104_355 VGND VGND VPWR VPWR sky130_fd_sc_hd__decap_3
X_7249_ _7253_/A1 _4833_/X _7255_/A3 _7255_/B1 hold791/X VGND VGND VPWR VPWR _8675_/D
+ sky130_fd_sc_hd__a32o_2
XFILLER_104_377 VGND VGND VPWR VPWR sky130_fd_sc_hd__fill_1
XFILLER_131_152 VGND VGND VPWR VPWR sky130_fd_sc_hd__decap_3
XFILLER_132_675 VGND VGND VPWR VPWR sky130_fd_sc_hd__decap_3
XFILLER_49_57 VGND VGND VPWR VPWR sky130_fd_sc_hd__fill_2
XTAP_TAPCELL_ROW_129_2100 VGND VPWR sky130_fd_sc_hd__tapvpwrvgnd_1
XFILLER_131_196 VGND VGND VPWR VPWR sky130_fd_sc_hd__decap_3
Xfanout753 fanout754/X VGND VGND VPWR VPWR fanout753/X sky130_fd_sc_hd__clkdlybuf4s25_1
XFILLER_46_604 VGND VGND VPWR VPWR sky130_fd_sc_hd__decap_3
XFILLER_65_23 VGND VGND VPWR VPWR sky130_fd_sc_hd__decap_3
XFILLER_92_209 VGND VGND VPWR VPWR sky130_fd_sc_hd__decap_3
XFILLER_46_637 VGND VGND VPWR VPWR sky130_fd_sc_hd__decap_3
XFILLER_46_648 VGND VGND VPWR VPWR sky130_fd_sc_hd__decap_3
XFILLER_73_434 VGND VGND VPWR VPWR sky130_fd_sc_hd__decap_3
XFILLER_65_78 VGND VGND VPWR VPWR sky130_fd_sc_hd__decap_3
XFILLER_65_89 VGND VGND VPWR VPWR sky130_fd_sc_hd__decap_3
XFILLER_54_681 VGND VGND VPWR VPWR sky130_fd_sc_hd__decap_3
XTAP_TAPCELL_ROW_107_1785 VGND VPWR sky130_fd_sc_hd__tapvpwrvgnd_1
XTAP_TAPCELL_ROW_16_518 VGND VPWR sky130_fd_sc_hd__tapvpwrvgnd_1
XFILLER_81_44 VGND VGND VPWR VPWR sky130_fd_sc_hd__decap_3
XTAP_TAPCELL_ROW_107_1796 VGND VPWR sky130_fd_sc_hd__tapvpwrvgnd_1
XFILLER_14_578 VGND VGND VPWR VPWR sky130_fd_sc_hd__decap_3
XFILLER_81_55 VGND VGND VPWR VPWR sky130_fd_sc_hd__fill_1
XFILLER_81_66 VGND VGND VPWR VPWR sky130_fd_sc_hd__fill_1
XFILLER_14_71 VGND VGND VPWR VPWR sky130_fd_sc_hd__decap_3
XTAP_TAPCELL_ROW_120_1974 VGND VPWR sky130_fd_sc_hd__tapvpwrvgnd_1
XFILLER_10_740 VGND VGND VPWR VPWR sky130_fd_sc_hd__decap_3
XFILLER_10_784 VGND VGND VPWR VPWR sky130_fd_sc_hd__decap_3
XFILLER_127_436 VGND VGND VPWR VPWR sky130_fd_sc_hd__decap_3
XFILLER_127_458 VGND VGND VPWR VPWR sky130_fd_sc_hd__decap_3
XFILLER_6_722 VGND VGND VPWR VPWR sky130_fd_sc_hd__decap_3
XTAP_TAPCELL_ROW_58_1106 VGND VPWR sky130_fd_sc_hd__tapvpwrvgnd_1
XFILLER_53_9 VGND VGND VPWR VPWR sky130_fd_sc_hd__fill_1
XFILLER_6_755 VGND VGND VPWR VPWR sky130_fd_sc_hd__fill_1
XFILLER_6_766 VGND VGND VPWR VPWR sky130_fd_sc_hd__decap_3
XFILLER_108_683 VGND VGND VPWR VPWR sky130_fd_sc_hd__decap_3
XFILLER_123_620 VGND VGND VPWR VPWR sky130_fd_sc_hd__decap_3
XFILLER_135_480 VGND VGND VPWR VPWR sky130_fd_sc_hd__decap_3
XFILLER_30_81 VGND VGND VPWR VPWR sky130_fd_sc_hd__decap_3
XFILLER_5_287 VGND VGND VPWR VPWR sky130_fd_sc_hd__decap_3
XFILLER_6_799 VGND VGND VPWR VPWR sky130_fd_sc_hd__decap_3
XFILLER_122_141 VGND VGND VPWR VPWR sky130_fd_sc_hd__decap_3
XFILLER_110_303 VGND VGND VPWR VPWR sky130_fd_sc_hd__fill_1
XFILLER_1_471 VGND VGND VPWR VPWR sky130_fd_sc_hd__fill_1
XFILLER_69_729 VGND VGND VPWR VPWR sky130_fd_sc_hd__decap_3
XFILLER_49_420 VGND VGND VPWR VPWR sky130_fd_sc_hd__decap_3
XFILLER_77_773 VGND VGND VPWR VPWR sky130_fd_sc_hd__decap_3
XFILLER_92_710 VGND VGND VPWR VPWR sky130_fd_sc_hd__decap_3
Xinput8 wdata[14] VGND VGND VPWR VPWR input8/X sky130_fd_sc_hd__clkdlybuf4s25_1
XFILLER_37_659 VGND VGND VPWR VPWR sky130_fd_sc_hd__decap_3
XFILLER_76_283 VGND VGND VPWR VPWR sky130_fd_sc_hd__decap_3
XFILLER_92_743 VGND VGND VPWR VPWR sky130_fd_sc_hd__decap_3
XFILLER_24_309 VGND VGND VPWR VPWR sky130_fd_sc_hd__fill_2
XFILLER_36_136 VGND VGND VPWR VPWR sky130_fd_sc_hd__decap_3
XTAP_TAPCELL_ROW_69_1257 VGND VPWR sky130_fd_sc_hd__tapvpwrvgnd_1
XFILLER_51_128 VGND VGND VPWR VPWR sky130_fd_sc_hd__decap_3
Xclkbuf_5_12__f_CLK clkbuf_4_6_0_CLK/X VGND VGND VPWR VPWR clkbuf_leaf_52_CLK/A sky130_fd_sc_hd__clkbuf_16
X_4950_ _4950_/A VGND VGND VPWR VPWR _7558_/D sky130_fd_sc_hd__buf_1
XTAP_TAPCELL_ROW_82_1435 VGND VPWR sky130_fd_sc_hd__tapvpwrvgnd_1
XTAP_TAPCELL_ROW_82_1446 VGND VPWR sky130_fd_sc_hd__tapvpwrvgnd_1
X_3901_ _3897_/X _3900_/X _4112_/S VGND VGND VPWR VPWR _3902_/A sky130_fd_sc_hd__mux2_2
X_4881_ _4881_/A VGND VGND VPWR VPWR _7542_/D sky130_fd_sc_hd__buf_1
XFILLER_32_353 VGND VGND VPWR VPWR sky130_fd_sc_hd__fill_2
X_3832_ _4639_/A1 _3829_/X _3831_/X _3840_/S VGND VGND VPWR VPWR _3832_/X sky130_fd_sc_hd__o211a_2
X_6620_ _6620_/A VGND VGND VPWR VPWR _8359_/D sky130_fd_sc_hd__buf_2
XTAP_TAPCELL_ROW_43_893 VGND VPWR sky130_fd_sc_hd__tapvpwrvgnd_1
X_6551_ _6656_/S VGND VGND VPWR VPWR _6570_/S sky130_fd_sc_hd__buf_6
X_3763_ _3763_/A VGND VGND VPWR VPWR _4388_/B sky130_fd_sc_hd__clkbuf_2
X_5502_ _5502_/A VGND VGND VPWR VPWR _7798_/D sky130_fd_sc_hd__buf_1
X_6482_ _4937_/X _8295_/Q _6482_/S VGND VGND VPWR VPWR _6483_/A sky130_fd_sc_hd__mux2_2
XFILLER_10_18 VGND VGND VPWR VPWR sky130_fd_sc_hd__decap_3
XFILLER_133_417 VGND VGND VPWR VPWR sky130_fd_sc_hd__decap_3
X_8221_ _8710_/CLK _8221_/D fanout665/X VGND VGND VPWR VPWR _8221_/Q sky130_fd_sc_hd__dfrtp_2
X_5433_ _5433_/A VGND VGND VPWR VPWR _7765_/D sky130_fd_sc_hd__buf_1
XFILLER_10_29 VGND VGND VPWR VPWR sky130_fd_sc_hd__decap_3
XFILLER_126_18 VGND VGND VPWR VPWR sky130_fd_sc_hd__decap_3
XFILLER_126_480 VGND VGND VPWR VPWR sky130_fd_sc_hd__decap_3
X_8152_ _8719_/CLK _8152_/D fanout583/X VGND VGND VPWR VPWR _8152_/Q sky130_fd_sc_hd__dfrtp_2
X_5364_ _5364_/A VGND VGND VPWR VPWR _7732_/D sky130_fd_sc_hd__buf_1
XFILLER_114_664 VGND VGND VPWR VPWR sky130_fd_sc_hd__decap_3
XFILLER_126_29 VGND VGND VPWR VPWR sky130_fd_sc_hd__decap_3
X_7103_ _4799_/X hold973/X _7109_/S VGND VGND VPWR VPWR _7104_/A sky130_fd_sc_hd__mux2_1
X_4315_ _8345_/Q _3799_/X _4424_/A2 _8264_/Q _4315_/C1 VGND VGND VPWR VPWR _4315_/X
+ sky130_fd_sc_hd__o221a_2
XFILLER_101_314 VGND VGND VPWR VPWR sky130_fd_sc_hd__decap_3
XFILLER_59_228 VGND VGND VPWR VPWR sky130_fd_sc_hd__decap_3
XFILLER_99_386 VGND VGND VPWR VPWR sky130_fd_sc_hd__decap_3
XTAP_TAPCELL_ROW_93_1597 VGND VPWR sky130_fd_sc_hd__tapvpwrvgnd_1
X_8083_ _8569_/CLK _8083_/D load_slew494/X VGND VGND VPWR VPWR _8083_/Q sky130_fd_sc_hd__dfrtp_2
X_5295_ _5295_/A VGND VGND VPWR VPWR _7700_/D sky130_fd_sc_hd__buf_1
XFILLER_19_27 VGND VGND VPWR VPWR sky130_fd_sc_hd__decap_3
XFILLER_59_239 VGND VGND VPWR VPWR sky130_fd_sc_hd__decap_3
X_7034_ _5003_/X hold966/X _7046_/S VGND VGND VPWR VPWR _7035_/A sky130_fd_sc_hd__mux2_1
X_4246_ _8663_/Q _4326_/B VGND VGND VPWR VPWR _4246_/X sky130_fd_sc_hd__or2_2
XFILLER_28_604 VGND VGND VPWR VPWR sky130_fd_sc_hd__decap_3
XFILLER_74_209 VGND VGND VPWR VPWR sky130_fd_sc_hd__fill_1
XFILLER_95_570 VGND VGND VPWR VPWR sky130_fd_sc_hd__decap_3
X_4177_ _4198_/A _4177_/B VGND VGND VPWR VPWR _4177_/X sky130_fd_sc_hd__or2_2
XFILLER_28_648 VGND VGND VPWR VPWR sky130_fd_sc_hd__fill_1
XFILLER_83_732 VGND VGND VPWR VPWR sky130_fd_sc_hd__fill_2
XFILLER_83_743 VGND VGND VPWR VPWR sky130_fd_sc_hd__decap_3
XFILLER_27_136 VGND VGND VPWR VPWR sky130_fd_sc_hd__decap_3
XFILLER_28_659 VGND VGND VPWR VPWR sky130_fd_sc_hd__decap_3
XFILLER_35_15 VGND VGND VPWR VPWR sky130_fd_sc_hd__decap_3
XFILLER_82_231 VGND VGND VPWR VPWR sky130_fd_sc_hd__fill_2
XTAP_TAPCELL_ROW_124_2030 VGND VPWR sky130_fd_sc_hd__tapvpwrvgnd_1
XFILLER_27_169 VGND VGND VPWR VPWR sky130_fd_sc_hd__decap_3
XFILLER_43_629 VGND VGND VPWR VPWR sky130_fd_sc_hd__fill_1
X_7936_ _8679_/CLK _7936_/D fanout698/X VGND VGND VPWR VPWR _7936_/Q sky130_fd_sc_hd__dfrtp_2
XFILLER_70_448 VGND VGND VPWR VPWR sky130_fd_sc_hd__decap_3
X_7867_ _8768_/CLK _7867_/D load_slew565/X VGND VGND VPWR VPWR _7867_/Q sky130_fd_sc_hd__dfrtp_2
XFILLER_51_662 VGND VGND VPWR VPWR sky130_fd_sc_hd__fill_2
X_6818_ _8452_/Q _4916_/A _6828_/S VGND VGND VPWR VPWR _6819_/A sky130_fd_sc_hd__mux2_2
X_7798_ _8780_/CLK _7798_/D fanout723/X VGND VGND VPWR VPWR _7798_/Q sky130_fd_sc_hd__dfrtp_2
XFILLER_51_69 VGND VGND VPWR VPWR sky130_fd_sc_hd__decap_3
XFILLER_7_508 VGND VGND VPWR VPWR sky130_fd_sc_hd__decap_3
X_6749_ _8419_/Q _4776_/A _6765_/S VGND VGND VPWR VPWR _6750_/A sky130_fd_sc_hd__mux2_2
XTAP_TAPCELL_ROW_21_587 VGND VPWR sky130_fd_sc_hd__tapvpwrvgnd_1
XFILLER_3_703 VGND VGND VPWR VPWR sky130_fd_sc_hd__decap_3
XTAP_TAPCELL_ROW_135_2181 VGND VPWR sky130_fd_sc_hd__tapvpwrvgnd_1
XTAP_TAPCELL_ROW_135_2192 VGND VPWR sky130_fd_sc_hd__tapvpwrvgnd_1
X_8419_ _8583_/CLK _8419_/D fanout619/X VGND VGND VPWR VPWR _8419_/Q sky130_fd_sc_hd__dfrtp_2
XFILLER_124_439 VGND VGND VPWR VPWR sky130_fd_sc_hd__decap_3
XFILLER_105_653 VGND VGND VPWR VPWR sky130_fd_sc_hd__decap_3
XFILLER_2_224 VGND VGND VPWR VPWR sky130_fd_sc_hd__fill_1
XFILLER_3_747 VGND VGND VPWR VPWR sky130_fd_sc_hd__decap_3
XFILLER_104_141 VGND VGND VPWR VPWR sky130_fd_sc_hd__decap_3
XFILLER_105_697 VGND VGND VPWR VPWR sky130_fd_sc_hd__decap_3
XFILLER_132_472 VGND VGND VPWR VPWR sky130_fd_sc_hd__decap_3
XFILLER_132_483 VGND VGND VPWR VPWR sky130_fd_sc_hd__decap_3
XTAP_TAPCELL_ROW_53_1036 VGND VPWR sky130_fd_sc_hd__tapvpwrvgnd_1
XFILLER_120_645 VGND VGND VPWR VPWR sky130_fd_sc_hd__decap_3
XFILLER_58_250 VGND VGND VPWR VPWR sky130_fd_sc_hd__fill_2
XFILLER_59_762 VGND VGND VPWR VPWR sky130_fd_sc_hd__decap_3
Xfanout561 fanout613/X VGND VGND VPWR VPWR fanout561/X sky130_fd_sc_hd__clkdlybuf4s25_1
Xfanout583 fanout585/X VGND VGND VPWR VPWR fanout583/X sky130_fd_sc_hd__clkdlybuf4s25_1
XFILLER_18_125 VGND VGND VPWR VPWR sky130_fd_sc_hd__decap_3
XFILLER_46_401 VGND VGND VPWR VPWR sky130_fd_sc_hd__decap_3
XFILLER_58_294 VGND VGND VPWR VPWR sky130_fd_sc_hd__decap_3
XFILLER_76_88 VGND VGND VPWR VPWR sky130_fd_sc_hd__fill_2
XFILLER_86_592 VGND VGND VPWR VPWR sky130_fd_sc_hd__decap_3
XTAP_TAPCELL_ROW_109_1814 VGND VPWR sky130_fd_sc_hd__tapvpwrvgnd_1
XTAP_TAPCELL_ROW_109_1825 VGND VPWR sky130_fd_sc_hd__tapvpwrvgnd_1
Xfanout594 fanout613/X VGND VGND VPWR VPWR fanout594/X sky130_fd_sc_hd__clkdlybuf4s25_1
XFILLER_132_50 VGND VGND VPWR VPWR sky130_fd_sc_hd__decap_3
XFILLER_18_136 VGND VGND VPWR VPWR sky130_fd_sc_hd__decap_3
XFILLER_34_607 VGND VGND VPWR VPWR sky130_fd_sc_hd__decap_3
XFILLER_46_467 VGND VGND VPWR VPWR sky130_fd_sc_hd__decap_3
XFILLER_74_754 VGND VGND VPWR VPWR sky130_fd_sc_hd__fill_2
XFILLER_132_83 VGND VGND VPWR VPWR sky130_fd_sc_hd__fill_1
XFILLER_132_94 VGND VGND VPWR VPWR sky130_fd_sc_hd__decap_3
XFILLER_27_670 VGND VGND VPWR VPWR sky130_fd_sc_hd__fill_2
XTAP_TAPCELL_ROW_29_698 VGND VPWR sky130_fd_sc_hd__tapvpwrvgnd_1
XFILLER_33_128 VGND VGND VPWR VPWR sky130_fd_sc_hd__decap_3
XFILLER_42_640 VGND VGND VPWR VPWR sky130_fd_sc_hd__decap_3
XFILLER_61_459 VGND VGND VPWR VPWR sky130_fd_sc_hd__decap_3
XFILLER_25_81 VGND VGND VPWR VPWR sky130_fd_sc_hd__decap_3
XFILLER_42_651 VGND VGND VPWR VPWR sky130_fd_sc_hd__decap_3
XPHY_EDGE_ROW_1_Left_137 VGND VGND VPWR VPWR sky130_fd_sc_hd__decap_3
XFILLER_14_386 VGND VGND VPWR VPWR sky130_fd_sc_hd__fill_1
XTAP_TAPCELL_ROW_64_1187 VGND VPWR sky130_fd_sc_hd__tapvpwrvgnd_1
XFILLER_128_701 VGND VGND VPWR VPWR sky130_fd_sc_hd__decap_3
XFILLER_41_194 VGND VGND VPWR VPWR sky130_fd_sc_hd__decap_3
XTAP_TAPCELL_ROW_40_852 VGND VPWR sky130_fd_sc_hd__tapvpwrvgnd_1
XFILLER_128_734 VGND VGND VPWR VPWR sky130_fd_sc_hd__decap_3
XFILLER_128_778 VGND VGND VPWR VPWR sky130_fd_sc_hd__decap_3
XFILLER_115_417 VGND VGND VPWR VPWR sky130_fd_sc_hd__fill_1
XFILLER_96_312 VGND VGND VPWR VPWR sky130_fd_sc_hd__decap_3
XFILLER_110_122 VGND VGND VPWR VPWR sky130_fd_sc_hd__decap_3
XFILLER_123_494 VGND VGND VPWR VPWR sky130_fd_sc_hd__decap_3
X_5080_ _5080_/A VGND VGND VPWR VPWR _7599_/D sky130_fd_sc_hd__buf_1
X_4100_ _8082_/Q _8163_/Q _4100_/S VGND VGND VPWR VPWR _4101_/B sky130_fd_sc_hd__mux2_2
XFILLER_2_41 VGND VGND VPWR VPWR sky130_fd_sc_hd__decap_3
XFILLER_84_518 VGND VGND VPWR VPWR sky130_fd_sc_hd__decap_3
XFILLER_96_356 VGND VGND VPWR VPWR sky130_fd_sc_hd__decap_3
X_4031_ _4031_/A VGND VGND VPWR VPWR _4031_/X sky130_fd_sc_hd__buf_1
XFILLER_2_74 VGND VGND VPWR VPWR sky130_fd_sc_hd__decap_3
XFILLER_2_85 VGND VGND VPWR VPWR sky130_fd_sc_hd__decap_3
XFILLER_65_732 VGND VGND VPWR VPWR sky130_fd_sc_hd__fill_1
XFILLER_77_581 VGND VGND VPWR VPWR sky130_fd_sc_hd__decap_3
XFILLER_64_220 VGND VGND VPWR VPWR sky130_fd_sc_hd__decap_3
XFILLER_65_754 VGND VGND VPWR VPWR sky130_fd_sc_hd__fill_2
XTAP_TAPCELL_ROW_48_963 VGND VPWR sky130_fd_sc_hd__tapvpwrvgnd_1
XFILLER_52_404 VGND VGND VPWR VPWR sky130_fd_sc_hd__fill_1
XFILLER_64_264 VGND VGND VPWR VPWR sky130_fd_sc_hd__decap_3
X_8770_ _8770_/CLK _8770_/D fanout549/X VGND VGND VPWR VPWR _8770_/Q sky130_fd_sc_hd__dfrtp_2
X_5982_ _8059_/Q _4968_/A _5990_/S VGND VGND VPWR VPWR _5983_/A sky130_fd_sc_hd__mux2_2
XFILLER_52_448 VGND VGND VPWR VPWR sky130_fd_sc_hd__decap_3
XFILLER_80_757 VGND VGND VPWR VPWR sky130_fd_sc_hd__decap_3
X_7721_ _8545_/CLK _7721_/D wire657/X VGND VGND VPWR VPWR _7721_/Q sky130_fd_sc_hd__dfrtp_2
X_4933_ _4933_/A VGND VGND VPWR VPWR _4933_/X sky130_fd_sc_hd__buf_1
XFILLER_33_662 VGND VGND VPWR VPWR sky130_fd_sc_hd__decap_3
XFILLER_20_323 VGND VGND VPWR VPWR sky130_fd_sc_hd__fill_1
XFILLER_33_684 VGND VGND VPWR VPWR sky130_fd_sc_hd__decap_3
X_7652_ _8634_/CLK _7652_/D load_slew704/X VGND VGND VPWR VPWR _7652_/Q sky130_fd_sc_hd__dfrtp_2
X_4864_ _4951_/A VGND VGND VPWR VPWR _4902_/B sky130_fd_sc_hd__clkbuf_2
X_3815_ _3862_/A _3815_/B VGND VGND VPWR VPWR _3815_/X sky130_fd_sc_hd__or2_2
X_7583_ _8645_/CLK _7583_/D load_slew501/X VGND VGND VPWR VPWR _7583_/Q sky130_fd_sc_hd__dfrtp_2
X_6603_ _6603_/A VGND VGND VPWR VPWR _8351_/D sky130_fd_sc_hd__buf_2
X_4795_ _4795_/A VGND VGND VPWR VPWR _4795_/X sky130_fd_sc_hd__buf_1
XFILLER_118_200 VGND VGND VPWR VPWR sky130_fd_sc_hd__decap_3
X_3746_ _3735_/X _3736_/X _3738_/X _3745_/X VGND VGND VPWR VPWR _3746_/X sky130_fd_sc_hd__a22o_2
X_6534_ _6534_/A VGND VGND VPWR VPWR _8318_/D sky130_fd_sc_hd__buf_2
XFILLER_119_778 VGND VGND VPWR VPWR sky130_fd_sc_hd__decap_3
XFILLER_134_704 VGND VGND VPWR VPWR sky130_fd_sc_hd__decap_3
XFILLER_21_39 VGND VGND VPWR VPWR sky130_fd_sc_hd__decap_3
XTAP_TAPCELL_ROW_95_1626 VGND VPWR sky130_fd_sc_hd__tapvpwrvgnd_1
X_6465_ _6465_/A VGND VGND VPWR VPWR _8286_/D sky130_fd_sc_hd__buf_2
XFILLER_106_417 VGND VGND VPWR VPWR sky130_fd_sc_hd__decap_3
XFILLER_106_439 VGND VGND VPWR VPWR sky130_fd_sc_hd__decap_3
XFILLER_133_214 VGND VGND VPWR VPWR sky130_fd_sc_hd__decap_3
XFILLER_133_225 VGND VGND VPWR VPWR sky130_fd_sc_hd__decap_3
XFILLER_134_737 VGND VGND VPWR VPWR sky130_fd_sc_hd__decap_3
X_8204_ _8771_/CLK _8204_/D load_slew596/X VGND VGND VPWR VPWR _8204_/Q sky130_fd_sc_hd__dfrtp_2
X_5416_ _5416_/A VGND VGND VPWR VPWR _7757_/D sky130_fd_sc_hd__buf_1
XFILLER_133_258 VGND VGND VPWR VPWR sky130_fd_sc_hd__decap_3
Xoutput131 _3833_/X VGND VGND VPWR VPWR rdata[4] sky130_fd_sc_hd__clkdlybuf4s25_1
Xoutput142 _3841_/X VGND VGND VPWR VPWR rdata[5] sky130_fd_sc_hd__clkdlybuf4s25_1
Xoutput120 _3822_/X VGND VGND VPWR VPWR rdata[3] sky130_fd_sc_hd__clkdlybuf4s25_1
X_6396_ _4765_/X _8254_/Q _6398_/S VGND VGND VPWR VPWR _6397_/A sky130_fd_sc_hd__mux2_2
XFILLER_99_172 VGND VGND VPWR VPWR sky130_fd_sc_hd__decap_3
Xoutput153 _3854_/X VGND VGND VPWR VPWR rdata[6] sky130_fd_sc_hd__clkdlybuf4s25_1
Xoutput164 _3866_/X VGND VGND VPWR VPWR rdata[7] sky130_fd_sc_hd__clkdlybuf4s25_1
X_8135_ _8783_/CLK _8135_/D load_slew682/X VGND VGND VPWR VPWR _8135_/Q sky130_fd_sc_hd__dfrtp_2
X_5347_ _5347_/A VGND VGND VPWR VPWR _7724_/D sky130_fd_sc_hd__buf_1
XFILLER_101_111 VGND VGND VPWR VPWR sky130_fd_sc_hd__fill_1
XFILLER_114_483 VGND VGND VPWR VPWR sky130_fd_sc_hd__decap_3
X_8066_ _8801_/CLK _8066_/D load_slew608/X VGND VGND VPWR VPWR _8066_/Q sky130_fd_sc_hd__dfrtp_2
X_5278_ _5278_/A VGND VGND VPWR VPWR _7692_/D sky130_fd_sc_hd__buf_1
X_7017_ _4969_/X hold937/X _7025_/S VGND VGND VPWR VPWR _7018_/A sky130_fd_sc_hd__mux2_1
X_4229_ _4231_/A _4225_/X _4227_/X _4228_/X VGND VGND VPWR VPWR _4229_/X sky130_fd_sc_hd__a22o_2
XFILLER_28_412 VGND VGND VPWR VPWR sky130_fd_sc_hd__decap_3
XFILLER_16_607 VGND VGND VPWR VPWR sky130_fd_sc_hd__decap_3
XFILLER_46_47 VGND VGND VPWR VPWR sky130_fd_sc_hd__decap_3
XFILLER_56_765 VGND VGND VPWR VPWR sky130_fd_sc_hd__decap_3
XFILLER_71_702 VGND VGND VPWR VPWR sky130_fd_sc_hd__decap_3
XFILLER_71_724 VGND VGND VPWR VPWR sky130_fd_sc_hd__decap_3
X_7919_ _8732_/CLK _7919_/D fanout487/X VGND VGND VPWR VPWR _7919_/Q sky130_fd_sc_hd__dfrtp_2
XFILLER_12_802 VGND VGND VPWR VPWR sky130_fd_sc_hd__fill_2
XFILLER_24_640 VGND VGND VPWR VPWR sky130_fd_sc_hd__decap_3
XFILLER_24_651 VGND VGND VPWR VPWR sky130_fd_sc_hd__fill_2
XFILLER_24_662 VGND VGND VPWR VPWR sky130_fd_sc_hd__decap_3
XFILLER_62_24 VGND VGND VPWR VPWR sky130_fd_sc_hd__decap_3
XTAP_TAPCELL_ROW_104_1744 VGND VPWR sky130_fd_sc_hd__tapvpwrvgnd_1
XTAP_TAPCELL_ROW_104_1755 VGND VPWR sky130_fd_sc_hd__tapvpwrvgnd_1
XTAP_TAPCELL_ROW_26_657 VGND VPWR sky130_fd_sc_hd__tapvpwrvgnd_1
XFILLER_24_695 VGND VGND VPWR VPWR sky130_fd_sc_hd__decap_3
XFILLER_62_79 VGND VGND VPWR VPWR sky130_fd_sc_hd__decap_3
XFILLER_134_3 VGND VGND VPWR VPWR sky130_fd_sc_hd__decap_3
XFILLER_11_389 VGND VGND VPWR VPWR sky130_fd_sc_hd__decap_3
XFILLER_109_299 VGND VGND VPWR VPWR sky130_fd_sc_hd__fill_1
XFILLER_124_203 VGND VGND VPWR VPWR sky130_fd_sc_hd__decap_3
XFILLER_11_72 VGND VGND VPWR VPWR sky130_fd_sc_hd__decap_3
XFILLER_105_461 VGND VGND VPWR VPWR sky130_fd_sc_hd__decap_3
XFILLER_127_72 VGND VGND VPWR VPWR sky130_fd_sc_hd__decap_3
XFILLER_132_280 VGND VGND VPWR VPWR sky130_fd_sc_hd__decap_3
XFILLER_78_312 VGND VGND VPWR VPWR sky130_fd_sc_hd__fill_2
XFILLER_78_323 VGND VGND VPWR VPWR sky130_fd_sc_hd__decap_3
XFILLER_87_54 VGND VGND VPWR VPWR sky130_fd_sc_hd__fill_2
XFILLER_66_507 VGND VGND VPWR VPWR sky130_fd_sc_hd__decap_3
XTAP_TAPCELL_ROW_6_371 VGND VPWR sky130_fd_sc_hd__tapvpwrvgnd_1
XFILLER_16_9 VGND VGND VPWR VPWR sky130_fd_sc_hd__decap_3
XFILLER_93_337 VGND VGND VPWR VPWR sky130_fd_sc_hd__decap_3
XTAP_TAPCELL_ROW_6_382 VGND VPWR sky130_fd_sc_hd__tapvpwrvgnd_1
Xfanout380 _4368_/A VGND VGND VPWR VPWR _4442_/A sky130_fd_sc_hd__clkdlybuf4s25_1
XFILLER_46_220 VGND VGND VPWR VPWR sky130_fd_sc_hd__decap_3
XFILLER_46_242 VGND VGND VPWR VPWR sky130_fd_sc_hd__fill_1
XFILLER_47_743 VGND VGND VPWR VPWR sky130_fd_sc_hd__decap_3
XFILLER_47_765 VGND VGND VPWR VPWR sky130_fd_sc_hd__decap_3
XFILLER_74_551 VGND VGND VPWR VPWR sky130_fd_sc_hd__decap_3
XFILLER_19_467 VGND VGND VPWR VPWR sky130_fd_sc_hd__decap_3
XTAP_TAPCELL_ROW_45_922 VGND VPWR sky130_fd_sc_hd__tapvpwrvgnd_1
XTAP_TAPCELL_ROW_66_1216 VGND VPWR sky130_fd_sc_hd__tapvpwrvgnd_1
XFILLER_46_286 VGND VGND VPWR VPWR sky130_fd_sc_hd__decap_3
XFILLER_62_757 VGND VGND VPWR VPWR sky130_fd_sc_hd__decap_3
XFILLER_15_673 VGND VGND VPWR VPWR sky130_fd_sc_hd__decap_3
XFILLER_61_278 VGND VGND VPWR VPWR sky130_fd_sc_hd__fill_2
XFILLER_14_172 VGND VGND VPWR VPWR sky130_fd_sc_hd__decap_3
XFILLER_128_531 VGND VGND VPWR VPWR sky130_fd_sc_hd__fill_1
Xinput11 wdata[17] VGND VGND VPWR VPWR _5018_/A sky130_fd_sc_hd__clkdlybuf4s25_1
Xinput22 wdata[27] VGND VGND VPWR VPWR _4718_/A sky130_fd_sc_hd__clkdlybuf4s25_1
X_4580_ _8034_/Q _3995_/B _4648_/B1 _7953_/Q _4665_/C1 VGND VGND VPWR VPWR _4580_/X
+ sky130_fd_sc_hd__o221a_2
XFILLER_116_704 VGND VGND VPWR VPWR sky130_fd_sc_hd__decap_3
XFILLER_128_542 VGND VGND VPWR VPWR sky130_fd_sc_hd__decap_3
Xinput33 wdata[37] VGND VGND VPWR VPWR _4760_/A sky130_fd_sc_hd__clkdlybuf4s25_1
Xinput44 wdata[47] VGND VGND VPWR VPWR _4802_/A sky130_fd_sc_hd__clkdlybuf4s25_1
Xinput55 wdata[57] VGND VGND VPWR VPWR _4844_/A sky130_fd_sc_hd__clkdlybuf4s25_1
XFILLER_128_575 VGND VGND VPWR VPWR sky130_fd_sc_hd__decap_3
Xhold806 _8687_/Q VGND VGND VPWR VPWR hold806/X sky130_fd_sc_hd__dlygate4sd3_1
Xhold817 _8030_/Q VGND VGND VPWR VPWR hold817/X sky130_fd_sc_hd__dlygate4sd3_1
Xhold828 _8000_/Q VGND VGND VPWR VPWR hold828/X sky130_fd_sc_hd__dlygate4sd3_1
Xinput66 wdata[67] VGND VGND VPWR VPWR _4886_/A sky130_fd_sc_hd__clkdlybuf4s25_1
Xinput77 wdata[77] VGND VGND VPWR VPWR _4928_/A sky130_fd_sc_hd__clkdlybuf4s25_1
XFILLER_115_225 VGND VGND VPWR VPWR sky130_fd_sc_hd__decap_3
XFILLER_115_236 VGND VGND VPWR VPWR sky130_fd_sc_hd__decap_3
XTAP_TAPCELL_ROW_77_1367 VGND VPWR sky130_fd_sc_hd__tapvpwrvgnd_1
Xhold839 _8693_/Q VGND VGND VPWR VPWR hold839/X sky130_fd_sc_hd__dlygate4sd3_1
X_6250_ _4815_/X _8185_/Q _6268_/S VGND VGND VPWR VPWR _6251_/A sky130_fd_sc_hd__mux2_4
XFILLER_130_206 VGND VGND VPWR VPWR sky130_fd_sc_hd__decap_3
XFILLER_131_718 VGND VGND VPWR VPWR sky130_fd_sc_hd__decap_3
XFILLER_131_729 VGND VGND VPWR VPWR sky130_fd_sc_hd__decap_3
X_6181_ _6181_/A VGND VGND VPWR VPWR _8152_/D sky130_fd_sc_hd__buf_6
X_5201_ _7656_/Q _5019_/X _5205_/S VGND VGND VPWR VPWR _5202_/A sky130_fd_sc_hd__mux2_2
XFILLER_111_431 VGND VGND VPWR VPWR sky130_fd_sc_hd__decap_3
XFILLER_130_239 VGND VGND VPWR VPWR sky130_fd_sc_hd__decap_3
XFILLER_69_323 VGND VGND VPWR VPWR sky130_fd_sc_hd__decap_3
XTAP_TAPCELL_ROW_90_1556 VGND VPWR sky130_fd_sc_hd__tapvpwrvgnd_1
Xload_slew731 fanout730/X VGND VGND VPWR VPWR load_slew731/X sky130_fd_sc_hd__buf_4
Xload_slew720 fanout719/X VGND VGND VPWR VPWR load_slew720/X sky130_fd_sc_hd__buf_2
X_5132_ _5132_/A VGND VGND VPWR VPWR _7624_/D sky130_fd_sc_hd__buf_1
XFILLER_111_464 VGND VGND VPWR VPWR sky130_fd_sc_hd__decap_3
XFILLER_29_209 VGND VGND VPWR VPWR sky130_fd_sc_hd__fill_1
XFILLER_96_153 VGND VGND VPWR VPWR sky130_fd_sc_hd__decap_3
XFILLER_97_676 VGND VGND VPWR VPWR sky130_fd_sc_hd__decap_3
Xload_slew742 fanout741/X VGND VGND VPWR VPWR load_slew742/X sky130_fd_sc_hd__clkbuf_4
XFILLER_96_197 VGND VGND VPWR VPWR sky130_fd_sc_hd__fill_2
X_5063_ _5063_/A VGND VGND VPWR VPWR _7591_/D sky130_fd_sc_hd__buf_1
XFILLER_37_231 VGND VGND VPWR VPWR sky130_fd_sc_hd__decap_3
X_4014_ _3988_/A _4010_/X _4013_/X _4083_/C1 VGND VGND VPWR VPWR _4014_/X sky130_fd_sc_hd__a211o_2
XFILLER_25_404 VGND VGND VPWR VPWR sky130_fd_sc_hd__decap_3
XFILLER_65_573 VGND VGND VPWR VPWR sky130_fd_sc_hd__decap_3
XFILLER_52_256 VGND VGND VPWR VPWR sky130_fd_sc_hd__fill_2
XFILLER_52_267 VGND VGND VPWR VPWR sky130_fd_sc_hd__fill_1
X_8753_ _8753_/CLK _8753_/D fanout643/X VGND VGND VPWR VPWR _8753_/Q sky130_fd_sc_hd__dfrtp_2
X_5965_ _8045_/D _8049_/D VGND VGND VPWR VPWR _5965_/Y sky130_fd_sc_hd__xnor2_2
XFILLER_80_587 VGND VGND VPWR VPWR sky130_fd_sc_hd__fill_1
XTAP_TAPCELL_ROW_23_616 VGND VPWR sky130_fd_sc_hd__tapvpwrvgnd_1
X_8684_ _8684_/CLK _8684_/D fanout569/X VGND VGND VPWR VPWR _8684_/Q sky130_fd_sc_hd__dfrtp_2
X_7704_ _8770_/CLK _7704_/D load_slew550/X VGND VGND VPWR VPWR _7704_/Q sky130_fd_sc_hd__dfrtp_2
X_5896_ _5948_/A VGND VGND VPWR VPWR _5896_/X sky130_fd_sc_hd__clkbuf_1
X_4916_ _4916_/A _4936_/B VGND VGND VPWR VPWR _4917_/A sky130_fd_sc_hd__and2_2
XFILLER_21_632 VGND VGND VPWR VPWR sky130_fd_sc_hd__decap_3
XFILLER_32_38 VGND VGND VPWR VPWR sky130_fd_sc_hd__decap_3
X_7635_ _8530_/CLK _7635_/D fanout747/X VGND VGND VPWR VPWR _7635_/Q sky130_fd_sc_hd__dfrtp_2
X_4847_ _4847_/A VGND VGND VPWR VPWR _7534_/D sky130_fd_sc_hd__buf_1
XFILLER_119_531 VGND VGND VPWR VPWR sky130_fd_sc_hd__decap_3
XFILLER_21_676 VGND VGND VPWR VPWR sky130_fd_sc_hd__decap_3
XFILLER_20_186 VGND VGND VPWR VPWR sky130_fd_sc_hd__decap_3
XFILLER_20_197 VGND VGND VPWR VPWR sky130_fd_sc_hd__decap_3
XPHY_EDGE_ROW_73_Left_209 VGND VGND VPWR VPWR sky130_fd_sc_hd__decap_3
X_7566_ _8622_/CLK _7566_/D wire657/X VGND VGND VPWR VPWR _7566_/Q sky130_fd_sc_hd__dfrtp_2
X_4778_ _4777_/X _7518_/Q _4778_/S VGND VGND VPWR VPWR _4779_/A sky130_fd_sc_hd__mux2_2
XFILLER_134_501 VGND VGND VPWR VPWR sky130_fd_sc_hd__decap_3
XTAP_TAPCELL_ROW_132_2140 VGND VPWR sky130_fd_sc_hd__tapvpwrvgnd_1
X_3729_ _5963_/B VGND VGND VPWR VPWR _8050_/D sky130_fd_sc_hd__inv_2
X_7497_ _5036_/X _8804_/Q _7497_/S VGND VGND VPWR VPWR _7498_/A sky130_fd_sc_hd__mux2_2
X_6517_ _6517_/A VGND VGND VPWR VPWR _8310_/D sky130_fd_sc_hd__buf_2
XFILLER_134_545 VGND VGND VPWR VPWR sky130_fd_sc_hd__decap_3
X_6448_ _6448_/A VGND VGND VPWR VPWR _8278_/D sky130_fd_sc_hd__buf_2
XFILLER_0_503 VGND VGND VPWR VPWR sky130_fd_sc_hd__fill_1
XFILLER_115_770 VGND VGND VPWR VPWR sky130_fd_sc_hd__decap_3
XFILLER_122_729 VGND VGND VPWR VPWR sky130_fd_sc_hd__decap_3
XFILLER_134_589 VGND VGND VPWR VPWR sky130_fd_sc_hd__decap_3
XFILLER_79_109 VGND VGND VPWR VPWR sky130_fd_sc_hd__decap_3
X_6379_ _6484_/S VGND VGND VPWR VPWR _6398_/S sky130_fd_sc_hd__buf_4
X_8118_ _8766_/CLK _8118_/D fanout575/X VGND VGND VPWR VPWR _8118_/Q sky130_fd_sc_hd__dfrtp_2
XFILLER_130_740 VGND VGND VPWR VPWR sky130_fd_sc_hd__decap_3
XFILLER_48_507 VGND VGND VPWR VPWR sky130_fd_sc_hd__decap_3
XFILLER_57_24 VGND VGND VPWR VPWR sky130_fd_sc_hd__fill_2
XFILLER_88_654 VGND VGND VPWR VPWR sky130_fd_sc_hd__decap_3
XFILLER_102_475 VGND VGND VPWR VPWR sky130_fd_sc_hd__fill_1
XFILLER_102_486 VGND VGND VPWR VPWR sky130_fd_sc_hd__decap_3
XFILLER_130_784 VGND VGND VPWR VPWR sky130_fd_sc_hd__decap_3
XFILLER_29_710 VGND VGND VPWR VPWR sky130_fd_sc_hd__decap_3
XFILLER_57_57 VGND VGND VPWR VPWR sky130_fd_sc_hd__decap_3
XFILLER_87_175 VGND VGND VPWR VPWR sky130_fd_sc_hd__decap_3
X_8049_ _8400_/CLK _8049_/D wire555/X VGND VGND VPWR VPWR _8049_/Q sky130_fd_sc_hd__dfrtp_2
XFILLER_29_732 VGND VGND VPWR VPWR sky130_fd_sc_hd__decap_3
XFILLER_57_79 VGND VGND VPWR VPWR sky130_fd_sc_hd__decap_3
XPHY_EDGE_ROW_82_Left_218 VGND VGND VPWR VPWR sky130_fd_sc_hd__decap_3
XTAP_TAPCELL_ROW_3_330 VGND VPWR sky130_fd_sc_hd__tapvpwrvgnd_1
XTAP_TAPCELL_ROW_3_341 VGND VPWR sky130_fd_sc_hd__tapvpwrvgnd_1
XFILLER_28_253 VGND VGND VPWR VPWR sky130_fd_sc_hd__decap_3
XFILLER_56_562 VGND VGND VPWR VPWR sky130_fd_sc_hd__decap_3
XFILLER_90_318 VGND VGND VPWR VPWR sky130_fd_sc_hd__decap_3
XFILLER_16_437 VGND VGND VPWR VPWR sky130_fd_sc_hd__decap_3
XFILLER_43_234 VGND VGND VPWR VPWR sky130_fd_sc_hd__decap_3
XFILLER_44_757 VGND VGND VPWR VPWR sky130_fd_sc_hd__decap_3
XFILLER_44_779 VGND VGND VPWR VPWR sky130_fd_sc_hd__decap_3
XFILLER_12_610 VGND VGND VPWR VPWR sky130_fd_sc_hd__decap_3
XFILLER_71_587 VGND VGND VPWR VPWR sky130_fd_sc_hd__decap_3
XPHY_EDGE_ROW_125_Right_125 VGND VGND VPWR VPWR sky130_fd_sc_hd__decap_3
XFILLER_12_643 VGND VGND VPWR VPWR sky130_fd_sc_hd__fill_1
XTAP_TAPCELL_ROW_61_1146 VGND VPWR sky130_fd_sc_hd__tapvpwrvgnd_1
XFILLER_7_113 VGND VGND VPWR VPWR sky130_fd_sc_hd__decap_3
XFILLER_8_625 VGND VGND VPWR VPWR sky130_fd_sc_hd__decap_3
XPHY_EDGE_ROW_91_Left_227 VGND VGND VPWR VPWR sky130_fd_sc_hd__decap_3
XFILLER_8_669 VGND VGND VPWR VPWR sky130_fd_sc_hd__decap_3
XTAP_TAPCELL_ROW_117_1924 VGND VPWR sky130_fd_sc_hd__tapvpwrvgnd_1
XTAP_TAPCELL_ROW_50_991 VGND VPWR sky130_fd_sc_hd__tapvpwrvgnd_1
XFILLER_22_71 VGND VGND VPWR VPWR sky130_fd_sc_hd__decap_3
XTAP_TAPCELL_ROW_117_1935 VGND VPWR sky130_fd_sc_hd__tapvpwrvgnd_1
XFILLER_125_556 VGND VGND VPWR VPWR sky130_fd_sc_hd__decap_3
XFILLER_3_330 VGND VGND VPWR VPWR sky130_fd_sc_hd__fill_1
XFILLER_79_632 VGND VGND VPWR VPWR sky130_fd_sc_hd__decap_3
XFILLER_120_250 VGND VGND VPWR VPWR sky130_fd_sc_hd__fill_2
XFILLER_66_326 VGND VGND VPWR VPWR sky130_fd_sc_hd__decap_3
XFILLER_78_164 VGND VGND VPWR VPWR sky130_fd_sc_hd__decap_3
XTAP_TAPCELL_ROW_72_1297 VGND VPWR sky130_fd_sc_hd__tapvpwrvgnd_1
XFILLER_120_294 VGND VGND VPWR VPWR sky130_fd_sc_hd__fill_2
XFILLER_14_6 VGND VGND VPWR VPWR sky130_fd_sc_hd__decap_3
XFILLER_19_231 VGND VGND VPWR VPWR sky130_fd_sc_hd__fill_1
XFILLER_78_197 VGND VGND VPWR VPWR sky130_fd_sc_hd__decap_3
XFILLER_94_657 VGND VGND VPWR VPWR sky130_fd_sc_hd__decap_3
XFILLER_35_724 VGND VGND VPWR VPWR sky130_fd_sc_hd__decap_3
XFILLER_81_318 VGND VGND VPWR VPWR sky130_fd_sc_hd__fill_2
XFILLER_81_329 VGND VGND VPWR VPWR sky130_fd_sc_hd__decap_3
XFILLER_93_178 VGND VGND VPWR VPWR sky130_fd_sc_hd__fill_2
XFILLER_34_212 VGND VGND VPWR VPWR sky130_fd_sc_hd__fill_2
XFILLER_50_727 VGND VGND VPWR VPWR sky130_fd_sc_hd__decap_3
XFILLER_97_3 VGND VGND VPWR VPWR sky130_fd_sc_hd__fill_1
X_5750_ _5750_/A VGND VGND VPWR VPWR _7914_/D sky130_fd_sc_hd__buf_1
X_5681_ _5849_/S VGND VGND VPWR VPWR _5700_/S sky130_fd_sc_hd__buf_2
X_4701_ _4701_/A VGND VGND VPWR VPWR _7499_/D sky130_fd_sc_hd__buf_1
X_7420_ _8767_/Q _4878_/A _7428_/S VGND VGND VPWR VPWR _7421_/A sky130_fd_sc_hd__mux2_2
X_4632_ _8778_/Q _7553_/Q _4632_/S VGND VGND VPWR VPWR _4633_/B sky130_fd_sc_hd__mux2_2
XFILLER_135_309 VGND VGND VPWR VPWR sky130_fd_sc_hd__decap_3
XFILLER_8_62 VGND VGND VPWR VPWR sky130_fd_sc_hd__decap_3
XFILLER_128_361 VGND VGND VPWR VPWR sky130_fd_sc_hd__decap_3
X_7351_ _8734_/Q _4739_/A _7365_/S VGND VGND VPWR VPWR _7352_/A sky130_fd_sc_hd__mux2_2
X_4563_ _7709_/Q _3774_/X _4645_/B1 _7628_/Q _4677_/C1 VGND VGND VPWR VPWR _4563_/X
+ sky130_fd_sc_hd__o221a_2
XFILLER_128_383 VGND VGND VPWR VPWR sky130_fd_sc_hd__fill_2
XFILLER_7_691 VGND VGND VPWR VPWR sky130_fd_sc_hd__decap_3
X_7282_ _7282_/A _7282_/B VGND VGND VPWR VPWR _7451_/S sky130_fd_sc_hd__nor2_4
X_6302_ _4921_/X _8210_/Q _6310_/S VGND VGND VPWR VPWR _6303_/A sky130_fd_sc_hd__mux2_4
X_4494_ _8765_/Q _7540_/Q _4494_/S VGND VGND VPWR VPWR _4494_/X sky130_fd_sc_hd__mux2_2
XFILLER_116_589 VGND VGND VPWR VPWR sky130_fd_sc_hd__decap_3
X_6233_ _4782_/X _8177_/Q _6247_/S VGND VGND VPWR VPWR _6234_/A sky130_fd_sc_hd__mux2_4
XFILLER_103_217 VGND VGND VPWR VPWR sky130_fd_sc_hd__decap_3
XFILLER_131_526 VGND VGND VPWR VPWR sky130_fd_sc_hd__decap_3
XFILLER_131_559 VGND VGND VPWR VPWR sky130_fd_sc_hd__fill_1
XFILLER_134_18 VGND VGND VPWR VPWR sky130_fd_sc_hd__decap_3
XFILLER_134_29 VGND VGND VPWR VPWR sky130_fd_sc_hd__decap_3
Xload_slew550 fanout549/X VGND VGND VPWR VPWR load_slew550/X sky130_fd_sc_hd__buf_2
X_6164_ _6164_/A VGND VGND VPWR VPWR _8144_/D sky130_fd_sc_hd__buf_6
XFILLER_111_261 VGND VGND VPWR VPWR sky130_fd_sc_hd__fill_2
XFILLER_111_272 VGND VGND VPWR VPWR sky130_fd_sc_hd__fill_2
XFILLER_84_101 VGND VGND VPWR VPWR sky130_fd_sc_hd__decap_3
XFILLER_85_635 VGND VGND VPWR VPWR sky130_fd_sc_hd__decap_3
Xload_slew572 fanout571/X VGND VGND VPWR VPWR load_slew572/X sky130_fd_sc_hd__buf_4
X_6095_ _8113_/Q _4852_/A _6095_/S VGND VGND VPWR VPWR _6096_/A sky130_fd_sc_hd__mux2_2
X_5115_ _5115_/A VGND VGND VPWR VPWR _7616_/D sky130_fd_sc_hd__buf_1
XFILLER_27_27 VGND VGND VPWR VPWR sky130_fd_sc_hd__decap_3
X_5046_ _5046_/A VGND VGND VPWR VPWR _7583_/D sky130_fd_sc_hd__buf_1
XFILLER_72_307 VGND VGND VPWR VPWR sky130_fd_sc_hd__fill_1
XFILLER_26_757 VGND VGND VPWR VPWR sky130_fd_sc_hd__decap_3
XFILLER_38_584 VGND VGND VPWR VPWR sky130_fd_sc_hd__decap_3
XFILLER_80_340 VGND VGND VPWR VPWR sky130_fd_sc_hd__decap_3
X_6997_ _6997_/A VGND VGND VPWR VPWR _8536_/D sky130_fd_sc_hd__buf_6
XFILLER_13_429 VGND VGND VPWR VPWR sky130_fd_sc_hd__decap_3
XFILLER_41_727 VGND VGND VPWR VPWR sky130_fd_sc_hd__fill_1
XFILLER_41_738 VGND VGND VPWR VPWR sky130_fd_sc_hd__decap_3
XFILLER_43_15 VGND VGND VPWR VPWR sky130_fd_sc_hd__fill_1
XFILLER_43_37 VGND VGND VPWR VPWR sky130_fd_sc_hd__decap_3
XTAP_TAPCELL_ROW_101_1703 VGND VPWR sky130_fd_sc_hd__tapvpwrvgnd_1
XTAP_TAPCELL_ROW_36_796 VGND VPWR sky130_fd_sc_hd__tapvpwrvgnd_1
X_8736_ _8736_/CLK _8736_/D fanout479/X VGND VGND VPWR VPWR _8736_/Q sky130_fd_sc_hd__dfrtp_2
X_5948_ _5948_/A VGND VGND VPWR VPWR _5948_/X sky130_fd_sc_hd__clkbuf_1
XFILLER_21_473 VGND VGND VPWR VPWR sky130_fd_sc_hd__fill_1
X_8667_ _8668_/CLK _8667_/D wire638/X VGND VGND VPWR VPWR _8667_/Q sky130_fd_sc_hd__dfrtp_2
X_5879_ _5868_/X _5879_/A2 _5023_/X _5879_/B1 hold763/X VGND VGND VPWR VPWR _7981_/D
+ sky130_fd_sc_hd__a32o_2
X_8598_ _8679_/CLK _8598_/D fanout697/X VGND VGND VPWR VPWR _8598_/Q sky130_fd_sc_hd__dfrtp_2
X_7618_ _8799_/CLK _7618_/D wire600/X VGND VGND VPWR VPWR _7618_/Q sky130_fd_sc_hd__dfrtp_2
XFILLER_5_617 VGND VGND VPWR VPWR sky130_fd_sc_hd__decap_3
X_7549_ _8450_/CLK _7549_/D load_slew742/X VGND VGND VPWR VPWR _7549_/Q sky130_fd_sc_hd__dfrtp_2
XFILLER_107_567 VGND VGND VPWR VPWR sky130_fd_sc_hd__decap_3
XFILLER_134_353 VGND VGND VPWR VPWR sky130_fd_sc_hd__decap_3
XTAP_TAPCELL_ROW_8_400 VGND VPWR sky130_fd_sc_hd__tapvpwrvgnd_1
XTAP_TAPCELL_ROW_8_411 VGND VPWR sky130_fd_sc_hd__tapvpwrvgnd_1
XFILLER_108_74 VGND VGND VPWR VPWR sky130_fd_sc_hd__fill_1
XFILLER_108_96 VGND VGND VPWR VPWR sky130_fd_sc_hd__decap_3
XFILLER_122_548 VGND VGND VPWR VPWR sky130_fd_sc_hd__decap_3
XFILLER_134_386 VGND VGND VPWR VPWR sky130_fd_sc_hd__decap_3
XTAP_TAPCELL_ROW_112_1854 VGND VPWR sky130_fd_sc_hd__tapvpwrvgnd_1
XTAP_TAPCELL_ROW_112_1865 VGND VPWR sky130_fd_sc_hd__tapvpwrvgnd_1
XFILLER_130_581 VGND VGND VPWR VPWR sky130_fd_sc_hd__decap_3
XFILLER_130_592 VGND VGND VPWR VPWR sky130_fd_sc_hd__decap_3
XFILLER_75_145 VGND VGND VPWR VPWR sky130_fd_sc_hd__decap_3
XFILLER_84_11 VGND VGND VPWR VPWR sky130_fd_sc_hd__fill_1
XFILLER_29_573 VGND VGND VPWR VPWR sky130_fd_sc_hd__decap_3
XFILLER_90_104 VGND VGND VPWR VPWR sky130_fd_sc_hd__decap_3
XFILLER_17_724 VGND VGND VPWR VPWR sky130_fd_sc_hd__decap_3
XFILLER_17_735 VGND VGND VPWR VPWR sky130_fd_sc_hd__decap_3
XFILLER_91_638 VGND VGND VPWR VPWR sky130_fd_sc_hd__decap_3
XFILLER_17_60 VGND VGND VPWR VPWR sky130_fd_sc_hd__decap_3
XFILLER_71_340 VGND VGND VPWR VPWR sky130_fd_sc_hd__decap_3
XFILLER_44_576 VGND VGND VPWR VPWR sky130_fd_sc_hd__fill_1
XFILLER_71_373 VGND VGND VPWR VPWR sky130_fd_sc_hd__decap_3
XFILLER_129_125 VGND VGND VPWR VPWR sky130_fd_sc_hd__decap_3
XFILLER_40_760 VGND VGND VPWR VPWR sky130_fd_sc_hd__decap_3
XFILLER_129_158 VGND VGND VPWR VPWR sky130_fd_sc_hd__decap_3
XFILLER_129_169 VGND VGND VPWR VPWR sky130_fd_sc_hd__decap_3
XTAP_TAPCELL_ROW_74_1326 VGND VPWR sky130_fd_sc_hd__tapvpwrvgnd_1
XFILLER_4_672 VGND VGND VPWR VPWR sky130_fd_sc_hd__decap_3
XFILLER_113_559 VGND VGND VPWR VPWR sky130_fd_sc_hd__fill_1
XFILLER_98_248 VGND VGND VPWR VPWR sky130_fd_sc_hd__decap_3
XFILLER_100_209 VGND VGND VPWR VPWR sky130_fd_sc_hd__fill_1
XFILLER_121_570 VGND VGND VPWR VPWR sky130_fd_sc_hd__decap_3
XFILLER_39_304 VGND VGND VPWR VPWR sky130_fd_sc_hd__decap_3
XFILLER_12_3 VGND VGND VPWR VPWR sky130_fd_sc_hd__decap_3
XFILLER_94_421 VGND VGND VPWR VPWR sky130_fd_sc_hd__decap_3
XFILLER_54_318 VGND VGND VPWR VPWR sky130_fd_sc_hd__decap_3
XFILLER_82_605 VGND VGND VPWR VPWR sky130_fd_sc_hd__decap_3
XFILLER_81_137 VGND VGND VPWR VPWR sky130_fd_sc_hd__decap_3
X_6920_ _6920_/A VGND VGND VPWR VPWR _8499_/D sky130_fd_sc_hd__buf_6
XFILLER_35_554 VGND VGND VPWR VPWR sky130_fd_sc_hd__decap_3
XFILLER_90_660 VGND VGND VPWR VPWR sky130_fd_sc_hd__fill_2
X_6851_ _4981_/X _8467_/Q _6853_/S VGND VGND VPWR VPWR _6852_/A sky130_fd_sc_hd__mux2_4
XFILLER_62_384 VGND VGND VPWR VPWR sky130_fd_sc_hd__fill_2
XFILLER_90_682 VGND VGND VPWR VPWR sky130_fd_sc_hd__decap_3
XTAP_TAPCELL_ROW_85_1477 VGND VPWR sky130_fd_sc_hd__tapvpwrvgnd_1
XTAP_TAPCELL_ROW_85_1488 VGND VPWR sky130_fd_sc_hd__tapvpwrvgnd_1
X_5802_ _5802_/A VGND VGND VPWR VPWR _7939_/D sky130_fd_sc_hd__buf_1
XTAP_TAPCELL_ROW_33_755 VGND VPWR sky130_fd_sc_hd__tapvpwrvgnd_1
X_3994_ _8639_/Q _3784_/X _4631_/A2 _8558_/Q _4465_/A VGND VGND VPWR VPWR _3994_/X
+ sky130_fd_sc_hd__o221a_2
X_8521_ _8688_/CLK _8521_/D load_slew572/X VGND VGND VPWR VPWR _8521_/Q sky130_fd_sc_hd__dfrtp_2
X_6782_ _8435_/Q _4844_/A _6786_/S VGND VGND VPWR VPWR _6783_/A sky130_fd_sc_hd__mux2_2
XFILLER_13_18 VGND VGND VPWR VPWR sky130_fd_sc_hd__decap_3
X_5733_ _5733_/A VGND VGND VPWR VPWR _7906_/D sky130_fd_sc_hd__buf_1
XFILLER_129_18 VGND VGND VPWR VPWR sky130_fd_sc_hd__decap_3
XFILLER_30_281 VGND VGND VPWR VPWR sky130_fd_sc_hd__decap_3
XFILLER_31_782 VGND VGND VPWR VPWR sky130_fd_sc_hd__fill_2
X_8452_ _8695_/CLK _8452_/D fanout732/A VGND VGND VPWR VPWR _8452_/Q sky130_fd_sc_hd__dfrtp_2
X_5664_ _5664_/A VGND VGND VPWR VPWR _7874_/D sky130_fd_sc_hd__buf_1
XFILLER_108_309 VGND VGND VPWR VPWR sky130_fd_sc_hd__decap_3
XFILLER_135_106 VGND VGND VPWR VPWR sky130_fd_sc_hd__decap_3
X_8383_ _8788_/CLK _8383_/D load_slew663/X VGND VGND VPWR VPWR _8383_/Q sky130_fd_sc_hd__dfrtp_2
X_7403_ _8759_/Q _4844_/A _7407_/S VGND VGND VPWR VPWR _7404_/A sky130_fd_sc_hd__mux2_2
X_5595_ _5595_/A VGND VGND VPWR VPWR _7841_/D sky130_fd_sc_hd__buf_1
X_4615_ _4633_/A _4613_/X _4614_/X VGND VGND VPWR VPWR _4615_/X sky130_fd_sc_hd__o21a_2
XFILLER_128_180 VGND VGND VPWR VPWR sky130_fd_sc_hd__decap_3
XFILLER_135_128 VGND VGND VPWR VPWR sky130_fd_sc_hd__decap_3
X_7334_ _8726_/Q _4706_/A _7344_/S VGND VGND VPWR VPWR _7335_/A sky130_fd_sc_hd__mux2_2
X_4546_ _4539_/X _4541_/X _4543_/X _4545_/X VGND VGND VPWR VPWR _4546_/X sky130_fd_sc_hd__a22o_2
XFILLER_104_504 VGND VGND VPWR VPWR sky130_fd_sc_hd__fill_1
XFILLER_132_802 VGND VGND VPWR VPWR sky130_fd_sc_hd__fill_2
XFILLER_104_526 VGND VGND VPWR VPWR sky130_fd_sc_hd__decap_3
XFILLER_116_397 VGND VGND VPWR VPWR sky130_fd_sc_hd__decap_3
XFILLER_1_108 VGND VGND VPWR VPWR sky130_fd_sc_hd__decap_3
XFILLER_1_119 VGND VGND VPWR VPWR sky130_fd_sc_hd__decap_3
Xmax_cap185 _5909_/X VGND VGND VPWR VPWR _5919_/B1 sky130_fd_sc_hd__buf_2
Xmax_cap174 _7230_/X VGND VGND VPWR VPWR _7242_/A3 sky130_fd_sc_hd__clkbuf_2
X_7265_ _7254_/X _4887_/X _7266_/A3 _7266_/B1 hold776/X VGND VGND VPWR VPWR _8688_/D
+ sky130_fd_sc_hd__a32o_2
X_4477_ _4498_/A _4475_/X _4476_/X VGND VGND VPWR VPWR _4477_/X sky130_fd_sc_hd__o21a_2
XFILLER_89_259 VGND VGND VPWR VPWR sky130_fd_sc_hd__decap_3
XFILLER_98_760 VGND VGND VPWR VPWR sky130_fd_sc_hd__decap_3
X_7196_ _7189_/X _5003_/X _7201_/A3 wire207/X hold894/X VGND VGND VPWR VPWR _8634_/D
+ sky130_fd_sc_hd__a32o_2
X_6216_ _4749_/X _8169_/Q _6226_/S VGND VGND VPWR VPWR _6217_/A sky130_fd_sc_hd__mux2_4
XFILLER_100_710 VGND VGND VPWR VPWR sky130_fd_sc_hd__decap_3
XFILLER_131_389 VGND VGND VPWR VPWR sky130_fd_sc_hd__decap_3
XFILLER_58_602 VGND VGND VPWR VPWR sky130_fd_sc_hd__decap_3
XFILLER_85_410 VGND VGND VPWR VPWR sky130_fd_sc_hd__decap_3
X_6147_ _4953_/X _8136_/Q _6163_/S VGND VGND VPWR VPWR _6148_/A sky130_fd_sc_hd__mux2_4
XFILLER_112_592 VGND VGND VPWR VPWR sky130_fd_sc_hd__fill_1
XFILLER_57_123 VGND VGND VPWR VPWR sky130_fd_sc_hd__decap_3
XFILLER_97_281 VGND VGND VPWR VPWR sky130_fd_sc_hd__decap_3
Xload_slew391 _4646_/A1 VGND VGND VPWR VPWR _4651_/A sky130_fd_sc_hd__clkbuf_4
XFILLER_57_156 VGND VGND VPWR VPWR sky130_fd_sc_hd__decap_3
XTAP_TAPCELL_ROW_127_2072 VGND VPWR sky130_fd_sc_hd__tapvpwrvgnd_1
X_6078_ _6078_/A VGND VGND VPWR VPWR _8104_/D sky130_fd_sc_hd__buf_1
X_5029_ _5029_/A VGND VGND VPWR VPWR _7577_/D sky130_fd_sc_hd__buf_1
XFILLER_72_159 VGND VGND VPWR VPWR sky130_fd_sc_hd__decap_3
XFILLER_26_576 VGND VGND VPWR VPWR sky130_fd_sc_hd__decap_3
XFILLER_26_598 VGND VGND VPWR VPWR sky130_fd_sc_hd__decap_3
XFILLER_81_693 VGND VGND VPWR VPWR sky130_fd_sc_hd__decap_3
XFILLER_110_53 VGND VGND VPWR VPWR sky130_fd_sc_hd__decap_3
XFILLER_41_557 VGND VGND VPWR VPWR sky130_fd_sc_hd__decap_3
XFILLER_22_760 VGND VGND VPWR VPWR sky130_fd_sc_hd__decap_3
XFILLER_70_24 VGND VGND VPWR VPWR sky130_fd_sc_hd__decap_3
X_8719_ _8719_/CLK _8719_/D load_slew591/X VGND VGND VPWR VPWR _8719_/Q sky130_fd_sc_hd__dfrtp_2
XFILLER_110_97 VGND VGND VPWR VPWR sky130_fd_sc_hd__fill_1
XFILLER_21_281 VGND VGND VPWR VPWR sky130_fd_sc_hd__decap_3
XFILLER_70_46 VGND VGND VPWR VPWR sky130_fd_sc_hd__decap_3
XFILLER_126_106 VGND VGND VPWR VPWR sky130_fd_sc_hd__decap_3
XFILLER_127_629 VGND VGND VPWR VPWR sky130_fd_sc_hd__fill_1
XTAP_TAPCELL_ROW_11_449 VGND VPWR sky130_fd_sc_hd__tapvpwrvgnd_1
XFILLER_119_51 VGND VGND VPWR VPWR sky130_fd_sc_hd__decap_3
XFILLER_135_640 VGND VGND VPWR VPWR sky130_fd_sc_hd__decap_3
XFILLER_134_150 VGND VGND VPWR VPWR sky130_fd_sc_hd__decap_3
XFILLER_135_651 VGND VGND VPWR VPWR sky130_fd_sc_hd__decap_3
XFILLER_134_183 VGND VGND VPWR VPWR sky130_fd_sc_hd__decap_3
XFILLER_135_684 VGND VGND VPWR VPWR sky130_fd_sc_hd__decap_3
XFILLER_1_620 VGND VGND VPWR VPWR sky130_fd_sc_hd__decap_3
XFILLER_135_50 VGND VGND VPWR VPWR sky130_fd_sc_hd__decap_3
XFILLER_1_653 VGND VGND VPWR VPWR sky130_fd_sc_hd__decap_3
XTAP_TAPCELL_ROW_56_1078 VGND VPWR sky130_fd_sc_hd__tapvpwrvgnd_1
XFILLER_0_141 VGND VGND VPWR VPWR sky130_fd_sc_hd__fill_2
XFILLER_0_163 VGND VGND VPWR VPWR sky130_fd_sc_hd__decap_3
XFILLER_122_389 VGND VGND VPWR VPWR sky130_fd_sc_hd__decap_3
XFILLER_135_72 VGND VGND VPWR VPWR sky130_fd_sc_hd__decap_3
XFILLER_135_94 VGND VGND VPWR VPWR sky130_fd_sc_hd__decap_3
XFILLER_1_697 VGND VGND VPWR VPWR sky130_fd_sc_hd__decap_3
XFILLER_48_123 VGND VGND VPWR VPWR sky130_fd_sc_hd__fill_1
XFILLER_76_421 VGND VGND VPWR VPWR sky130_fd_sc_hd__decap_3
XFILLER_48_167 VGND VGND VPWR VPWR sky130_fd_sc_hd__decap_3
XFILLER_49_679 VGND VGND VPWR VPWR sky130_fd_sc_hd__decap_3
XFILLER_91_402 VGND VGND VPWR VPWR sky130_fd_sc_hd__decap_3
XFILLER_95_98 VGND VGND VPWR VPWR sky130_fd_sc_hd__decap_3
XFILLER_91_446 VGND VGND VPWR VPWR sky130_fd_sc_hd__fill_2
XFILLER_17_554 VGND VGND VPWR VPWR sky130_fd_sc_hd__decap_3
XFILLER_60_800 VGND VGND VPWR VPWR sky130_fd_sc_hd__decap_3
XFILLER_13_771 VGND VGND VPWR VPWR sky130_fd_sc_hd__decap_3
XFILLER_32_579 VGND VGND VPWR VPWR sky130_fd_sc_hd__decap_3
XFILLER_44_91 VGND VGND VPWR VPWR sky130_fd_sc_hd__decap_3
XFILLER_9_753 VGND VGND VPWR VPWR sky130_fd_sc_hd__decap_3
XTAP_TAPCELL_ROW_30_714 VGND VPWR sky130_fd_sc_hd__tapvpwrvgnd_1
XFILLER_8_274 VGND VGND VPWR VPWR sky130_fd_sc_hd__fill_1
XFILLER_8_296 VGND VGND VPWR VPWR sky130_fd_sc_hd__decap_3
XFILLER_9_797 VGND VGND VPWR VPWR sky130_fd_sc_hd__decap_3
X_4400_ _8757_/Q _7532_/Q _7613_/Q _7694_/Q _4449_/S _4415_/A VGND VGND VPWR VPWR
+ _4400_/X sky130_fd_sc_hd__mux4_2
XFILLER_126_651 VGND VGND VPWR VPWR sky130_fd_sc_hd__decap_3
XFILLER_132_109 VGND VGND VPWR VPWR sky130_fd_sc_hd__decap_3
XFILLER_5_30 VGND VGND VPWR VPWR sky130_fd_sc_hd__decap_3
X_5380_ _7740_/Q _5030_/A _5398_/S VGND VGND VPWR VPWR _5381_/A sky130_fd_sc_hd__mux2_2
XFILLER_126_695 VGND VGND VPWR VPWR sky130_fd_sc_hd__decap_3
XFILLER_5_63 VGND VGND VPWR VPWR sky130_fd_sc_hd__decap_3
XFILLER_99_524 VGND VGND VPWR VPWR sky130_fd_sc_hd__decap_3
X_4331_ _8346_/Q _4629_/B _4388_/B _8265_/Q _3791_/A VGND VGND VPWR VPWR _4331_/X
+ sky130_fd_sc_hd__o221a_2
XFILLER_5_96 VGND VGND VPWR VPWR sky130_fd_sc_hd__decap_3
XFILLER_99_579 VGND VGND VPWR VPWR sky130_fd_sc_hd__decap_3
X_7050_ _7050_/A VGND VGND VPWR VPWR _8560_/D sky130_fd_sc_hd__buf_2
X_4262_ _7682_/Q _4682_/A2 _3752_/X _7601_/Q _3890_/X VGND VGND VPWR VPWR _4262_/X
+ sky130_fd_sc_hd__o221a_2
XFILLER_39_101 VGND VGND VPWR VPWR sky130_fd_sc_hd__fill_2
X_6001_ _8068_/Q input8/X _6011_/S VGND VGND VPWR VPWR _6002_/A sky130_fd_sc_hd__mux2_2
XFILLER_79_281 VGND VGND VPWR VPWR sky130_fd_sc_hd__decap_3
XFILLER_95_741 VGND VGND VPWR VPWR sky130_fd_sc_hd__decap_3
X_4193_ _8415_/Q _8496_/Q _4193_/S VGND VGND VPWR VPWR _4194_/B sky130_fd_sc_hd__mux2_2
XFILLER_67_465 VGND VGND VPWR VPWR sky130_fd_sc_hd__fill_2
XTAP_TAPCELL_ROW_87_1506 VGND VPWR sky130_fd_sc_hd__tapvpwrvgnd_1
XTAP_TAPCELL_ROW_87_1517 VGND VPWR sky130_fd_sc_hd__tapvpwrvgnd_1
XFILLER_67_498 VGND VGND VPWR VPWR sky130_fd_sc_hd__decap_3
XFILLER_94_284 VGND VGND VPWR VPWR sky130_fd_sc_hd__decap_3
XTAP_TAPCELL_ROW_38_825 VGND VPWR sky130_fd_sc_hd__tapvpwrvgnd_1
X_7952_ _8697_/CLK _7952_/D load_slew720/X VGND VGND VPWR VPWR _7952_/Q sky130_fd_sc_hd__dfrtp_2
XFILLER_70_619 VGND VGND VPWR VPWR sky130_fd_sc_hd__fill_1
XFILLER_82_457 VGND VGND VPWR VPWR sky130_fd_sc_hd__decap_3
X_6903_ _6903_/A VGND VGND VPWR VPWR _8491_/D sky130_fd_sc_hd__buf_6
XFILLER_51_800 VGND VGND VPWR VPWR sky130_fd_sc_hd__decap_3
XFILLER_63_671 VGND VGND VPWR VPWR sky130_fd_sc_hd__fill_1
X_7883_ _8387_/CLK _7883_/D fanout654/X VGND VGND VPWR VPWR _7883_/Q sky130_fd_sc_hd__dfrtp_2
XFILLER_23_535 VGND VGND VPWR VPWR sky130_fd_sc_hd__decap_3
XFILLER_23_557 VGND VGND VPWR VPWR sky130_fd_sc_hd__decap_3
XFILLER_50_321 VGND VGND VPWR VPWR sky130_fd_sc_hd__decap_3
X_6834_ _7002_/S VGND VGND VPWR VPWR _6853_/S sky130_fd_sc_hd__buf_6
XFILLER_23_579 VGND VGND VPWR VPWR sky130_fd_sc_hd__decap_3
X_3977_ _8394_/Q _8475_/Q _8556_/Q _8637_/Q _4550_/S _3958_/A VGND VGND VPWR VPWR
+ _3977_/X sky130_fd_sc_hd__mux4_2
X_6765_ _8427_/Q _4810_/A _6765_/S VGND VGND VPWR VPWR _6766_/A sky130_fd_sc_hd__mux2_2
X_8504_ _8624_/CLK _8504_/D load_slew645/X VGND VGND VPWR VPWR _8504_/Q sky130_fd_sc_hd__dfrtp_2
X_5716_ _5716_/A VGND VGND VPWR VPWR _7898_/D sky130_fd_sc_hd__buf_1
XFILLER_109_607 VGND VGND VPWR VPWR sky130_fd_sc_hd__decap_3
XFILLER_40_27 VGND VGND VPWR VPWR sky130_fd_sc_hd__fill_1
X_8435_ _8597_/CLK _8435_/D fanout705/X VGND VGND VPWR VPWR _8435_/Q sky130_fd_sc_hd__dfrtp_2
X_6696_ _8394_/Q _5014_/A _6702_/S VGND VGND VPWR VPWR _6697_/A sky130_fd_sc_hd__mux2_2
XTAP_TAPCELL_ROW_98_1668 VGND VPWR sky130_fd_sc_hd__tapvpwrvgnd_1
X_5647_ _5647_/A VGND VGND VPWR VPWR _7866_/D sky130_fd_sc_hd__buf_1
X_8366_ _8684_/CLK _8366_/D fanout569/X VGND VGND VPWR VPWR _8366_/Q sky130_fd_sc_hd__dfrtp_2
X_5578_ _5578_/A VGND VGND VPWR VPWR _7833_/D sky130_fd_sc_hd__buf_1
XFILLER_104_323 VGND VGND VPWR VPWR sky130_fd_sc_hd__fill_2
XFILLER_116_161 VGND VGND VPWR VPWR sky130_fd_sc_hd__decap_3
XFILLER_117_673 VGND VGND VPWR VPWR sky130_fd_sc_hd__decap_3
XFILLER_132_610 VGND VGND VPWR VPWR sky130_fd_sc_hd__decap_3
X_8297_ _8709_/CLK _8297_/D wire680/X VGND VGND VPWR VPWR _8297_/Q sky130_fd_sc_hd__dfrtp_2
X_7317_ _8718_/Q _5014_/A _7323_/S VGND VGND VPWR VPWR _7318_/A sky130_fd_sc_hd__mux2_2
X_4529_ _4529_/A _4529_/B VGND VGND VPWR VPWR _4529_/X sky130_fd_sc_hd__or2_2
XFILLER_116_194 VGND VGND VPWR VPWR sky130_fd_sc_hd__fill_2
XFILLER_131_131 VGND VGND VPWR VPWR sky130_fd_sc_hd__decap_3
XFILLER_132_643 VGND VGND VPWR VPWR sky130_fd_sc_hd__fill_1
XFILLER_132_654 VGND VGND VPWR VPWR sky130_fd_sc_hd__decap_3
XFILLER_49_14 VGND VGND VPWR VPWR sky130_fd_sc_hd__decap_3
X_7248_ _7253_/A1 _7248_/A2 _7255_/A3 _7255_/B1 hold805/X VGND VGND VPWR VPWR _8674_/D
+ sky130_fd_sc_hd__a32o_2
XFILLER_131_164 VGND VGND VPWR VPWR sky130_fd_sc_hd__decap_3
XFILLER_131_175 VGND VGND VPWR VPWR sky130_fd_sc_hd__decap_3
XFILLER_132_687 VGND VGND VPWR VPWR sky130_fd_sc_hd__decap_3
XTAP_TAPCELL_ROW_129_2101 VGND VPWR sky130_fd_sc_hd__tapvpwrvgnd_1
Xfanout721 fanout725/X VGND VGND VPWR VPWR fanout721/X sky130_fd_sc_hd__clkdlybuf4s25_1
Xfanout732 fanout732/A VGND VGND VPWR VPWR fanout732/X sky130_fd_sc_hd__clkdlybuf4s25_1
Xfanout743 fanout744/X VGND VGND VPWR VPWR fanout743/X sky130_fd_sc_hd__clkdlybuf4s25_1
Xfanout754 fanout754/A VGND VGND VPWR VPWR fanout754/X sky130_fd_sc_hd__clkdlybuf4s25_1
X_7179_ _7270_/A VGND VGND VPWR VPWR _7179_/X sky130_fd_sc_hd__clkbuf_1
XFILLER_46_616 VGND VGND VPWR VPWR sky130_fd_sc_hd__decap_3
XFILLER_58_454 VGND VGND VPWR VPWR sky130_fd_sc_hd__decap_3
XFILLER_86_763 VGND VGND VPWR VPWR sky130_fd_sc_hd__decap_3
XFILLER_65_35 VGND VGND VPWR VPWR sky130_fd_sc_hd__decap_3
XFILLER_65_57 VGND VGND VPWR VPWR sky130_fd_sc_hd__fill_1
XFILLER_73_424 VGND VGND VPWR VPWR sky130_fd_sc_hd__decap_3
XFILLER_45_137 VGND VGND VPWR VPWR sky130_fd_sc_hd__decap_3
XFILLER_26_362 VGND VGND VPWR VPWR sky130_fd_sc_hd__fill_2
XFILLER_54_660 VGND VGND VPWR VPWR sky130_fd_sc_hd__decap_3
XTAP_TAPCELL_ROW_107_1786 VGND VPWR sky130_fd_sc_hd__tapvpwrvgnd_1
XTAP_TAPCELL_ROW_16_519 VGND VPWR sky130_fd_sc_hd__tapvpwrvgnd_1
XFILLER_121_63 VGND VGND VPWR VPWR sky130_fd_sc_hd__fill_2
XFILLER_41_332 VGND VGND VPWR VPWR sky130_fd_sc_hd__decap_3
XFILLER_53_181 VGND VGND VPWR VPWR sky130_fd_sc_hd__decap_3
XFILLER_81_23 VGND VGND VPWR VPWR sky130_fd_sc_hd__decap_3
XTAP_TAPCELL_ROW_107_1797 VGND VPWR sky130_fd_sc_hd__tapvpwrvgnd_1
XFILLER_14_50 VGND VGND VPWR VPWR sky130_fd_sc_hd__decap_3
XTAP_TAPCELL_ROW_120_1975 VGND VPWR sky130_fd_sc_hd__tapvpwrvgnd_1
XFILLER_10_752 VGND VGND VPWR VPWR sky130_fd_sc_hd__decap_3
XFILLER_10_763 VGND VGND VPWR VPWR sky130_fd_sc_hd__decap_3
XFILLER_14_83 VGND VGND VPWR VPWR sky130_fd_sc_hd__fill_1
XFILLER_14_94 VGND VGND VPWR VPWR sky130_fd_sc_hd__decap_3
XFILLER_6_701 VGND VGND VPWR VPWR sky130_fd_sc_hd__decap_3
XFILLER_10_796 VGND VGND VPWR VPWR sky130_fd_sc_hd__decap_3
XFILLER_6_734 VGND VGND VPWR VPWR sky130_fd_sc_hd__decap_3
XTAP_TAPCELL_ROW_58_1107 VGND VPWR sky130_fd_sc_hd__tapvpwrvgnd_1
XFILLER_6_778 VGND VGND VPWR VPWR sky130_fd_sc_hd__decap_3
XFILLER_107_150 VGND VGND VPWR VPWR sky130_fd_sc_hd__decap_3
XFILLER_107_172 VGND VGND VPWR VPWR sky130_fd_sc_hd__decap_3
XFILLER_123_654 VGND VGND VPWR VPWR sky130_fd_sc_hd__decap_3
XFILLER_135_492 VGND VGND VPWR VPWR sky130_fd_sc_hd__fill_1
XFILLER_5_299 VGND VGND VPWR VPWR sky130_fd_sc_hd__decap_3
XFILLER_69_719 VGND VGND VPWR VPWR sky130_fd_sc_hd__decap_3
XFILLER_122_175 VGND VGND VPWR VPWR sky130_fd_sc_hd__decap_3
XFILLER_110_348 VGND VGND VPWR VPWR sky130_fd_sc_hd__decap_3
XFILLER_122_197 VGND VGND VPWR VPWR sky130_fd_sc_hd__decap_3
XFILLER_77_741 VGND VGND VPWR VPWR sky130_fd_sc_hd__decap_3
XFILLER_37_605 VGND VGND VPWR VPWR sky130_fd_sc_hd__decap_3
XFILLER_77_763 VGND VGND VPWR VPWR sky130_fd_sc_hd__decap_3
XFILLER_77_785 VGND VGND VPWR VPWR sky130_fd_sc_hd__decap_3
XFILLER_37_627 VGND VGND VPWR VPWR sky130_fd_sc_hd__fill_1
XFILLER_76_262 VGND VGND VPWR VPWR sky130_fd_sc_hd__decap_3
XFILLER_76_295 VGND VGND VPWR VPWR sky130_fd_sc_hd__fill_1
XFILLER_92_722 VGND VGND VPWR VPWR sky130_fd_sc_hd__fill_1
Xinput9 wdata[15] VGND VGND VPWR VPWR input9/X sky130_fd_sc_hd__clkdlybuf4s25_1
XFILLER_92_755 VGND VGND VPWR VPWR sky130_fd_sc_hd__fill_1
XTAP_TAPCELL_ROW_69_1258 VGND VPWR sky130_fd_sc_hd__tapvpwrvgnd_1
XFILLER_17_362 VGND VGND VPWR VPWR sky130_fd_sc_hd__decap_3
XFILLER_91_265 VGND VGND VPWR VPWR sky130_fd_sc_hd__fill_2
XFILLER_91_287 VGND VGND VPWR VPWR sky130_fd_sc_hd__decap_3
XFILLER_32_321 VGND VGND VPWR VPWR sky130_fd_sc_hd__fill_2
XFILLER_44_192 VGND VGND VPWR VPWR sky130_fd_sc_hd__decap_3
XFILLER_45_693 VGND VGND VPWR VPWR sky130_fd_sc_hd__decap_3
XTAP_TAPCELL_ROW_82_1436 VGND VPWR sky130_fd_sc_hd__tapvpwrvgnd_1
XTAP_TAPCELL_ROW_82_1447 VGND VPWR sky130_fd_sc_hd__tapvpwrvgnd_1
X_3900_ _3898_/X _3899_/X _3900_/S VGND VGND VPWR VPWR _3900_/X sky130_fd_sc_hd__mux2_2
X_4880_ _4879_/X _7542_/Q _4896_/S VGND VGND VPWR VPWR _4881_/A sky130_fd_sc_hd__mux2_2
X_3831_ _3831_/A _3831_/B VGND VGND VPWR VPWR _3831_/X sky130_fd_sc_hd__or2_2
XFILLER_32_376 VGND VGND VPWR VPWR sky130_fd_sc_hd__decap_3
XTAP_TAPCELL_ROW_43_894 VGND VPWR sky130_fd_sc_hd__tapvpwrvgnd_1
X_3762_ _3762_/A VGND VGND VPWR VPWR _4032_/B sky130_fd_sc_hd__clkbuf_2
X_6550_ _6550_/A VGND VGND VPWR VPWR _8326_/D sky130_fd_sc_hd__buf_2
XFILLER_118_415 VGND VGND VPWR VPWR sky130_fd_sc_hd__decap_3
XFILLER_9_561 VGND VGND VPWR VPWR sky130_fd_sc_hd__decap_3
X_5501_ _7798_/Q _4932_/A _5503_/S VGND VGND VPWR VPWR _5502_/A sky130_fd_sc_hd__mux2_2
XFILLER_118_448 VGND VGND VPWR VPWR sky130_fd_sc_hd__fill_2
XFILLER_9_594 VGND VGND VPWR VPWR sky130_fd_sc_hd__decap_3
X_6481_ _6481_/A VGND VGND VPWR VPWR _8294_/D sky130_fd_sc_hd__buf_2
X_8220_ _8786_/CLK _8220_/D fanout666/X VGND VGND VPWR VPWR _8220_/Q sky130_fd_sc_hd__dfrtp_2
X_5432_ _7765_/Q _4794_/A _5440_/S VGND VGND VPWR VPWR _5433_/A sky130_fd_sc_hd__mux2_2
XFILLER_133_429 VGND VGND VPWR VPWR sky130_fd_sc_hd__decap_3
XFILLER_99_310 VGND VGND VPWR VPWR sky130_fd_sc_hd__decap_3
X_8151_ _8638_/CLK _8151_/D load_slew596/X VGND VGND VPWR VPWR _8151_/Q sky130_fd_sc_hd__dfrtp_2
X_5363_ _7732_/Q input6/X _5377_/S VGND VGND VPWR VPWR _5364_/A sky130_fd_sc_hd__mux2_2
XFILLER_126_492 VGND VGND VPWR VPWR sky130_fd_sc_hd__fill_2
XFILLER_99_343 VGND VGND VPWR VPWR sky130_fd_sc_hd__fill_1
X_7102_ _7102_/A VGND VGND VPWR VPWR _8585_/D sky130_fd_sc_hd__buf_2
X_4314_ _8102_/Q _8183_/Q _4314_/S VGND VGND VPWR VPWR _4314_/X sky130_fd_sc_hd__mux2_2
XFILLER_87_516 VGND VGND VPWR VPWR sky130_fd_sc_hd__decap_3
XTAP_TAPCELL_ROW_93_1598 VGND VPWR sky130_fd_sc_hd__tapvpwrvgnd_1
X_8082_ _8649_/CLK _8082_/D wire531/X VGND VGND VPWR VPWR _8082_/Q sky130_fd_sc_hd__dfrtp_2
X_5294_ hold976/X _4861_/X _5310_/S VGND VGND VPWR VPWR _5295_/A sky130_fd_sc_hd__mux2_2
XFILLER_101_337 VGND VGND VPWR VPWR sky130_fd_sc_hd__decap_3
XFILLER_113_175 VGND VGND VPWR VPWR sky130_fd_sc_hd__decap_3
X_7033_ _7033_/A VGND VGND VPWR VPWR _8552_/D sky130_fd_sc_hd__buf_2
X_4245_ _8339_/Q _3939_/X _3916_/B _8258_/Q _4677_/C1 VGND VGND VPWR VPWR _4245_/X
+ sky130_fd_sc_hd__o221a_2
XFILLER_19_39 VGND VGND VPWR VPWR sky130_fd_sc_hd__decap_3
X_4176_ _8737_/Q _7512_/Q _4183_/S VGND VGND VPWR VPWR _4177_/B sky130_fd_sc_hd__mux2_2
XFILLER_55_402 VGND VGND VPWR VPWR sky130_fd_sc_hd__decap_3
XFILLER_67_284 VGND VGND VPWR VPWR sky130_fd_sc_hd__decap_3
XFILLER_95_582 VGND VGND VPWR VPWR sky130_fd_sc_hd__decap_3
XFILLER_27_148 VGND VGND VPWR VPWR sky130_fd_sc_hd__decap_3
XFILLER_82_221 VGND VGND VPWR VPWR sky130_fd_sc_hd__fill_1
XTAP_TAPCELL_ROW_124_2031 VGND VPWR sky130_fd_sc_hd__tapvpwrvgnd_1
XFILLER_70_416 VGND VGND VPWR VPWR sky130_fd_sc_hd__decap_3
XFILLER_70_427 VGND VGND VPWR VPWR sky130_fd_sc_hd__fill_2
X_7935_ _8019_/CLK _7935_/D load_slew714/X VGND VGND VPWR VPWR _7935_/Q sky130_fd_sc_hd__dfrtp_2
XFILLER_35_192 VGND VGND VPWR VPWR sky130_fd_sc_hd__decap_3
X_7866_ _8689_/CLK _7866_/D wire552/X VGND VGND VPWR VPWR _7866_/Q sky130_fd_sc_hd__dfrtp_2
XFILLER_11_505 VGND VGND VPWR VPWR sky130_fd_sc_hd__decap_3
X_6817_ _6817_/A VGND VGND VPWR VPWR _8451_/D sky130_fd_sc_hd__buf_2
XFILLER_50_162 VGND VGND VPWR VPWR sky130_fd_sc_hd__decap_3
X_7797_ _8700_/CLK _7797_/D wire746/X VGND VGND VPWR VPWR _7797_/Q sky130_fd_sc_hd__dfrtp_2
X_6748_ _6748_/A VGND VGND VPWR VPWR _8418_/D sky130_fd_sc_hd__buf_2
XFILLER_129_6 VGND VGND VPWR VPWR sky130_fd_sc_hd__decap_3
XTAP_TAPCELL_ROW_21_588 VGND VPWR sky130_fd_sc_hd__tapvpwrvgnd_1
X_6679_ _8386_/Q _4980_/A _6681_/S VGND VGND VPWR VPWR _6680_/A sky130_fd_sc_hd__mux2_2
XTAP_TAPCELL_ROW_135_2182 VGND VPWR sky130_fd_sc_hd__tapvpwrvgnd_1
X_8418_ _8662_/CLK _8418_/D load_slew621/X VGND VGND VPWR VPWR _8418_/Q sky130_fd_sc_hd__dfrtp_2
XFILLER_105_610 VGND VGND VPWR VPWR sky130_fd_sc_hd__decap_3
XFILLER_117_470 VGND VGND VPWR VPWR sky130_fd_sc_hd__decap_3
XFILLER_3_715 VGND VGND VPWR VPWR sky130_fd_sc_hd__decap_3
XTAP_TAPCELL_ROW_135_2193 VGND VPWR sky130_fd_sc_hd__tapvpwrvgnd_1
X_8349_ _8754_/CLK _8349_/D wire693/X VGND VGND VPWR VPWR _8349_/Q sky130_fd_sc_hd__dfrtp_2
XFILLER_3_759 VGND VGND VPWR VPWR sky130_fd_sc_hd__decap_3
XFILLER_104_153 VGND VGND VPWR VPWR sky130_fd_sc_hd__fill_2
XFILLER_105_665 VGND VGND VPWR VPWR sky130_fd_sc_hd__decap_3
XFILLER_105_676 VGND VGND VPWR VPWR sky130_fd_sc_hd__decap_3
XFILLER_116_41 VGND VGND VPWR VPWR sky130_fd_sc_hd__decap_3
XFILLER_132_451 VGND VGND VPWR VPWR sky130_fd_sc_hd__decap_3
XFILLER_78_505 VGND VGND VPWR VPWR sky130_fd_sc_hd__decap_3
XTAP_TAPCELL_ROW_53_1037 VGND VPWR sky130_fd_sc_hd__tapvpwrvgnd_1
XFILLER_104_197 VGND VGND VPWR VPWR sky130_fd_sc_hd__decap_3
XFILLER_132_495 VGND VGND VPWR VPWR sky130_fd_sc_hd__decap_3
Xfanout540 fanout543/X VGND VGND VPWR VPWR fanout540/X sky130_fd_sc_hd__clkdlybuf4s25_1
Xfanout551 fanout553/X VGND VGND VPWR VPWR wire552/A sky130_fd_sc_hd__clkdlybuf4s25_1
XFILLER_76_56 VGND VGND VPWR VPWR sky130_fd_sc_hd__fill_1
XFILLER_93_508 VGND VGND VPWR VPWR sky130_fd_sc_hd__fill_1
Xfanout562 fanout566/X VGND VGND VPWR VPWR fanout562/X sky130_fd_sc_hd__clkdlybuf4s25_1
Xfanout573 fanout576/X VGND VGND VPWR VPWR wire574/A sky130_fd_sc_hd__clkdlybuf4s25_1
XFILLER_58_262 VGND VGND VPWR VPWR sky130_fd_sc_hd__decap_3
XFILLER_86_571 VGND VGND VPWR VPWR sky130_fd_sc_hd__fill_2
XFILLER_86_582 VGND VGND VPWR VPWR sky130_fd_sc_hd__decap_3
XTAP_TAPCELL_ROW_109_1815 VGND VPWR sky130_fd_sc_hd__tapvpwrvgnd_1
Xfanout595 fanout595/A VGND VGND VPWR VPWR fanout595/X sky130_fd_sc_hd__clkdlybuf4s25_1
XFILLER_132_62 VGND VGND VPWR VPWR sky130_fd_sc_hd__decap_3
XFILLER_46_457 VGND VGND VPWR VPWR sky130_fd_sc_hd__fill_1
XFILLER_73_221 VGND VGND VPWR VPWR sky130_fd_sc_hd__decap_3
XFILLER_74_744 VGND VGND VPWR VPWR sky130_fd_sc_hd__decap_3
XFILLER_74_766 VGND VGND VPWR VPWR sky130_fd_sc_hd__fill_1
XFILLER_34_619 VGND VGND VPWR VPWR sky130_fd_sc_hd__fill_1
XFILLER_92_22 VGND VGND VPWR VPWR sky130_fd_sc_hd__decap_3
XFILLER_14_321 VGND VGND VPWR VPWR sky130_fd_sc_hd__decap_3
XFILLER_61_449 VGND VGND VPWR VPWR sky130_fd_sc_hd__fill_1
XTAP_TAPCELL_ROW_29_699 VGND VPWR sky130_fd_sc_hd__tapvpwrvgnd_1
XFILLER_14_365 VGND VGND VPWR VPWR sky130_fd_sc_hd__decap_3
XFILLER_25_60 VGND VGND VPWR VPWR sky130_fd_sc_hd__decap_3
XFILLER_41_151 VGND VGND VPWR VPWR sky130_fd_sc_hd__decap_3
XTAP_TAPCELL_ROW_64_1188 VGND VPWR sky130_fd_sc_hd__tapvpwrvgnd_1
XFILLER_128_713 VGND VGND VPWR VPWR sky130_fd_sc_hd__decap_3
XTAP_TAPCELL_ROW_40_853 VGND VPWR sky130_fd_sc_hd__tapvpwrvgnd_1
XFILLER_128_746 VGND VGND VPWR VPWR sky130_fd_sc_hd__decap_3
XFILLER_128_757 VGND VGND VPWR VPWR sky130_fd_sc_hd__decap_3
XFILLER_127_234 VGND VGND VPWR VPWR sky130_fd_sc_hd__decap_3
XFILLER_41_81 VGND VGND VPWR VPWR sky130_fd_sc_hd__decap_3
XFILLER_108_470 VGND VGND VPWR VPWR sky130_fd_sc_hd__decap_3
XFILLER_44_6 VGND VGND VPWR VPWR sky130_fd_sc_hd__decap_3
XFILLER_123_473 VGND VGND VPWR VPWR sky130_fd_sc_hd__decap_3
XFILLER_96_302 VGND VGND VPWR VPWR sky130_fd_sc_hd__decap_3
XPHY_EDGE_ROW_102_Left_238 VGND VGND VPWR VPWR sky130_fd_sc_hd__decap_3
XFILLER_111_635 VGND VGND VPWR VPWR sky130_fd_sc_hd__decap_3
XFILLER_2_781 VGND VGND VPWR VPWR sky130_fd_sc_hd__decap_3
XFILLER_96_324 VGND VGND VPWR VPWR sky130_fd_sc_hd__decap_3
XFILLER_111_657 VGND VGND VPWR VPWR sky130_fd_sc_hd__decap_3
XFILLER_2_53 VGND VGND VPWR VPWR sky130_fd_sc_hd__decap_3
XFILLER_96_368 VGND VGND VPWR VPWR sky130_fd_sc_hd__decap_3
XPHY_EDGE_ROW_10_Right_10 VGND VGND VPWR VPWR sky130_fd_sc_hd__decap_3
X_4030_ _4026_/X _4029_/X _4030_/S VGND VGND VPWR VPWR _4031_/A sky130_fd_sc_hd__mux2_2
XFILLER_110_167 VGND VGND VPWR VPWR sky130_fd_sc_hd__decap_3
XFILLER_37_402 VGND VGND VPWR VPWR sky130_fd_sc_hd__decap_3
XFILLER_64_210 VGND VGND VPWR VPWR sky130_fd_sc_hd__fill_1
XFILLER_65_722 VGND VGND VPWR VPWR sky130_fd_sc_hd__decap_3
XFILLER_77_593 VGND VGND VPWR VPWR sky130_fd_sc_hd__fill_2
XFILLER_2_97 VGND VGND VPWR VPWR sky130_fd_sc_hd__decap_3
XFILLER_37_435 VGND VGND VPWR VPWR sky130_fd_sc_hd__fill_2
XFILLER_92_530 VGND VGND VPWR VPWR sky130_fd_sc_hd__fill_2
XFILLER_37_468 VGND VGND VPWR VPWR sky130_fd_sc_hd__fill_1
XFILLER_65_788 VGND VGND VPWR VPWR sky130_fd_sc_hd__fill_1
XTAP_TAPCELL_ROW_48_964 VGND VPWR sky130_fd_sc_hd__tapvpwrvgnd_1
X_5981_ _5981_/A VGND VGND VPWR VPWR _8058_/D sky130_fd_sc_hd__buf_1
XFILLER_18_693 VGND VGND VPWR VPWR sky130_fd_sc_hd__fill_1
XFILLER_24_129 VGND VGND VPWR VPWR sky130_fd_sc_hd__decap_3
X_7720_ _8621_/CLK _7720_/D load_slew682/X VGND VGND VPWR VPWR _7720_/Q sky130_fd_sc_hd__dfrtp_2
X_4932_ _4932_/A _4936_/B VGND VGND VPWR VPWR _4933_/A sky130_fd_sc_hd__and2_2
XFILLER_17_192 VGND VGND VPWR VPWR sky130_fd_sc_hd__fill_2
XFILLER_33_641 VGND VGND VPWR VPWR sky130_fd_sc_hd__decap_3
XPHY_EDGE_ROW_111_Left_247 VGND VGND VPWR VPWR sky130_fd_sc_hd__decap_3
X_7651_ _8795_/CLK _7651_/D fanout607/X VGND VGND VPWR VPWR _7651_/Q sky130_fd_sc_hd__dfrtp_2
XFILLER_32_173 VGND VGND VPWR VPWR sky130_fd_sc_hd__fill_2
XFILLER_33_696 VGND VGND VPWR VPWR sky130_fd_sc_hd__decap_3
XFILLER_60_471 VGND VGND VPWR VPWR sky130_fd_sc_hd__decap_3
X_6602_ _4833_/X _8351_/Q _6612_/S VGND VGND VPWR VPWR _6603_/A sky130_fd_sc_hd__mux2_2
X_4863_ _4863_/A VGND VGND VPWR VPWR _7538_/D sky130_fd_sc_hd__buf_1
XFILLER_119_713 VGND VGND VPWR VPWR sky130_fd_sc_hd__decap_3
X_3814_ _8381_/Q _8462_/Q _3814_/S VGND VGND VPWR VPWR _3815_/B sky130_fd_sc_hd__mux2_2
X_7582_ _8733_/CLK _7582_/D load_slew486/X VGND VGND VPWR VPWR _7582_/Q sky130_fd_sc_hd__dfrtp_2
X_4794_ _4794_/A _4810_/B VGND VGND VPWR VPWR _4795_/A sky130_fd_sc_hd__and2_2
XFILLER_119_735 VGND VGND VPWR VPWR sky130_fd_sc_hd__decap_3
XFILLER_21_18 VGND VGND VPWR VPWR sky130_fd_sc_hd__decap_3
X_3745_ _7963_/Q _4195_/A2 _4600_/A2 _7882_/Q _3840_/S VGND VGND VPWR VPWR _3745_/X
+ sky130_fd_sc_hd__o221a_2
X_6533_ _5036_/X _8318_/Q _6549_/S VGND VGND VPWR VPWR _6534_/A sky130_fd_sc_hd__mux2_2
XFILLER_118_245 VGND VGND VPWR VPWR sky130_fd_sc_hd__decap_3
XFILLER_118_256 VGND VGND VPWR VPWR sky130_fd_sc_hd__fill_2
XTAP_TAPCELL_ROW_95_1616 VGND VPWR sky130_fd_sc_hd__tapvpwrvgnd_1
XTAP_TAPCELL_ROW_95_1627 VGND VPWR sky130_fd_sc_hd__tapvpwrvgnd_1
X_6464_ _4899_/X _8286_/Q _6482_/S VGND VGND VPWR VPWR _6465_/A sky130_fd_sc_hd__mux2_2
XFILLER_134_716 VGND VGND VPWR VPWR sky130_fd_sc_hd__decap_3
XFILLER_134_749 VGND VGND VPWR VPWR sky130_fd_sc_hd__decap_3
Xoutput110 _4122_/X VGND VGND VPWR VPWR rdata[30] sky130_fd_sc_hd__clkdlybuf4s25_1
X_8203_ _8608_/CLK _8203_/D _8053_/SET_B VGND VGND VPWR VPWR _8203_/Q sky130_fd_sc_hd__dfrtp_2
X_5415_ _7757_/Q _4760_/A _5419_/S VGND VGND VPWR VPWR _5416_/A sky130_fd_sc_hd__mux2_2
XFILLER_133_237 VGND VGND VPWR VPWR sky130_fd_sc_hd__decap_3
XPHY_EDGE_ROW_120_Left_256 VGND VGND VPWR VPWR sky130_fd_sc_hd__decap_3
Xoutput132 _4348_/X VGND VGND VPWR VPWR rdata[50] sky130_fd_sc_hd__clkdlybuf4s25_1
Xoutput143 _4467_/X VGND VGND VPWR VPWR rdata[60] sky130_fd_sc_hd__clkdlybuf4s25_1
Xoutput121 _4234_/X VGND VGND VPWR VPWR rdata[40] sky130_fd_sc_hd__clkdlybuf4s25_1
X_6395_ _6395_/A VGND VGND VPWR VPWR _8253_/D sky130_fd_sc_hd__buf_2
XFILLER_0_707 VGND VGND VPWR VPWR sky130_fd_sc_hd__decap_3
XFILLER_0_729 VGND VGND VPWR VPWR sky130_fd_sc_hd__decap_3
XFILLER_102_602 VGND VGND VPWR VPWR sky130_fd_sc_hd__fill_1
Xoutput154 _4572_/X VGND VGND VPWR VPWR rdata[70] sky130_fd_sc_hd__clkdlybuf4s25_1
Xoutput165 _4685_/X VGND VGND VPWR VPWR rdata[80] sky130_fd_sc_hd__clkdlybuf4s25_1
X_8134_ _8701_/CLK _8134_/D fanout648/A VGND VGND VPWR VPWR _8134_/Q sky130_fd_sc_hd__dfrtp_2
X_5346_ _7724_/Q _4964_/A _5356_/S VGND VGND VPWR VPWR _5347_/A sky130_fd_sc_hd__mux2_2
XFILLER_99_184 VGND VGND VPWR VPWR sky130_fd_sc_hd__decap_3
X_8065_ _8802_/CLK _8065_/D load_slew579/X VGND VGND VPWR VPWR _8065_/Q sky130_fd_sc_hd__dfrtp_2
X_5277_ _7692_/Q _7248_/A2 _5289_/S VGND VGND VPWR VPWR _5278_/A sky130_fd_sc_hd__mux2_2
XFILLER_102_668 VGND VGND VPWR VPWR sky130_fd_sc_hd__fill_2
XFILLER_75_508 VGND VGND VPWR VPWR sky130_fd_sc_hd__decap_3
X_7016_ _7016_/A VGND VGND VPWR VPWR _8544_/D sky130_fd_sc_hd__buf_2
X_4228_ _7679_/Q _3921_/X _3870_/X _7598_/Q _3890_/X VGND VGND VPWR VPWR _4228_/X
+ sky130_fd_sc_hd__o221a_2
XFILLER_28_424 VGND VGND VPWR VPWR sky130_fd_sc_hd__decap_3
XFILLER_56_755 VGND VGND VPWR VPWR sky130_fd_sc_hd__fill_1
XPHY_EDGE_ROW_106_Right_106 VGND VGND VPWR VPWR sky130_fd_sc_hd__decap_3
X_4159_ _8655_/Q _4286_/A2 _3785_/X _8574_/Q _3758_/A VGND VGND VPWR VPWR _4159_/X
+ sky130_fd_sc_hd__o221a_2
XFILLER_16_619 VGND VGND VPWR VPWR sky130_fd_sc_hd__decap_3
XFILLER_55_276 VGND VGND VPWR VPWR sky130_fd_sc_hd__decap_3
XFILLER_56_777 VGND VGND VPWR VPWR sky130_fd_sc_hd__fill_1
XFILLER_102_32 VGND VGND VPWR VPWR sky130_fd_sc_hd__decap_3
XFILLER_43_449 VGND VGND VPWR VPWR sky130_fd_sc_hd__fill_1
XFILLER_55_287 VGND VGND VPWR VPWR sky130_fd_sc_hd__decap_3
XFILLER_71_747 VGND VGND VPWR VPWR sky130_fd_sc_hd__decap_3
X_7918_ _8495_/CLK _7918_/D fanout517/X VGND VGND VPWR VPWR _7918_/Q sky130_fd_sc_hd__dfrtp_2
XTAP_TAPCELL_ROW_104_1745 VGND VPWR sky130_fd_sc_hd__tapvpwrvgnd_1
XTAP_TAPCELL_ROW_26_658 VGND VPWR sky130_fd_sc_hd__tapvpwrvgnd_1
XFILLER_24_674 VGND VGND VPWR VPWR sky130_fd_sc_hd__decap_3
XFILLER_62_58 VGND VGND VPWR VPWR sky130_fd_sc_hd__decap_3
X_7849_ _8701_/CLK _7849_/D load_slew645/X VGND VGND VPWR VPWR _7849_/Q sky130_fd_sc_hd__dfrtp_2
XFILLER_109_223 VGND VGND VPWR VPWR sky130_fd_sc_hd__fill_1
XFILLER_127_3 VGND VGND VPWR VPWR sky130_fd_sc_hd__decap_3
XFILLER_11_51 VGND VGND VPWR VPWR sky130_fd_sc_hd__decap_3
XFILLER_11_84 VGND VGND VPWR VPWR sky130_fd_sc_hd__decap_3
XFILLER_127_51 VGND VGND VPWR VPWR sky130_fd_sc_hd__decap_3
XFILLER_3_523 VGND VGND VPWR VPWR sky130_fd_sc_hd__fill_2
XFILLER_127_84 VGND VGND VPWR VPWR sky130_fd_sc_hd__decap_3
XFILLER_133_771 VGND VGND VPWR VPWR sky130_fd_sc_hd__decap_3
XTAP_TAPCELL_ROW_115_1896 VGND VPWR sky130_fd_sc_hd__tapvpwrvgnd_1
XFILLER_105_495 VGND VGND VPWR VPWR sky130_fd_sc_hd__decap_3
XFILLER_120_421 VGND VGND VPWR VPWR sky130_fd_sc_hd__decap_3
XFILLER_3_589 VGND VGND VPWR VPWR sky130_fd_sc_hd__decap_3
XFILLER_78_335 VGND VGND VPWR VPWR sky130_fd_sc_hd__decap_3
XFILLER_87_66 VGND VGND VPWR VPWR sky130_fd_sc_hd__decap_3
XFILLER_132_292 VGND VGND VPWR VPWR sky130_fd_sc_hd__decap_3
XFILLER_66_519 VGND VGND VPWR VPWR sky130_fd_sc_hd__decap_3
XFILLER_78_368 VGND VGND VPWR VPWR sky130_fd_sc_hd__decap_3
XTAP_TAPCELL_ROW_6_372 VGND VPWR sky130_fd_sc_hd__tapvpwrvgnd_1
XTAP_TAPCELL_ROW_6_383 VGND VPWR sky130_fd_sc_hd__tapvpwrvgnd_1
Xfanout370 _4344_/A VGND VGND VPWR VPWR _4681_/A sky130_fd_sc_hd__clkdlybuf4s25_1
Xfanout381 _4412_/B2 VGND VGND VPWR VPWR _4368_/A sky130_fd_sc_hd__clkdlybuf4s25_1
Xfanout392 _8045_/Q VGND VGND VPWR VPWR _4412_/B2 sky130_fd_sc_hd__clkdlybuf4s25_1
XFILLER_19_424 VGND VGND VPWR VPWR sky130_fd_sc_hd__decap_3
XFILLER_93_349 VGND VGND VPWR VPWR sky130_fd_sc_hd__fill_2
XFILLER_47_788 VGND VGND VPWR VPWR sky130_fd_sc_hd__decap_3
XTAP_TAPCELL_ROW_66_1217 VGND VPWR sky130_fd_sc_hd__tapvpwrvgnd_1
XFILLER_34_427 VGND VGND VPWR VPWR sky130_fd_sc_hd__decap_3
XFILLER_34_449 VGND VGND VPWR VPWR sky130_fd_sc_hd__decap_3
XFILLER_36_81 VGND VGND VPWR VPWR sky130_fd_sc_hd__decap_3
XFILLER_46_298 VGND VGND VPWR VPWR sky130_fd_sc_hd__decap_3
XTAP_TAPCELL_ROW_45_923 VGND VPWR sky130_fd_sc_hd__tapvpwrvgnd_1
XFILLER_15_685 VGND VGND VPWR VPWR sky130_fd_sc_hd__fill_1
XFILLER_14_195 VGND VGND VPWR VPWR sky130_fd_sc_hd__fill_1
XFILLER_128_510 VGND VGND VPWR VPWR sky130_fd_sc_hd__decap_3
XFILLER_30_699 VGND VGND VPWR VPWR sky130_fd_sc_hd__fill_1
XFILLER_52_91 VGND VGND VPWR VPWR sky130_fd_sc_hd__decap_3
Xinput12 wdata[18] VGND VGND VPWR VPWR _5022_/A sky130_fd_sc_hd__clkdlybuf4s25_1
XFILLER_128_554 VGND VGND VPWR VPWR sky130_fd_sc_hd__decap_3
Xinput23 wdata[28] VGND VGND VPWR VPWR _4722_/A sky130_fd_sc_hd__clkdlybuf4s25_1
Xinput34 wdata[38] VGND VGND VPWR VPWR _4764_/A sky130_fd_sc_hd__clkdlybuf4s25_1
Xinput45 wdata[48] VGND VGND VPWR VPWR _4806_/A sky130_fd_sc_hd__clkdlybuf4s25_1
XFILLER_128_587 VGND VGND VPWR VPWR sky130_fd_sc_hd__fill_1
XFILLER_128_598 VGND VGND VPWR VPWR sky130_fd_sc_hd__decap_3
Xhold807 _7994_/Q VGND VGND VPWR VPWR hold807/X sky130_fd_sc_hd__dlygate4sd3_1
Xhold818 _8027_/Q VGND VGND VPWR VPWR hold818/X sky130_fd_sc_hd__dlygate4sd3_1
Xinput56 wdata[58] VGND VGND VPWR VPWR _4848_/A sky130_fd_sc_hd__clkdlybuf4s25_1
Xinput67 wdata[68] VGND VGND VPWR VPWR _4890_/A sky130_fd_sc_hd__clkdlybuf4s25_1
Xinput78 wdata[78] VGND VGND VPWR VPWR _4932_/A sky130_fd_sc_hd__clkdlybuf4s25_1
XFILLER_115_248 VGND VGND VPWR VPWR sky130_fd_sc_hd__fill_2
XTAP_TAPCELL_ROW_77_1368 VGND VPWR sky130_fd_sc_hd__tapvpwrvgnd_1
Xhold829 _8016_/Q VGND VGND VPWR VPWR hold829/X sky130_fd_sc_hd__dlygate4sd3_1
XFILLER_42_3 VGND VGND VPWR VPWR sky130_fd_sc_hd__fill_2
X_6180_ _5019_/X _8152_/Q _6184_/S VGND VGND VPWR VPWR _6181_/A sky130_fd_sc_hd__mux2_4
X_5200_ _5200_/A VGND VGND VPWR VPWR _7655_/D sky130_fd_sc_hd__buf_1
XFILLER_111_410 VGND VGND VPWR VPWR sky130_fd_sc_hd__decap_3
XFILLER_130_218 VGND VGND VPWR VPWR sky130_fd_sc_hd__decap_3
XTAP_TAPCELL_ROW_90_1546 VGND VPWR sky130_fd_sc_hd__tapvpwrvgnd_1
XTAP_TAPCELL_ROW_90_1557 VGND VPWR sky130_fd_sc_hd__tapvpwrvgnd_1
Xload_slew710 fanout709/X VGND VGND VPWR VPWR load_slew710/X sky130_fd_sc_hd__buf_4
X_5131_ _4883_/X hold958/X _5137_/S VGND VGND VPWR VPWR _5132_/A sky130_fd_sc_hd__mux2_2
X_5062_ _4745_/X hold982/X _5074_/S VGND VGND VPWR VPWR _5063_/A sky130_fd_sc_hd__mux2_2
XFILLER_57_519 VGND VGND VPWR VPWR sky130_fd_sc_hd__decap_3
X_4013_ _4013_/A1 _4011_/X _4012_/X VGND VGND VPWR VPWR _4013_/X sky130_fd_sc_hd__o21a_2
XFILLER_37_221 VGND VGND VPWR VPWR sky130_fd_sc_hd__decap_3
XFILLER_38_744 VGND VGND VPWR VPWR sky130_fd_sc_hd__fill_1
XFILLER_38_766 VGND VGND VPWR VPWR sky130_fd_sc_hd__fill_2
XFILLER_38_777 VGND VGND VPWR VPWR sky130_fd_sc_hd__decap_3
XFILLER_53_725 VGND VGND VPWR VPWR sky130_fd_sc_hd__decap_3
XFILLER_16_18 VGND VGND VPWR VPWR sky130_fd_sc_hd__decap_3
XFILLER_16_29 VGND VGND VPWR VPWR sky130_fd_sc_hd__decap_3
XFILLER_25_438 VGND VGND VPWR VPWR sky130_fd_sc_hd__decap_3
XFILLER_25_449 VGND VGND VPWR VPWR sky130_fd_sc_hd__decap_3
XFILLER_37_287 VGND VGND VPWR VPWR sky130_fd_sc_hd__decap_3
XFILLER_65_585 VGND VGND VPWR VPWR sky130_fd_sc_hd__decap_3
X_8752_ _8753_/CLK _8752_/D load_slew642/X VGND VGND VPWR VPWR _8752_/Q sky130_fd_sc_hd__dfrtp_2
X_7703_ _8766_/CLK _7703_/D wire574/X VGND VGND VPWR VPWR _7703_/Q sky130_fd_sc_hd__dfrtp_2
X_5964_ _8044_/D _8048_/D VGND VGND VPWR VPWR _5964_/Y sky130_fd_sc_hd__xnor2_2
XFILLER_52_279 VGND VGND VPWR VPWR sky130_fd_sc_hd__decap_3
XTAP_TAPCELL_ROW_23_617 VGND VPWR sky130_fd_sc_hd__tapvpwrvgnd_1
X_8683_ _8683_/CLK _8683_/D fanout566/X VGND VGND VPWR VPWR _8683_/Q sky130_fd_sc_hd__dfrtp_2
X_5895_ _5947_/A VGND VGND VPWR VPWR _5895_/X sky130_fd_sc_hd__clkbuf_1
X_4915_ _4915_/A VGND VGND VPWR VPWR _7550_/D sky130_fd_sc_hd__buf_1
XFILLER_21_644 VGND VGND VPWR VPWR sky130_fd_sc_hd__decap_3
X_7634_ _8697_/CLK _7634_/D load_slew724/X VGND VGND VPWR VPWR _7634_/Q sky130_fd_sc_hd__dfrtp_2
X_4846_ _4845_/X _4846_/A1 _4862_/S VGND VGND VPWR VPWR _4847_/A sky130_fd_sc_hd__mux2_2
X_7565_ _8790_/CLK _7565_/D fanout672/X VGND VGND VPWR VPWR _7565_/Q sky130_fd_sc_hd__dfrtp_2
X_6516_ _5003_/X _8310_/Q _6528_/S VGND VGND VPWR VPWR _6517_/A sky130_fd_sc_hd__mux2_2
X_4777_ _4777_/A VGND VGND VPWR VPWR _4777_/X sky130_fd_sc_hd__buf_1
XFILLER_106_204 VGND VGND VPWR VPWR sky130_fd_sc_hd__decap_3
XFILLER_107_727 VGND VGND VPWR VPWR sky130_fd_sc_hd__fill_1
XFILLER_113_9 VGND VGND VPWR VPWR sky130_fd_sc_hd__decap_3
XFILLER_119_598 VGND VGND VPWR VPWR sky130_fd_sc_hd__decap_3
X_3728_ _6314_/C _3728_/B VGND VGND VPWR VPWR _5963_/B sky130_fd_sc_hd__xnor2_2
X_7496_ _7496_/A VGND VGND VPWR VPWR _8803_/D sky130_fd_sc_hd__buf_1
XFILLER_107_749 VGND VGND VPWR VPWR sky130_fd_sc_hd__fill_2
XFILLER_134_557 VGND VGND VPWR VPWR sky130_fd_sc_hd__decap_3
XTAP_TAPCELL_ROW_132_2141 VGND VPWR sky130_fd_sc_hd__tapvpwrvgnd_1
X_6447_ _4866_/X hold978/X _6461_/S VGND VGND VPWR VPWR _6448_/A sky130_fd_sc_hd__mux2_1
X_6378_ _6378_/A VGND VGND VPWR VPWR _8245_/D sky130_fd_sc_hd__buf_2
XFILLER_115_782 VGND VGND VPWR VPWR sky130_fd_sc_hd__fill_2
XFILLER_87_110 VGND VGND VPWR VPWR sky130_fd_sc_hd__fill_2
XFILLER_88_611 VGND VGND VPWR VPWR sky130_fd_sc_hd__decap_3
X_8117_ _8684_/CLK _8117_/D load_slew558/X VGND VGND VPWR VPWR _8117_/Q sky130_fd_sc_hd__dfrtp_2
X_5329_ _7717_/Q _4933_/X _5331_/S VGND VGND VPWR VPWR _5330_/A sky130_fd_sc_hd__mux2_2
XFILLER_130_752 VGND VGND VPWR VPWR sky130_fd_sc_hd__decap_3
XFILLER_130_763 VGND VGND VPWR VPWR sky130_fd_sc_hd__decap_3
XFILLER_87_154 VGND VGND VPWR VPWR sky130_fd_sc_hd__decap_3
XFILLER_130_796 VGND VGND VPWR VPWR sky130_fd_sc_hd__decap_3
XFILLER_57_47 VGND VGND VPWR VPWR sky130_fd_sc_hd__decap_3
XFILLER_75_305 VGND VGND VPWR VPWR sky130_fd_sc_hd__decap_3
XFILLER_87_187 VGND VGND VPWR VPWR sky130_fd_sc_hd__decap_3
X_8048_ _8803_/CLK _8048_/D wire547/X VGND VGND VPWR VPWR _8048_/Q sky130_fd_sc_hd__dfrtp_2
XTAP_TAPCELL_ROW_3_331 VGND VPWR sky130_fd_sc_hd__tapvpwrvgnd_1
XFILLER_113_86 VGND VGND VPWR VPWR sky130_fd_sc_hd__decap_3
XFILLER_44_736 VGND VGND VPWR VPWR sky130_fd_sc_hd__decap_3
XFILLER_56_596 VGND VGND VPWR VPWR sky130_fd_sc_hd__decap_3
XFILLER_83_393 VGND VGND VPWR VPWR sky130_fd_sc_hd__decap_3
XFILLER_12_622 VGND VGND VPWR VPWR sky130_fd_sc_hd__decap_3
XFILLER_24_471 VGND VGND VPWR VPWR sky130_fd_sc_hd__decap_3
XFILLER_11_132 VGND VGND VPWR VPWR sky130_fd_sc_hd__decap_3
XFILLER_12_655 VGND VGND VPWR VPWR sky130_fd_sc_hd__decap_3
XFILLER_51_290 VGND VGND VPWR VPWR sky130_fd_sc_hd__decap_3
XFILLER_8_604 VGND VGND VPWR VPWR sky130_fd_sc_hd__decap_3
XTAP_TAPCELL_ROW_61_1147 VGND VPWR sky130_fd_sc_hd__tapvpwrvgnd_1
XFILLER_129_329 VGND VGND VPWR VPWR sky130_fd_sc_hd__decap_3
XFILLER_8_637 VGND VGND VPWR VPWR sky130_fd_sc_hd__decap_3
XFILLER_11_198 VGND VGND VPWR VPWR sky130_fd_sc_hd__decap_3
XFILLER_22_50 VGND VGND VPWR VPWR sky130_fd_sc_hd__decap_3
XFILLER_8_648 VGND VGND VPWR VPWR sky130_fd_sc_hd__decap_3
XTAP_TAPCELL_ROW_50_992 VGND VPWR sky130_fd_sc_hd__tapvpwrvgnd_1
XFILLER_125_502 VGND VGND VPWR VPWR sky130_fd_sc_hd__fill_2
XFILLER_22_83 VGND VGND VPWR VPWR sky130_fd_sc_hd__fill_1
XTAP_TAPCELL_ROW_117_1925 VGND VPWR sky130_fd_sc_hd__tapvpwrvgnd_1
XTAP_TAPCELL_ROW_117_1936 VGND VPWR sky130_fd_sc_hd__tapvpwrvgnd_1
XFILLER_106_760 VGND VGND VPWR VPWR sky130_fd_sc_hd__decap_3
XFILLER_98_419 VGND VGND VPWR VPWR sky130_fd_sc_hd__fill_1
XFILLER_112_229 VGND VGND VPWR VPWR sky130_fd_sc_hd__decap_3
XFILLER_105_281 VGND VGND VPWR VPWR sky130_fd_sc_hd__decap_3
XFILLER_120_273 VGND VGND VPWR VPWR sky130_fd_sc_hd__decap_3
XFILLER_78_176 VGND VGND VPWR VPWR sky130_fd_sc_hd__decap_3
XFILLER_93_113 VGND VGND VPWR VPWR sky130_fd_sc_hd__decap_3
XTAP_TAPCELL_ROW_72_1298 VGND VPWR sky130_fd_sc_hd__tapvpwrvgnd_1
XFILLER_47_552 VGND VGND VPWR VPWR sky130_fd_sc_hd__decap_3
XFILLER_62_522 VGND VGND VPWR VPWR sky130_fd_sc_hd__fill_1
XFILLER_62_533 VGND VGND VPWR VPWR sky130_fd_sc_hd__decap_3
XFILLER_74_371 VGND VGND VPWR VPWR sky130_fd_sc_hd__decap_3
XFILLER_62_555 VGND VGND VPWR VPWR sky130_fd_sc_hd__decap_3
XFILLER_34_279 VGND VGND VPWR VPWR sky130_fd_sc_hd__decap_3
XFILLER_15_493 VGND VGND VPWR VPWR sky130_fd_sc_hd__decap_3
X_5680_ _5680_/A VGND VGND VPWR VPWR _5849_/S sky130_fd_sc_hd__clkbuf_2
X_4700_ _4691_/X _4700_/A1 _4736_/S VGND VGND VPWR VPWR _4701_/A sky130_fd_sc_hd__mux2_2
XFILLER_30_452 VGND VGND VPWR VPWR sky130_fd_sc_hd__decap_3
XFILLER_30_474 VGND VGND VPWR VPWR sky130_fd_sc_hd__fill_2
XFILLER_8_41 VGND VGND VPWR VPWR sky130_fd_sc_hd__decap_3
X_4631_ _7958_/Q _4631_/A2 _4630_/X _4633_/A wire326/X VGND VGND VPWR VPWR _4631_/X
+ sky130_fd_sc_hd__o221a_2
XFILLER_8_74 VGND VGND VPWR VPWR sky130_fd_sc_hd__decap_3
XFILLER_8_85 VGND VGND VPWR VPWR sky130_fd_sc_hd__decap_3
X_7350_ _7350_/A VGND VGND VPWR VPWR _8733_/D sky130_fd_sc_hd__buf_1
X_4562_ _8772_/Q _7547_/Q _4568_/S VGND VGND VPWR VPWR _4562_/X sky130_fd_sc_hd__mux2_2
X_7281_ _5907_/A _4941_/X _7269_/A _7270_/A hold847/X VGND VGND VPWR VPWR _8701_/D
+ sky130_fd_sc_hd__a32o_2
X_6301_ _6301_/A VGND VGND VPWR VPWR _8209_/D sky130_fd_sc_hd__buf_6
X_4493_ _8684_/Q _3969_/X _4492_/X VGND VGND VPWR VPWR _4493_/X sky130_fd_sc_hd__o21a_2
XFILLER_131_505 VGND VGND VPWR VPWR sky130_fd_sc_hd__decap_3
X_6232_ _6232_/A VGND VGND VPWR VPWR _8176_/D sky130_fd_sc_hd__buf_6
XFILLER_131_538 VGND VGND VPWR VPWR sky130_fd_sc_hd__decap_3
XFILLER_69_143 VGND VGND VPWR VPWR sky130_fd_sc_hd__fill_1
X_6163_ _4985_/X _8144_/Q _6163_/S VGND VGND VPWR VPWR _6164_/A sky130_fd_sc_hd__mux2_4
X_6094_ _6094_/A VGND VGND VPWR VPWR _8112_/D sky130_fd_sc_hd__buf_1
X_5114_ _4849_/X _7616_/Q _5116_/S VGND VGND VPWR VPWR _5115_/A sky130_fd_sc_hd__mux2_2
XFILLER_111_284 VGND VGND VPWR VPWR sky130_fd_sc_hd__fill_2
XFILLER_85_669 VGND VGND VPWR VPWR sky130_fd_sc_hd__decap_3
Xload_slew584 fanout583/X VGND VGND VPWR VPWR load_slew584/X sky130_fd_sc_hd__buf_2
X_5045_ _4711_/X _7583_/Q _5053_/S VGND VGND VPWR VPWR _5046_/A sky130_fd_sc_hd__mux2_2
XFILLER_27_39 VGND VGND VPWR VPWR sky130_fd_sc_hd__decap_3
XFILLER_38_563 VGND VGND VPWR VPWR sky130_fd_sc_hd__decap_3
XFILLER_53_511 VGND VGND VPWR VPWR sky130_fd_sc_hd__decap_3
XFILLER_65_371 VGND VGND VPWR VPWR sky130_fd_sc_hd__decap_3
XFILLER_65_393 VGND VGND VPWR VPWR sky130_fd_sc_hd__fill_2
XFILLER_25_257 VGND VGND VPWR VPWR sky130_fd_sc_hd__decap_3
XFILLER_26_769 VGND VGND VPWR VPWR sky130_fd_sc_hd__decap_3
XFILLER_53_544 VGND VGND VPWR VPWR sky130_fd_sc_hd__decap_3
X_8804_ _8804_/CLK _8804_/D fanout498/X VGND VGND VPWR VPWR _8804_/Q sky130_fd_sc_hd__dfrtp_2
X_6996_ _4929_/X _8536_/Q _7000_/S VGND VGND VPWR VPWR _6997_/A sky130_fd_sc_hd__mux2_4
XFILLER_53_577 VGND VGND VPWR VPWR sky130_fd_sc_hd__decap_3
XFILLER_80_363 VGND VGND VPWR VPWR sky130_fd_sc_hd__fill_1
XTAP_TAPCELL_ROW_101_1704 VGND VPWR sky130_fd_sc_hd__tapvpwrvgnd_1
XTAP_TAPCELL_ROW_36_797 VGND VPWR sky130_fd_sc_hd__tapvpwrvgnd_1
X_8735_ _8735_/CLK _8735_/D fanout539/X VGND VGND VPWR VPWR _8735_/Q sky130_fd_sc_hd__dfrtp_2
X_5947_ _5947_/A VGND VGND VPWR VPWR _5947_/X sky130_fd_sc_hd__clkbuf_1
XFILLER_33_290 VGND VGND VPWR VPWR sky130_fd_sc_hd__decap_3
XFILLER_40_238 VGND VGND VPWR VPWR sky130_fd_sc_hd__decap_3
X_8666_ _8669_/CLK _8666_/D load_slew645/X VGND VGND VPWR VPWR _8666_/Q sky130_fd_sc_hd__dfrtp_2
XFILLER_21_452 VGND VGND VPWR VPWR sky130_fd_sc_hd__decap_3
XFILLER_21_463 VGND VGND VPWR VPWR sky130_fd_sc_hd__fill_1
X_7617_ _8518_/CLK _7617_/D fanout703/X VGND VGND VPWR VPWR _7617_/Q sky130_fd_sc_hd__dfrtp_2
X_5878_ _5880_/A1 _5879_/A2 _5019_/X _5879_/B1 hold757/X VGND VGND VPWR VPWR _7980_/D
+ sky130_fd_sc_hd__a32o_2
X_8597_ _8597_/CLK _8597_/D fanout705/X VGND VGND VPWR VPWR _8597_/Q sky130_fd_sc_hd__dfrtp_2
X_4829_ _4829_/A VGND VGND VPWR VPWR _4829_/X sky130_fd_sc_hd__clkbuf_1
XFILLER_135_800 VGND VGND VPWR VPWR sky130_fd_sc_hd__decap_3
XFILLER_5_629 VGND VGND VPWR VPWR sky130_fd_sc_hd__decap_3
Xclkbuf_leaf_147_CLK clkbuf_leaf_3_CLK/A VGND VGND VPWR VPWR _8328_/CLK sky130_fd_sc_hd__clkbuf_8
X_7548_ _8773_/CLK _7548_/D load_slew738/X VGND VGND VPWR VPWR _7548_/Q sky130_fd_sc_hd__dfrtp_2
XFILLER_111_6 VGND VGND VPWR VPWR sky130_fd_sc_hd__fill_1
XFILLER_134_321 VGND VGND VPWR VPWR sky130_fd_sc_hd__decap_3
XFILLER_4_139 VGND VGND VPWR VPWR sky130_fd_sc_hd__fill_1
X_7479_ _4999_/X _8795_/Q _7495_/S VGND VGND VPWR VPWR _7480_/A sky130_fd_sc_hd__mux2_2
XFILLER_134_365 VGND VGND VPWR VPWR sky130_fd_sc_hd__decap_3
XTAP_TAPCELL_ROW_8_401 VGND VPWR sky130_fd_sc_hd__tapvpwrvgnd_1
XFILLER_108_64 VGND VGND VPWR VPWR sky130_fd_sc_hd__decap_3
XFILLER_134_398 VGND VGND VPWR VPWR sky130_fd_sc_hd__decap_3
XFILLER_68_35 VGND VGND VPWR VPWR sky130_fd_sc_hd__decap_3
XFILLER_103_741 VGND VGND VPWR VPWR sky130_fd_sc_hd__decap_3
XTAP_TAPCELL_ROW_112_1855 VGND VPWR sky130_fd_sc_hd__tapvpwrvgnd_1
XTAP_TAPCELL_ROW_112_1866 VGND VPWR sky130_fd_sc_hd__tapvpwrvgnd_1
XFILLER_102_251 VGND VGND VPWR VPWR sky130_fd_sc_hd__fill_1
XFILLER_103_785 VGND VGND VPWR VPWR sky130_fd_sc_hd__decap_3
XFILLER_130_560 VGND VGND VPWR VPWR sky130_fd_sc_hd__decap_3
XFILLER_48_305 VGND VGND VPWR VPWR sky130_fd_sc_hd__decap_3
XFILLER_75_102 VGND VGND VPWR VPWR sky130_fd_sc_hd__decap_3
XFILLER_124_41 VGND VGND VPWR VPWR sky130_fd_sc_hd__decap_3
XFILLER_75_113 VGND VGND VPWR VPWR sky130_fd_sc_hd__decap_3
XFILLER_124_85 VGND VGND VPWR VPWR sky130_fd_sc_hd__decap_3
XFILLER_75_157 VGND VGND VPWR VPWR sky130_fd_sc_hd__decap_3
XFILLER_17_747 VGND VGND VPWR VPWR sky130_fd_sc_hd__decap_3
XFILLER_29_585 VGND VGND VPWR VPWR sky130_fd_sc_hd__decap_3
XFILLER_44_522 VGND VGND VPWR VPWR sky130_fd_sc_hd__decap_3
XFILLER_44_533 VGND VGND VPWR VPWR sky130_fd_sc_hd__decap_3
XFILLER_56_371 VGND VGND VPWR VPWR sky130_fd_sc_hd__decap_3
XFILLER_16_235 VGND VGND VPWR VPWR sky130_fd_sc_hd__decap_3
XFILLER_17_72 VGND VGND VPWR VPWR sky130_fd_sc_hd__decap_3
XFILLER_44_599 VGND VGND VPWR VPWR sky130_fd_sc_hd__fill_2
XFILLER_71_385 VGND VGND VPWR VPWR sky130_fd_sc_hd__fill_1
XFILLER_12_430 VGND VGND VPWR VPWR sky130_fd_sc_hd__decap_3
XFILLER_71_396 VGND VGND VPWR VPWR sky130_fd_sc_hd__decap_3
XFILLER_12_463 VGND VGND VPWR VPWR sky130_fd_sc_hd__decap_3
XFILLER_33_60 VGND VGND VPWR VPWR sky130_fd_sc_hd__decap_3
XFILLER_129_137 VGND VGND VPWR VPWR sky130_fd_sc_hd__decap_3
XFILLER_12_485 VGND VGND VPWR VPWR sky130_fd_sc_hd__decap_3
XFILLER_12_496 VGND VGND VPWR VPWR sky130_fd_sc_hd__decap_3
XFILLER_76_9 VGND VGND VPWR VPWR sky130_fd_sc_hd__fill_1
XFILLER_8_434 VGND VGND VPWR VPWR sky130_fd_sc_hd__decap_3
Xclkbuf_leaf_138_CLK clkbuf_5_4__f_CLK/X VGND VGND VPWR VPWR _8737_/CLK sky130_fd_sc_hd__clkbuf_8
XFILLER_4_640 VGND VGND VPWR VPWR sky130_fd_sc_hd__decap_3
XFILLER_4_651 VGND VGND VPWR VPWR sky130_fd_sc_hd__decap_3
XTAP_TAPCELL_ROW_74_1327 VGND VPWR sky130_fd_sc_hd__tapvpwrvgnd_1
XFILLER_125_376 VGND VGND VPWR VPWR sky130_fd_sc_hd__decap_3
XFILLER_4_684 VGND VGND VPWR VPWR sky130_fd_sc_hd__decap_3
XFILLER_67_669 VGND VGND VPWR VPWR sky130_fd_sc_hd__decap_3
XFILLER_94_455 VGND VGND VPWR VPWR sky130_fd_sc_hd__decap_3
XFILLER_94_477 VGND VGND VPWR VPWR sky130_fd_sc_hd__decap_3
XFILLER_75_691 VGND VGND VPWR VPWR sky130_fd_sc_hd__decap_3
XFILLER_47_393 VGND VGND VPWR VPWR sky130_fd_sc_hd__decap_3
X_6850_ _6850_/A VGND VGND VPWR VPWR _8466_/D sky130_fd_sc_hd__buf_6
XFILLER_90_694 VGND VGND VPWR VPWR sky130_fd_sc_hd__fill_2
XPHY_EDGE_ROW_8_Right_8 VGND VGND VPWR VPWR sky130_fd_sc_hd__decap_3
XTAP_TAPCELL_ROW_85_1478 VGND VPWR sky130_fd_sc_hd__tapvpwrvgnd_1
XTAP_TAPCELL_ROW_85_1489 VGND VPWR sky130_fd_sc_hd__tapvpwrvgnd_1
X_6781_ _6781_/A VGND VGND VPWR VPWR _8434_/D sky130_fd_sc_hd__buf_2
X_5801_ _5801_/A0 _4845_/A _5805_/S VGND VGND VPWR VPWR _5802_/A sky130_fd_sc_hd__mux2_2
XFILLER_50_536 VGND VGND VPWR VPWR sky130_fd_sc_hd__decap_3
X_3993_ _3993_/A _3993_/B VGND VGND VPWR VPWR _3993_/X sky130_fd_sc_hd__or2_2
X_8520_ _8763_/CLK _8520_/D wire555/X VGND VGND VPWR VPWR _8520_/Q sky130_fd_sc_hd__dfrtp_2
X_5732_ _7906_/Q _4707_/A _5742_/S VGND VGND VPWR VPWR _5733_/A sky130_fd_sc_hd__mux2_2
XFILLER_31_772 VGND VGND VPWR VPWR sky130_fd_sc_hd__fill_1
XTAP_TAPCELL_ROW_33_756 VGND VPWR sky130_fd_sc_hd__tapvpwrvgnd_1
XFILLER_31_794 VGND VGND VPWR VPWR sky130_fd_sc_hd__fill_2
X_8451_ _8775_/CLK _8451_/D load_slew727/X VGND VGND VPWR VPWR _8451_/Q sky130_fd_sc_hd__dfrtp_2
X_5663_ _7874_/Q _4913_/A _5675_/S VGND VGND VPWR VPWR _5664_/A sky130_fd_sc_hd__mux2_2
XFILLER_129_671 VGND VGND VPWR VPWR sky130_fd_sc_hd__fill_1
XFILLER_30_293 VGND VGND VPWR VPWR sky130_fd_sc_hd__decap_3
XTAP_TAPCELL_ROW_13_480 VGND VPWR sky130_fd_sc_hd__tapvpwrvgnd_1
Xclkbuf_leaf_129_CLK clkload2/A VGND VGND VPWR VPWR _8740_/CLK sky130_fd_sc_hd__clkbuf_8
X_8382_ _8382_/CLK _8382_/D fanout675/X VGND VGND VPWR VPWR _8382_/Q sky130_fd_sc_hd__dfrtp_2
X_7402_ _7402_/A VGND VGND VPWR VPWR _8758_/D sky130_fd_sc_hd__buf_1
X_5594_ _7841_/Q _4773_/A _5612_/S VGND VGND VPWR VPWR _5595_/A sky130_fd_sc_hd__mux2_2
X_4614_ _8037_/Q _3995_/B _4648_/B1 _7956_/Q _4669_/S VGND VGND VPWR VPWR _4614_/X
+ sky130_fd_sc_hd__o221a_2
XFILLER_116_321 VGND VGND VPWR VPWR sky130_fd_sc_hd__decap_3
XFILLER_129_682 VGND VGND VPWR VPWR sky130_fd_sc_hd__decap_3
X_7333_ _7333_/A VGND VGND VPWR VPWR _8725_/D sky130_fd_sc_hd__buf_1
X_4545_ _3828_/X _4544_/X _4545_/B1 VGND VGND VPWR VPWR _4545_/X sky130_fd_sc_hd__o21a_2
XFILLER_116_365 VGND VGND VPWR VPWR sky130_fd_sc_hd__decap_3
XFILLER_128_192 VGND VGND VPWR VPWR sky130_fd_sc_hd__decap_3
XFILLER_131_302 VGND VGND VPWR VPWR sky130_fd_sc_hd__decap_3
Xmax_cap186 _5908_/X VGND VGND VPWR VPWR _5919_/A2 sky130_fd_sc_hd__buf_2
X_7264_ _7254_/X _4883_/X _7266_/A3 _7266_/B1 hold806/X VGND VGND VPWR VPWR _8687_/D
+ sky130_fd_sc_hd__a32o_2
X_4476_ _8358_/Q _3767_/A _3817_/A _8277_/Q _3758_/A VGND VGND VPWR VPWR _4476_/X
+ sky130_fd_sc_hd__o221a_2
XFILLER_131_346 VGND VGND VPWR VPWR sky130_fd_sc_hd__decap_3
XPHY_EDGE_ROW_39_Right_39 VGND VGND VPWR VPWR sky130_fd_sc_hd__decap_3
Xmax_cap197 _5118_/A VGND VGND VPWR VPWR _5160_/S sky130_fd_sc_hd__buf_2
X_7195_ _7189_/X _4999_/X _7201_/A3 wire207/X hold879/X VGND VGND VPWR VPWR _8633_/D
+ sky130_fd_sc_hd__a32o_2
X_6215_ _6215_/A VGND VGND VPWR VPWR _8168_/D sky130_fd_sc_hd__buf_6
X_6146_ _6146_/A VGND VGND VPWR VPWR _8135_/D sky130_fd_sc_hd__buf_6
XFILLER_38_49 VGND VGND VPWR VPWR sky130_fd_sc_hd__fill_1
XFILLER_57_113 VGND VGND VPWR VPWR sky130_fd_sc_hd__fill_1
XFILLER_85_444 VGND VGND VPWR VPWR sky130_fd_sc_hd__decap_3
XFILLER_100_766 VGND VGND VPWR VPWR sky130_fd_sc_hd__decap_3
XFILLER_73_617 VGND VGND VPWR VPWR sky130_fd_sc_hd__fill_2
XTAP_TAPCELL_ROW_127_2073 VGND VPWR sky130_fd_sc_hd__tapvpwrvgnd_1
X_6077_ _8104_/Q _4814_/A _6095_/S VGND VGND VPWR VPWR _6078_/A sky130_fd_sc_hd__mux2_2
XFILLER_26_500 VGND VGND VPWR VPWR sky130_fd_sc_hd__decap_3
X_5028_ _5027_/X _7577_/Q _5028_/S VGND VGND VPWR VPWR _5029_/A sky130_fd_sc_hd__mux2_2
XFILLER_26_533 VGND VGND VPWR VPWR sky130_fd_sc_hd__decap_3
XFILLER_65_190 VGND VGND VPWR VPWR sky130_fd_sc_hd__decap_3
XFILLER_41_547 VGND VGND VPWR VPWR sky130_fd_sc_hd__decap_3
XPHY_EDGE_ROW_48_Right_48 VGND VGND VPWR VPWR sky130_fd_sc_hd__decap_3
X_6979_ _4895_/X _8528_/Q _6979_/S VGND VGND VPWR VPWR _6980_/A sky130_fd_sc_hd__mux2_4
XFILLER_110_65 VGND VGND VPWR VPWR sky130_fd_sc_hd__decap_3
XFILLER_110_76 VGND VGND VPWR VPWR sky130_fd_sc_hd__decap_3
X_8718_ _8799_/CLK _8718_/D fanout595/A VGND VGND VPWR VPWR _8718_/Q sky130_fd_sc_hd__dfrtp_2
XFILLER_21_271 VGND VGND VPWR VPWR sky130_fd_sc_hd__decap_3
X_8649_ _8649_/CLK _8649_/D wire531/X VGND VGND VPWR VPWR _8649_/Q sky130_fd_sc_hd__dfrtp_2
XFILLER_119_30 VGND VGND VPWR VPWR sky130_fd_sc_hd__decap_3
XFILLER_119_63 VGND VGND VPWR VPWR sky130_fd_sc_hd__fill_2
XFILLER_126_118 VGND VGND VPWR VPWR sky130_fd_sc_hd__decap_3
XFILLER_107_343 VGND VGND VPWR VPWR sky130_fd_sc_hd__decap_3
XFILLER_119_192 VGND VGND VPWR VPWR sky130_fd_sc_hd__decap_3
XFILLER_119_74 VGND VGND VPWR VPWR sky130_fd_sc_hd__decap_3
XFILLER_135_663 VGND VGND VPWR VPWR sky130_fd_sc_hd__decap_3
XFILLER_134_162 VGND VGND VPWR VPWR sky130_fd_sc_hd__decap_3
XFILLER_135_696 VGND VGND VPWR VPWR sky130_fd_sc_hd__decap_3
XFILLER_1_610 VGND VGND VPWR VPWR sky130_fd_sc_hd__decap_3
XPHY_EDGE_ROW_57_Right_57 VGND VGND VPWR VPWR sky130_fd_sc_hd__decap_3
XFILLER_122_357 VGND VGND VPWR VPWR sky130_fd_sc_hd__decap_3
XFILLER_134_195 VGND VGND VPWR VPWR sky130_fd_sc_hd__fill_1
XFILLER_1_632 VGND VGND VPWR VPWR sky130_fd_sc_hd__decap_3
XFILLER_89_750 VGND VGND VPWR VPWR sky130_fd_sc_hd__decap_3
XTAP_TAPCELL_ROW_56_1079 VGND VPWR sky130_fd_sc_hd__tapvpwrvgnd_1
Xhold990 _7550_/Q VGND VGND VPWR VPWR hold990/X sky130_fd_sc_hd__dlygate4sd3_1
XFILLER_110_508 VGND VGND VPWR VPWR sky130_fd_sc_hd__decap_3
XFILLER_1_665 VGND VGND VPWR VPWR sky130_fd_sc_hd__decap_3
XFILLER_1_676 VGND VGND VPWR VPWR sky130_fd_sc_hd__decap_3
XFILLER_49_625 VGND VGND VPWR VPWR sky130_fd_sc_hd__fill_2
XFILLER_89_772 VGND VGND VPWR VPWR sky130_fd_sc_hd__decap_3
XFILLER_0_197 VGND VGND VPWR VPWR sky130_fd_sc_hd__decap_3
XFILLER_103_582 VGND VGND VPWR VPWR sky130_fd_sc_hd__fill_1
XFILLER_76_433 VGND VGND VPWR VPWR sky130_fd_sc_hd__fill_1
XFILLER_95_66 VGND VGND VPWR VPWR sky130_fd_sc_hd__decap_3
XFILLER_17_500 VGND VGND VPWR VPWR sky130_fd_sc_hd__decap_3
XFILLER_17_511 VGND VGND VPWR VPWR sky130_fd_sc_hd__fill_2
XFILLER_48_179 VGND VGND VPWR VPWR sky130_fd_sc_hd__decap_3
XFILLER_63_116 VGND VGND VPWR VPWR sky130_fd_sc_hd__fill_2
XFILLER_29_393 VGND VGND VPWR VPWR sky130_fd_sc_hd__fill_1
XFILLER_91_458 VGND VGND VPWR VPWR sky130_fd_sc_hd__decap_3
XFILLER_17_566 VGND VGND VPWR VPWR sky130_fd_sc_hd__fill_1
XPHY_EDGE_ROW_66_Right_66 VGND VGND VPWR VPWR sky130_fd_sc_hd__decap_3
XFILLER_44_385 VGND VGND VPWR VPWR sky130_fd_sc_hd__fill_2
XFILLER_13_750 VGND VGND VPWR VPWR sky130_fd_sc_hd__decap_3
XFILLER_13_783 VGND VGND VPWR VPWR sky130_fd_sc_hd__fill_1
XFILLER_13_794 VGND VGND VPWR VPWR sky130_fd_sc_hd__fill_2
XFILLER_40_580 VGND VGND VPWR VPWR sky130_fd_sc_hd__decap_3
XFILLER_8_220 VGND VGND VPWR VPWR sky130_fd_sc_hd__fill_1
XFILLER_9_721 VGND VGND VPWR VPWR sky130_fd_sc_hd__decap_3
XFILLER_9_732 VGND VGND VPWR VPWR sky130_fd_sc_hd__decap_3
XTAP_TAPCELL_ROW_30_715 VGND VPWR sky130_fd_sc_hd__tapvpwrvgnd_1
XFILLER_118_608 VGND VGND VPWR VPWR sky130_fd_sc_hd__decap_3
XFILLER_9_765 VGND VGND VPWR VPWR sky130_fd_sc_hd__decap_3
XFILLER_99_503 VGND VGND VPWR VPWR sky130_fd_sc_hd__fill_1
XPHY_EDGE_ROW_75_Right_75 VGND VGND VPWR VPWR sky130_fd_sc_hd__decap_3
XFILLER_5_42 VGND VGND VPWR VPWR sky130_fd_sc_hd__decap_3
X_4330_ _4330_/A _4330_/B VGND VGND VPWR VPWR _4330_/X sky130_fd_sc_hd__or2_2
XFILLER_113_346 VGND VGND VPWR VPWR sky130_fd_sc_hd__decap_3
XFILLER_5_75 VGND VGND VPWR VPWR sky130_fd_sc_hd__decap_3
X_4261_ _4261_/A _4261_/B VGND VGND VPWR VPWR _4261_/X sky130_fd_sc_hd__or2_2
XFILLER_86_219 VGND VGND VPWR VPWR sky130_fd_sc_hd__decap_3
X_6000_ _6000_/A VGND VGND VPWR VPWR _8067_/D sky130_fd_sc_hd__buf_1
XFILLER_39_113 VGND VGND VPWR VPWR sky130_fd_sc_hd__fill_2
XFILLER_79_293 VGND VGND VPWR VPWR sky130_fd_sc_hd__fill_1
X_4192_ _7757_/Q _7838_/Q _7919_/Q _8000_/Q _4197_/S _4198_/A VGND VGND VPWR VPWR
+ _4192_/X sky130_fd_sc_hd__mux4_2
XFILLER_94_230 VGND VGND VPWR VPWR sky130_fd_sc_hd__fill_1
XTAP_TAPCELL_ROW_87_1507 VGND VPWR sky130_fd_sc_hd__tapvpwrvgnd_1
XFILLER_54_127 VGND VGND VPWR VPWR sky130_fd_sc_hd__decap_3
XFILLER_55_639 VGND VGND VPWR VPWR sky130_fd_sc_hd__fill_2
XFILLER_82_403 VGND VGND VPWR VPWR sky130_fd_sc_hd__decap_3
XPHY_EDGE_ROW_84_Right_84 VGND VGND VPWR VPWR sky130_fd_sc_hd__decap_3
XTAP_TAPCELL_ROW_38_826 VGND VPWR sky130_fd_sc_hd__tapvpwrvgnd_1
X_7951_ _8771_/CLK _7951_/D fanout576/X VGND VGND VPWR VPWR _7951_/Q sky130_fd_sc_hd__dfrtp_2
XFILLER_47_190 VGND VGND VPWR VPWR sky130_fd_sc_hd__decap_3
XFILLER_48_691 VGND VGND VPWR VPWR sky130_fd_sc_hd__decap_3
X_7882_ _8621_/CLK _7882_/D fanout681/X VGND VGND VPWR VPWR _7882_/Q sky130_fd_sc_hd__dfrtp_2
X_6902_ _4740_/X _8491_/Q _6916_/S VGND VGND VPWR VPWR _6903_/A sky130_fd_sc_hd__mux2_4
XFILLER_23_514 VGND VGND VPWR VPWR sky130_fd_sc_hd__decap_3
XFILLER_63_661 VGND VGND VPWR VPWR sky130_fd_sc_hd__fill_1
XTAP_TAPCELL_ROW_18_550 VGND VPWR sky130_fd_sc_hd__tapvpwrvgnd_1
X_6833_ _6833_/A VGND VGND VPWR VPWR _7002_/S sky130_fd_sc_hd__buf_6
XFILLER_24_18 VGND VGND VPWR VPWR sky130_fd_sc_hd__decap_3
XFILLER_24_29 VGND VGND VPWR VPWR sky130_fd_sc_hd__decap_3
XFILLER_62_171 VGND VGND VPWR VPWR sky130_fd_sc_hd__decap_3
X_3976_ _4460_/A VGND VGND VPWR VPWR _3976_/X sky130_fd_sc_hd__clkbuf_2
X_6764_ _6764_/A VGND VGND VPWR VPWR _8426_/D sky130_fd_sc_hd__buf_2
X_8503_ _8668_/CLK _8503_/D wire638/X VGND VGND VPWR VPWR _8503_/Q sky130_fd_sc_hd__dfrtp_2
X_6695_ _6695_/A VGND VGND VPWR VPWR _8393_/D sky130_fd_sc_hd__buf_2
X_5715_ _7898_/Q _5015_/A _5721_/S VGND VGND VPWR VPWR _5716_/A sky130_fd_sc_hd__mux2_2
X_8434_ _8593_/CLK _8434_/D fanout709/X VGND VGND VPWR VPWR _8434_/Q sky130_fd_sc_hd__dfrtp_2
X_5646_ _7866_/Q _4879_/A _5654_/S VGND VGND VPWR VPWR _5647_/A sky130_fd_sc_hd__mux2_2
XFILLER_108_129 VGND VGND VPWR VPWR sky130_fd_sc_hd__decap_3
XPHY_EDGE_ROW_93_Right_93 VGND VGND VPWR VPWR sky130_fd_sc_hd__decap_3
XTAP_TAPCELL_ROW_98_1658 VGND VPWR sky130_fd_sc_hd__tapvpwrvgnd_1
XTAP_TAPCELL_ROW_98_1669 VGND VPWR sky130_fd_sc_hd__tapvpwrvgnd_1
XFILLER_105_803 VGND VGND VPWR VPWR sky130_fd_sc_hd__fill_1
X_8365_ _8560_/CLK _8365_/D fanout548/X VGND VGND VPWR VPWR _8365_/Q sky130_fd_sc_hd__dfrtp_2
X_5577_ hold997/X _4740_/A _5591_/S VGND VGND VPWR VPWR _5578_/A sky130_fd_sc_hd__mux2_2
XFILLER_132_622 VGND VGND VPWR VPWR sky130_fd_sc_hd__decap_3
X_8296_ _8547_/CLK _8296_/D fanout648/A VGND VGND VPWR VPWR _8296_/Q sky130_fd_sc_hd__dfrtp_2
X_7316_ _7316_/A VGND VGND VPWR VPWR _8717_/D sky130_fd_sc_hd__buf_1
X_4528_ _8769_/Q _7544_/Q _4528_/S VGND VGND VPWR VPWR _4529_/B sky130_fd_sc_hd__mux2_2
XFILLER_49_26 VGND VGND VPWR VPWR sky130_fd_sc_hd__decap_3
XFILLER_6_9 VGND VGND VPWR VPWR sky130_fd_sc_hd__decap_3
XFILLER_78_709 VGND VGND VPWR VPWR sky130_fd_sc_hd__fill_1
Xfanout700 fanout702/X VGND VGND VPWR VPWR wire701/A sky130_fd_sc_hd__clkdlybuf4s25_1
X_7247_ _7253_/A1 _4824_/X _7255_/A3 _7255_/B1 hold790/X VGND VGND VPWR VPWR _8673_/D
+ sky130_fd_sc_hd__a32o_2
X_4459_ _7780_/Q _7861_/Q _7942_/Q _8023_/Q _4554_/S _4503_/A VGND VGND VPWR VPWR
+ _4460_/B sky130_fd_sc_hd__mux4_2
XFILLER_131_143 VGND VGND VPWR VPWR sky130_fd_sc_hd__decap_3
XFILLER_132_666 VGND VGND VPWR VPWR sky130_fd_sc_hd__decap_3
XFILLER_132_699 VGND VGND VPWR VPWR sky130_fd_sc_hd__fill_1
XFILLER_58_400 VGND VGND VPWR VPWR sky130_fd_sc_hd__decap_3
XTAP_TAPCELL_ROW_129_2102 VGND VPWR sky130_fd_sc_hd__tapvpwrvgnd_1
Xfanout711 fanout716/X VGND VGND VPWR VPWR fanout711/X sky130_fd_sc_hd__clkdlybuf4s25_1
XFILLER_131_187 VGND VGND VPWR VPWR sky130_fd_sc_hd__decap_3
Xfanout744 fanout754/X VGND VGND VPWR VPWR fanout744/X sky130_fd_sc_hd__clkdlybuf4s25_1
X_7178_ _7178_/A VGND VGND VPWR VPWR _7270_/A sky130_fd_sc_hd__clkbuf_2
X_6129_ _8129_/Q _4920_/A _6137_/S VGND VGND VPWR VPWR _6130_/A sky130_fd_sc_hd__mux2_2
XFILLER_46_628 VGND VGND VPWR VPWR sky130_fd_sc_hd__decap_3
XFILLER_58_477 VGND VGND VPWR VPWR sky130_fd_sc_hd__decap_3
XFILLER_65_47 VGND VGND VPWR VPWR sky130_fd_sc_hd__decap_3
XFILLER_121_20 VGND VGND VPWR VPWR sky130_fd_sc_hd__decap_3
XFILLER_26_374 VGND VGND VPWR VPWR sky130_fd_sc_hd__decap_3
XFILLER_26_396 VGND VGND VPWR VPWR sky130_fd_sc_hd__decap_3
XFILLER_81_35 VGND VGND VPWR VPWR sky130_fd_sc_hd__decap_3
XTAP_TAPCELL_ROW_107_1787 VGND VPWR sky130_fd_sc_hd__tapvpwrvgnd_1
XFILLER_14_569 VGND VGND VPWR VPWR sky130_fd_sc_hd__decap_3
XFILLER_41_355 VGND VGND VPWR VPWR sky130_fd_sc_hd__decap_3
XFILLER_81_57 VGND VGND VPWR VPWR sky130_fd_sc_hd__decap_3
XFILLER_14_62 VGND VGND VPWR VPWR sky130_fd_sc_hd__decap_3
XFILLER_41_388 VGND VGND VPWR VPWR sky130_fd_sc_hd__decap_3
XTAP_TAPCELL_ROW_120_1976 VGND VPWR sky130_fd_sc_hd__tapvpwrvgnd_1
XFILLER_10_731 VGND VGND VPWR VPWR sky130_fd_sc_hd__decap_3
XFILLER_10_775 VGND VGND VPWR VPWR sky130_fd_sc_hd__decap_3
XFILLER_127_449 VGND VGND VPWR VPWR sky130_fd_sc_hd__decap_3
XFILLER_6_713 VGND VGND VPWR VPWR sky130_fd_sc_hd__decap_3
XTAP_TAPCELL_ROW_58_1108 VGND VPWR sky130_fd_sc_hd__tapvpwrvgnd_1
XFILLER_108_630 VGND VGND VPWR VPWR sky130_fd_sc_hd__fill_2
XFILLER_5_234 VGND VGND VPWR VPWR sky130_fd_sc_hd__decap_3
XFILLER_6_746 VGND VGND VPWR VPWR sky130_fd_sc_hd__decap_3
XFILLER_6_757 VGND VGND VPWR VPWR sky130_fd_sc_hd__decap_3
XPHY_EDGE_ROW_15_Left_151 VGND VGND VPWR VPWR sky130_fd_sc_hd__decap_3
XFILLER_123_600 VGND VGND VPWR VPWR sky130_fd_sc_hd__decap_3
XFILLER_135_460 VGND VGND VPWR VPWR sky130_fd_sc_hd__decap_3
XFILLER_107_195 VGND VGND VPWR VPWR sky130_fd_sc_hd__decap_3
XFILLER_122_121 VGND VGND VPWR VPWR sky130_fd_sc_hd__decap_3
XFILLER_123_644 VGND VGND VPWR VPWR sky130_fd_sc_hd__fill_1
XFILLER_123_666 VGND VGND VPWR VPWR sky130_fd_sc_hd__decap_3
XFILLER_123_688 VGND VGND VPWR VPWR sky130_fd_sc_hd__fill_2
XFILLER_49_411 VGND VGND VPWR VPWR sky130_fd_sc_hd__decap_3
XFILLER_103_390 VGND VGND VPWR VPWR sky130_fd_sc_hd__fill_2
XFILLER_49_455 VGND VGND VPWR VPWR sky130_fd_sc_hd__fill_1
XFILLER_92_701 VGND VGND VPWR VPWR sky130_fd_sc_hd__decap_3
XFILLER_76_274 VGND VGND VPWR VPWR sky130_fd_sc_hd__decap_3
XFILLER_92_734 VGND VGND VPWR VPWR sky130_fd_sc_hd__decap_3
XFILLER_91_233 VGND VGND VPWR VPWR sky130_fd_sc_hd__fill_1
XPHY_EDGE_ROW_24_Left_160 VGND VGND VPWR VPWR sky130_fd_sc_hd__decap_3
XTAP_TAPCELL_ROW_69_1259 VGND VPWR sky130_fd_sc_hd__tapvpwrvgnd_1
XFILLER_51_119 VGND VGND VPWR VPWR sky130_fd_sc_hd__decap_3
XFILLER_17_396 VGND VGND VPWR VPWR sky130_fd_sc_hd__decap_3
XFILLER_44_171 VGND VGND VPWR VPWR sky130_fd_sc_hd__decap_3
XFILLER_91_299 VGND VGND VPWR VPWR sky130_fd_sc_hd__decap_3
XTAP_TAPCELL_ROW_82_1437 VGND VPWR sky130_fd_sc_hd__tapvpwrvgnd_1
XFILLER_32_344 VGND VGND VPWR VPWR sky130_fd_sc_hd__decap_3
X_3830_ _8706_/Q _8787_/Q _7562_/Q _7643_/Q _3778_/S _3835_/S1 VGND VGND VPWR VPWR
+ _3831_/B sky130_fd_sc_hd__mux4_2
XFILLER_60_697 VGND VGND VPWR VPWR sky130_fd_sc_hd__decap_3
XTAP_TAPCELL_ROW_43_895 VGND VPWR sky130_fd_sc_hd__tapvpwrvgnd_1
X_3761_ _7721_/Q _7802_/Q _3778_/S VGND VGND VPWR VPWR _3761_/X sky130_fd_sc_hd__mux2_2
X_5500_ _5500_/A VGND VGND VPWR VPWR _7797_/D sky130_fd_sc_hd__buf_1
X_6480_ _4933_/X hold934/X _6482_/S VGND VGND VPWR VPWR _6481_/A sky130_fd_sc_hd__mux2_1
XFILLER_133_408 VGND VGND VPWR VPWR sky130_fd_sc_hd__decap_3
X_5431_ _5431_/A VGND VGND VPWR VPWR _7764_/D sky130_fd_sc_hd__buf_1
XFILLER_126_460 VGND VGND VPWR VPWR sky130_fd_sc_hd__fill_2
XFILLER_126_471 VGND VGND VPWR VPWR sky130_fd_sc_hd__decap_3
Xclkbuf_leaf_60_CLK clkbuf_leaf_63_CLK/A VGND VGND VPWR VPWR _8597_/CLK sky130_fd_sc_hd__clkbuf_8
X_8150_ _8795_/CLK _8150_/D fanout601/X VGND VGND VPWR VPWR _8150_/Q sky130_fd_sc_hd__dfrtp_2
X_5362_ _5362_/A VGND VGND VPWR VPWR _7731_/D sky130_fd_sc_hd__buf_1
XFILLER_114_633 VGND VGND VPWR VPWR sky130_fd_sc_hd__fill_1
X_8081_ _8729_/CLK _8081_/D load_slew489/X VGND VGND VPWR VPWR _8081_/Q sky130_fd_sc_hd__dfrtp_2
X_7101_ _4795_/X hold922/X _7109_/S VGND VGND VPWR VPWR _7102_/A sky130_fd_sc_hd__mux2_1
X_4313_ _4313_/A1 _4304_/X _4307_/X _4312_/X VGND VGND VPWR VPWR _4313_/X sky130_fd_sc_hd__o31a_2
XTAP_TAPCELL_ROW_93_1588 VGND VPWR sky130_fd_sc_hd__tapvpwrvgnd_1
XTAP_TAPCELL_ROW_93_1599 VGND VPWR sky130_fd_sc_hd__tapvpwrvgnd_1
X_7032_ _4999_/X hold948/X _7046_/S VGND VGND VPWR VPWR _7033_/A sky130_fd_sc_hd__mux2_1
X_5293_ _5293_/A VGND VGND VPWR VPWR _7699_/D sky130_fd_sc_hd__buf_1
XFILLER_114_699 VGND VGND VPWR VPWR sky130_fd_sc_hd__fill_1
XFILLER_19_18 VGND VGND VPWR VPWR sky130_fd_sc_hd__decap_3
XFILLER_99_399 VGND VGND VPWR VPWR sky130_fd_sc_hd__decap_3
X_4244_ _4330_/A _4244_/B VGND VGND VPWR VPWR _4244_/X sky130_fd_sc_hd__or2_2
XFILLER_67_252 VGND VGND VPWR VPWR sky130_fd_sc_hd__decap_3
X_4175_ _4170_/X _4171_/X _4173_/X _4174_/X VGND VGND VPWR VPWR _4175_/X sky130_fd_sc_hd__a22o_2
XFILLER_27_105 VGND VGND VPWR VPWR sky130_fd_sc_hd__decap_3
XFILLER_82_200 VGND VGND VPWR VPWR sky130_fd_sc_hd__fill_2
XFILLER_95_594 VGND VGND VPWR VPWR sky130_fd_sc_hd__decap_3
XFILLER_27_127 VGND VGND VPWR VPWR sky130_fd_sc_hd__decap_3
XFILLER_55_447 VGND VGND VPWR VPWR sky130_fd_sc_hd__fill_1
XFILLER_83_756 VGND VGND VPWR VPWR sky130_fd_sc_hd__fill_1
XTAP_TAPCELL_ROW_124_2032 VGND VPWR sky130_fd_sc_hd__tapvpwrvgnd_1
X_7934_ _8754_/CLK _7934_/D load_slew691/X VGND VGND VPWR VPWR _7934_/Q sky130_fd_sc_hd__dfrtp_2
XFILLER_70_439 VGND VGND VPWR VPWR sky130_fd_sc_hd__decap_3
X_7865_ _8029_/CLK _7865_/D load_slew572/X VGND VGND VPWR VPWR _7865_/Q sky130_fd_sc_hd__dfrtp_2
X_7796_ _8778_/CLK _7796_/D load_slew727/X VGND VGND VPWR VPWR _7796_/Q sky130_fd_sc_hd__dfrtp_2
X_6816_ _8451_/Q _4912_/A _6828_/S VGND VGND VPWR VPWR _6817_/A sky130_fd_sc_hd__mux2_2
X_6747_ _8418_/Q _4772_/A _6765_/S VGND VGND VPWR VPWR _6748_/A sky130_fd_sc_hd__mux2_2
X_3959_ _7978_/Q _4634_/A2 _4622_/B1 _7897_/Q _4000_/A VGND VGND VPWR VPWR _3959_/X
+ sky130_fd_sc_hd__o221a_2
X_6678_ _6678_/A VGND VGND VPWR VPWR _8385_/D sky130_fd_sc_hd__buf_2
XFILLER_109_449 VGND VGND VPWR VPWR sky130_fd_sc_hd__fill_2
XTAP_TAPCELL_ROW_135_2183 VGND VPWR sky130_fd_sc_hd__tapvpwrvgnd_1
XTAP_TAPCELL_ROW_21_589 VGND VPWR sky130_fd_sc_hd__tapvpwrvgnd_1
X_8417_ _8734_/CLK _8417_/D wire519/X VGND VGND VPWR VPWR _8417_/Q sky130_fd_sc_hd__dfrtp_2
X_5629_ _7858_/Q _4845_/A _5633_/S VGND VGND VPWR VPWR _5630_/A sky130_fd_sc_hd__mux2_2
XFILLER_3_727 VGND VGND VPWR VPWR sky130_fd_sc_hd__fill_1
XTAP_TAPCELL_ROW_135_2194 VGND VPWR sky130_fd_sc_hd__tapvpwrvgnd_1
Xclkbuf_leaf_51_CLK clkload4/A VGND VGND VPWR VPWR _8800_/CLK sky130_fd_sc_hd__clkbuf_8
X_8348_ _8671_/CLK _8348_/D fanout686/X VGND VGND VPWR VPWR _8348_/Q sky130_fd_sc_hd__dfrtp_2
XFILLER_132_430 VGND VGND VPWR VPWR sky130_fd_sc_hd__decap_3
XFILLER_3_738 VGND VGND VPWR VPWR sky130_fd_sc_hd__decap_3
XFILLER_4_6 VGND VGND VPWR VPWR sky130_fd_sc_hd__decap_3
XFILLER_105_688 VGND VGND VPWR VPWR sky130_fd_sc_hd__decap_3
XFILLER_132_463 VGND VGND VPWR VPWR sky130_fd_sc_hd__decap_3
XFILLER_78_528 VGND VGND VPWR VPWR sky130_fd_sc_hd__decap_3
XTAP_TAPCELL_ROW_53_1038 VGND VPWR sky130_fd_sc_hd__tapvpwrvgnd_1
X_8279_ _8765_/CLK _8279_/D load_slew582/X VGND VGND VPWR VPWR _8279_/Q sky130_fd_sc_hd__dfrtp_2
XFILLER_104_176 VGND VGND VPWR VPWR sky130_fd_sc_hd__decap_3
XFILLER_76_24 VGND VGND VPWR VPWR sky130_fd_sc_hd__decap_3
XFILLER_78_539 VGND VGND VPWR VPWR sky130_fd_sc_hd__fill_1
Xfanout530 fanout543/X VGND VGND VPWR VPWR wire531/A sky130_fd_sc_hd__clkdlybuf4s25_1
XFILLER_58_241 VGND VGND VPWR VPWR sky130_fd_sc_hd__decap_3
XFILLER_59_753 VGND VGND VPWR VPWR sky130_fd_sc_hd__decap_3
XFILLER_19_617 VGND VGND VPWR VPWR sky130_fd_sc_hd__decap_3
XFILLER_74_701 VGND VGND VPWR VPWR sky130_fd_sc_hd__decap_3
XFILLER_86_561 VGND VGND VPWR VPWR sky130_fd_sc_hd__decap_3
XTAP_TAPCELL_ROW_109_1816 VGND VPWR sky130_fd_sc_hd__tapvpwrvgnd_1
Xfanout585 fanout613/X VGND VGND VPWR VPWR fanout585/X sky130_fd_sc_hd__clkdlybuf4s25_1
XFILLER_132_41 VGND VGND VPWR VPWR sky130_fd_sc_hd__decap_3
XFILLER_92_12 VGND VGND VPWR VPWR sky130_fd_sc_hd__fill_1
XFILLER_132_74 VGND VGND VPWR VPWR sky130_fd_sc_hd__decap_3
XFILLER_132_85 VGND VGND VPWR VPWR sky130_fd_sc_hd__decap_3
XFILLER_33_119 VGND VGND VPWR VPWR sky130_fd_sc_hd__decap_3
XFILLER_42_631 VGND VGND VPWR VPWR sky130_fd_sc_hd__decap_3
XFILLER_54_480 VGND VGND VPWR VPWR sky130_fd_sc_hd__fill_2
XFILLER_92_67 VGND VGND VPWR VPWR sky130_fd_sc_hd__decap_3
XFILLER_25_72 VGND VGND VPWR VPWR sky130_fd_sc_hd__decap_3
XFILLER_26_193 VGND VGND VPWR VPWR sky130_fd_sc_hd__decap_3
XFILLER_14_377 VGND VGND VPWR VPWR sky130_fd_sc_hd__decap_3
XFILLER_41_163 VGND VGND VPWR VPWR sky130_fd_sc_hd__decap_3
XFILLER_42_697 VGND VGND VPWR VPWR sky130_fd_sc_hd__decap_3
XTAP_TAPCELL_ROW_64_1189 VGND VPWR sky130_fd_sc_hd__tapvpwrvgnd_1
XTAP_TAPCELL_ROW_40_854 VGND VPWR sky130_fd_sc_hd__tapvpwrvgnd_1
XFILLER_128_725 VGND VGND VPWR VPWR sky130_fd_sc_hd__decap_3
XFILLER_127_246 VGND VGND VPWR VPWR sky130_fd_sc_hd__decap_3
XFILLER_128_769 VGND VGND VPWR VPWR sky130_fd_sc_hd__decap_3
XFILLER_41_93 VGND VGND VPWR VPWR sky130_fd_sc_hd__fill_1
XFILLER_127_279 VGND VGND VPWR VPWR sky130_fd_sc_hd__fill_1
XFILLER_6_565 VGND VGND VPWR VPWR sky130_fd_sc_hd__decap_3
XFILLER_6_587 VGND VGND VPWR VPWR sky130_fd_sc_hd__fill_1
Xclkbuf_leaf_42_CLK clkbuf_leaf_48_CLK/A VGND VGND VPWR VPWR _8795_/CLK sky130_fd_sc_hd__clkbuf_8
XFILLER_6_598 VGND VGND VPWR VPWR sky130_fd_sc_hd__decap_3
XFILLER_2_760 VGND VGND VPWR VPWR sky130_fd_sc_hd__decap_3
XFILLER_111_614 VGND VGND VPWR VPWR sky130_fd_sc_hd__fill_2
XFILLER_123_485 VGND VGND VPWR VPWR sky130_fd_sc_hd__decap_3
XFILLER_2_793 VGND VGND VPWR VPWR sky130_fd_sc_hd__decap_3
XFILLER_37_6 VGND VGND VPWR VPWR sky130_fd_sc_hd__fill_1
XFILLER_69_528 VGND VGND VPWR VPWR sky130_fd_sc_hd__decap_3
XFILLER_1_281 VGND VGND VPWR VPWR sky130_fd_sc_hd__fill_1
XFILLER_2_21 VGND VGND VPWR VPWR sky130_fd_sc_hd__decap_3
XFILLER_2_32 VGND VGND VPWR VPWR sky130_fd_sc_hd__decap_3
XFILLER_2_65 VGND VGND VPWR VPWR sky130_fd_sc_hd__decap_3
XFILLER_37_414 VGND VGND VPWR VPWR sky130_fd_sc_hd__decap_3
XFILLER_64_200 VGND VGND VPWR VPWR sky130_fd_sc_hd__decap_3
XFILLER_65_712 VGND VGND VPWR VPWR sky130_fd_sc_hd__fill_1
XFILLER_77_561 VGND VGND VPWR VPWR sky130_fd_sc_hd__decap_3
XFILLER_92_542 VGND VGND VPWR VPWR sky130_fd_sc_hd__decap_3
XFILLER_80_715 VGND VGND VPWR VPWR sky130_fd_sc_hd__fill_2
XTAP_TAPCELL_ROW_48_965 VGND VPWR sky130_fd_sc_hd__tapvpwrvgnd_1
X_5980_ _8058_/Q _4964_/A _5990_/S VGND VGND VPWR VPWR _5981_/A sky130_fd_sc_hd__mux2_2
XFILLER_33_620 VGND VGND VPWR VPWR sky130_fd_sc_hd__decap_3
XFILLER_45_491 VGND VGND VPWR VPWR sky130_fd_sc_hd__decap_3
X_4931_ _4931_/A VGND VGND VPWR VPWR _7554_/D sky130_fd_sc_hd__buf_1
XFILLER_32_141 VGND VGND VPWR VPWR sky130_fd_sc_hd__decap_3
XFILLER_33_653 VGND VGND VPWR VPWR sky130_fd_sc_hd__decap_3
X_7650_ _8794_/CLK _7650_/D load_slew582/X VGND VGND VPWR VPWR _7650_/Q sky130_fd_sc_hd__dfrtp_2
X_4862_ _4861_/X _7538_/Q _4862_/S VGND VGND VPWR VPWR _4863_/A sky130_fd_sc_hd__mux2_2
X_3813_ _3862_/A _3810_/X _3812_/X VGND VGND VPWR VPWR _3813_/X sky130_fd_sc_hd__o21a_2
X_6601_ _6601_/A VGND VGND VPWR VPWR _8350_/D sky130_fd_sc_hd__buf_2
XFILLER_20_336 VGND VGND VPWR VPWR sky130_fd_sc_hd__fill_2
X_7581_ _8725_/CLK _7581_/D load_slew491/X VGND VGND VPWR VPWR _7581_/Q sky130_fd_sc_hd__dfrtp_2
X_4793_ _4793_/A VGND VGND VPWR VPWR _7521_/D sky130_fd_sc_hd__buf_1
X_3744_ _3880_/A VGND VGND VPWR VPWR _3744_/X sky130_fd_sc_hd__clkbuf_2
X_6532_ _6532_/A VGND VGND VPWR VPWR _8317_/D sky130_fd_sc_hd__buf_2
XTAP_TAPCELL_ROW_95_1617 VGND VPWR sky130_fd_sc_hd__tapvpwrvgnd_1
XTAP_TAPCELL_ROW_95_1628 VGND VPWR sky130_fd_sc_hd__tapvpwrvgnd_1
X_6463_ _6484_/S VGND VGND VPWR VPWR _6482_/S sky130_fd_sc_hd__buf_4
XFILLER_106_408 VGND VGND VPWR VPWR sky130_fd_sc_hd__decap_3
XFILLER_127_780 VGND VGND VPWR VPWR sky130_fd_sc_hd__decap_3
XFILLER_133_205 VGND VGND VPWR VPWR sky130_fd_sc_hd__decap_3
XFILLER_134_728 VGND VGND VPWR VPWR sky130_fd_sc_hd__decap_3
Xoutput100 _4031_/X VGND VGND VPWR VPWR rdata[21] sky130_fd_sc_hd__clkdlybuf4s25_1
X_8202_ _8769_/CLK _8202_/D load_slew563/X VGND VGND VPWR VPWR _8202_/Q sky130_fd_sc_hd__dfrtp_2
X_5414_ _5414_/A VGND VGND VPWR VPWR _7756_/D sky130_fd_sc_hd__buf_1
XFILLER_114_430 VGND VGND VPWR VPWR sky130_fd_sc_hd__decap_3
XFILLER_127_791 VGND VGND VPWR VPWR sky130_fd_sc_hd__decap_3
XFILLER_133_249 VGND VGND VPWR VPWR sky130_fd_sc_hd__decap_3
Xclkbuf_leaf_33_CLK clkbuf_leaf_35_CLK/A VGND VGND VPWR VPWR _8764_/CLK sky130_fd_sc_hd__clkbuf_8
Xoutput133 _4360_/X VGND VGND VPWR VPWR rdata[51] sky130_fd_sc_hd__clkdlybuf4s25_1
Xoutput122 _4242_/X VGND VGND VPWR VPWR rdata[41] sky130_fd_sc_hd__clkdlybuf4s25_1
Xoutput111 _4132_/X VGND VGND VPWR VPWR rdata[31] sky130_fd_sc_hd__clkdlybuf4s25_1
X_8133_ _8781_/CLK _8133_/D fanout749/A VGND VGND VPWR VPWR _8133_/Q sky130_fd_sc_hd__dfrtp_2
X_6394_ _4761_/X _8253_/Q _6398_/S VGND VGND VPWR VPWR _6395_/A sky130_fd_sc_hd__mux2_2
XFILLER_0_719 VGND VGND VPWR VPWR sky130_fd_sc_hd__decap_3
XFILLER_114_452 VGND VGND VPWR VPWR sky130_fd_sc_hd__decap_3
XFILLER_99_163 VGND VGND VPWR VPWR sky130_fd_sc_hd__decap_3
Xoutput144 _4479_/X VGND VGND VPWR VPWR rdata[61] sky130_fd_sc_hd__clkdlybuf4s25_1
Xoutput155 _4584_/X VGND VGND VPWR VPWR rdata[71] sky130_fd_sc_hd__clkdlybuf4s25_1
Xoutput166 _3879_/X VGND VGND VPWR VPWR rdata[8] sky130_fd_sc_hd__clkdlybuf4s25_1
X_5345_ _5345_/A VGND VGND VPWR VPWR _7723_/D sky130_fd_sc_hd__buf_1
XFILLER_101_113 VGND VGND VPWR VPWR sky130_fd_sc_hd__decap_3
XFILLER_87_314 VGND VGND VPWR VPWR sky130_fd_sc_hd__fill_2
X_8064_ _8721_/CLK _8064_/D load_slew640/X VGND VGND VPWR VPWR _8064_/Q sky130_fd_sc_hd__dfrtp_2
X_5276_ _5276_/A VGND VGND VPWR VPWR _7691_/D sky130_fd_sc_hd__buf_1
XFILLER_101_146 VGND VGND VPWR VPWR sky130_fd_sc_hd__decap_3
X_7015_ _4965_/X hold947/X _7025_/S VGND VGND VPWR VPWR _7016_/A sky130_fd_sc_hd__mux2_1
X_4227_ _4227_/A _4227_/B VGND VGND VPWR VPWR _4227_/X sky130_fd_sc_hd__or2_2
XFILLER_56_701 VGND VGND VPWR VPWR sky130_fd_sc_hd__fill_2
XFILLER_28_447 VGND VGND VPWR VPWR sky130_fd_sc_hd__fill_2
XFILLER_55_222 VGND VGND VPWR VPWR sky130_fd_sc_hd__fill_2
XFILLER_83_520 VGND VGND VPWR VPWR sky130_fd_sc_hd__decap_3
X_4158_ _4158_/A _4158_/B VGND VGND VPWR VPWR _4158_/X sky130_fd_sc_hd__or2_2
XFILLER_102_11 VGND VGND VPWR VPWR sky130_fd_sc_hd__decap_3
XFILLER_55_244 VGND VGND VPWR VPWR sky130_fd_sc_hd__decap_3
X_4089_ _4087_/X _4088_/X _4514_/S VGND VGND VPWR VPWR _4089_/X sky130_fd_sc_hd__mux2_2
XFILLER_102_44 VGND VGND VPWR VPWR sky130_fd_sc_hd__fill_2
XFILLER_15_119 VGND VGND VPWR VPWR sky130_fd_sc_hd__decap_3
XFILLER_36_480 VGND VGND VPWR VPWR sky130_fd_sc_hd__decap_3
XFILLER_55_299 VGND VGND VPWR VPWR sky130_fd_sc_hd__decap_3
X_7917_ _8660_/CLK _7917_/D load_slew515/X VGND VGND VPWR VPWR _7917_/Q sky130_fd_sc_hd__dfrtp_2
XFILLER_23_130 VGND VGND VPWR VPWR sky130_fd_sc_hd__decap_3
XTAP_TAPCELL_ROW_104_1746 VGND VPWR sky130_fd_sc_hd__tapvpwrvgnd_1
XTAP_TAPCELL_ROW_26_659 VGND VPWR sky130_fd_sc_hd__tapvpwrvgnd_1
XFILLER_24_686 VGND VGND VPWR VPWR sky130_fd_sc_hd__decap_3
X_7848_ _8749_/CLK _7848_/D load_slew623/X VGND VGND VPWR VPWR _7848_/Q sky130_fd_sc_hd__dfrtp_2
XFILLER_51_494 VGND VGND VPWR VPWR sky130_fd_sc_hd__fill_1
Xwire205 _7218_/X VGND VGND VPWR VPWR wire205/X sky130_fd_sc_hd__clkbuf_4
X_7779_ _8761_/CLK _7779_/D fanout708/X VGND VGND VPWR VPWR _7779_/Q sky130_fd_sc_hd__dfrtp_2
XFILLER_109_246 VGND VGND VPWR VPWR sky130_fd_sc_hd__fill_2
XFILLER_109_279 VGND VGND VPWR VPWR sky130_fd_sc_hd__fill_1
XFILLER_11_30 VGND VGND VPWR VPWR sky130_fd_sc_hd__decap_3
XFILLER_125_717 VGND VGND VPWR VPWR sky130_fd_sc_hd__decap_3
XFILLER_11_63 VGND VGND VPWR VPWR sky130_fd_sc_hd__decap_3
XFILLER_127_30 VGND VGND VPWR VPWR sky130_fd_sc_hd__decap_3
XFILLER_3_513 VGND VGND VPWR VPWR sky130_fd_sc_hd__fill_1
Xclkbuf_leaf_24_CLK clkbuf_5_8__f_CLK/X VGND VGND VPWR VPWR _8803_/CLK sky130_fd_sc_hd__clkbuf_8
XFILLER_117_290 VGND VGND VPWR VPWR sky130_fd_sc_hd__fill_1
XFILLER_127_63 VGND VGND VPWR VPWR sky130_fd_sc_hd__decap_3
XFILLER_133_750 VGND VGND VPWR VPWR sky130_fd_sc_hd__decap_3
XFILLER_2_3 VGND VGND VPWR VPWR sky130_fd_sc_hd__decap_3
XTAP_TAPCELL_ROW_115_1897 VGND VPWR sky130_fd_sc_hd__tapvpwrvgnd_1
XFILLER_127_96 VGND VGND VPWR VPWR sky130_fd_sc_hd__decap_3
XFILLER_132_271 VGND VGND VPWR VPWR sky130_fd_sc_hd__decap_3
XFILLER_133_783 VGND VGND VPWR VPWR sky130_fd_sc_hd__fill_1
XFILLER_133_794 VGND VGND VPWR VPWR sky130_fd_sc_hd__decap_3
XFILLER_78_358 VGND VGND VPWR VPWR sky130_fd_sc_hd__decap_3
XFILLER_87_89 VGND VGND VPWR VPWR sky130_fd_sc_hd__decap_3
XFILLER_120_466 VGND VGND VPWR VPWR sky130_fd_sc_hd__decap_3
XFILLER_59_561 VGND VGND VPWR VPWR sky130_fd_sc_hd__decap_3
XFILLER_93_306 VGND VGND VPWR VPWR sky130_fd_sc_hd__decap_3
XTAP_TAPCELL_ROW_6_373 VGND VPWR sky130_fd_sc_hd__tapvpwrvgnd_1
Xfanout371 _8045_/Q VGND VGND VPWR VPWR fanout371/X sky130_fd_sc_hd__clkdlybuf4s25_1
Xfanout382 _4450_/A VGND VGND VPWR VPWR _4455_/A sky130_fd_sc_hd__clkdlybuf4s25_1
XFILLER_46_211 VGND VGND VPWR VPWR sky130_fd_sc_hd__decap_3
XFILLER_46_233 VGND VGND VPWR VPWR sky130_fd_sc_hd__decap_3
XFILLER_74_520 VGND VGND VPWR VPWR sky130_fd_sc_hd__decap_3
XFILLER_86_380 VGND VGND VPWR VPWR sky130_fd_sc_hd__decap_3
XFILLER_62_704 VGND VGND VPWR VPWR sky130_fd_sc_hd__decap_3
XTAP_TAPCELL_ROW_66_1218 VGND VPWR sky130_fd_sc_hd__tapvpwrvgnd_1
XFILLER_36_60 VGND VGND VPWR VPWR sky130_fd_sc_hd__decap_3
XFILLER_61_225 VGND VGND VPWR VPWR sky130_fd_sc_hd__decap_3
XTAP_TAPCELL_ROW_45_924 VGND VPWR sky130_fd_sc_hd__tapvpwrvgnd_1
XFILLER_14_130 VGND VGND VPWR VPWR sky130_fd_sc_hd__decap_3
XFILLER_15_631 VGND VGND VPWR VPWR sky130_fd_sc_hd__decap_3
XFILLER_14_141 VGND VGND VPWR VPWR sky130_fd_sc_hd__decap_3
XFILLER_30_601 VGND VGND VPWR VPWR sky130_fd_sc_hd__decap_3
XFILLER_70_781 VGND VGND VPWR VPWR sky130_fd_sc_hd__fill_2
XFILLER_30_645 VGND VGND VPWR VPWR sky130_fd_sc_hd__decap_3
XFILLER_42_494 VGND VGND VPWR VPWR sky130_fd_sc_hd__decap_3
XFILLER_128_522 VGND VGND VPWR VPWR sky130_fd_sc_hd__decap_3
Xinput13 wdata[19] VGND VGND VPWR VPWR _5026_/A sky130_fd_sc_hd__clkdlybuf4s25_1
XFILLER_10_380 VGND VGND VPWR VPWR sky130_fd_sc_hd__decap_3
XFILLER_128_533 VGND VGND VPWR VPWR sky130_fd_sc_hd__decap_3
Xinput24 wdata[29] VGND VGND VPWR VPWR _4726_/A sky130_fd_sc_hd__clkdlybuf4s25_1
Xinput35 wdata[39] VGND VGND VPWR VPWR _4768_/A sky130_fd_sc_hd__clkdlybuf4s25_1
Xinput46 wdata[49] VGND VGND VPWR VPWR _4810_/A sky130_fd_sc_hd__clkdlybuf4s25_1
XFILLER_116_717 VGND VGND VPWR VPWR sky130_fd_sc_hd__decap_3
XFILLER_128_566 VGND VGND VPWR VPWR sky130_fd_sc_hd__decap_3
XFILLER_6_351 VGND VGND VPWR VPWR sky130_fd_sc_hd__fill_1
Xhold808 _7983_/Q VGND VGND VPWR VPWR hold808/X sky130_fd_sc_hd__dlygate4sd3_1
Xhold819 _8026_/Q VGND VGND VPWR VPWR hold819/X sky130_fd_sc_hd__dlygate4sd3_1
Xinput57 wdata[59] VGND VGND VPWR VPWR _4852_/A sky130_fd_sc_hd__clkdlybuf4s25_1
Xinput68 wdata[69] VGND VGND VPWR VPWR _4894_/A sky130_fd_sc_hd__clkdlybuf4s25_1
Xinput79 wdata[79] VGND VGND VPWR VPWR _4936_/A sky130_fd_sc_hd__clkdlybuf4s25_1
XTAP_TAPCELL_ROW_77_1369 VGND VPWR sky130_fd_sc_hd__tapvpwrvgnd_1
Xclkbuf_leaf_15_CLK clkload2/A VGND VGND VPWR VPWR _8335_/CLK sky130_fd_sc_hd__clkbuf_8
XFILLER_131_709 VGND VGND VPWR VPWR sky130_fd_sc_hd__decap_3
XFILLER_97_601 VGND VGND VPWR VPWR sky130_fd_sc_hd__decap_3
XFILLER_111_422 VGND VGND VPWR VPWR sky130_fd_sc_hd__decap_3
XFILLER_124_794 VGND VGND VPWR VPWR sky130_fd_sc_hd__decap_3
XFILLER_35_3 VGND VGND VPWR VPWR sky130_fd_sc_hd__decap_3
XTAP_TAPCELL_ROW_90_1547 VGND VPWR sky130_fd_sc_hd__tapvpwrvgnd_1
XTAP_TAPCELL_ROW_90_1558 VGND VPWR sky130_fd_sc_hd__tapvpwrvgnd_1
Xload_slew722 fanout721/X VGND VGND VPWR VPWR load_slew722/X sky130_fd_sc_hd__clkbuf_4
X_5130_ _5130_/A VGND VGND VPWR VPWR _7623_/D sky130_fd_sc_hd__buf_1
XFILLER_96_144 VGND VGND VPWR VPWR sky130_fd_sc_hd__decap_3
Xload_slew733 fanout732/X VGND VGND VPWR VPWR load_slew733/X sky130_fd_sc_hd__buf_4
X_5061_ _5061_/A VGND VGND VPWR VPWR _7590_/D sky130_fd_sc_hd__buf_1
XFILLER_96_177 VGND VGND VPWR VPWR sky130_fd_sc_hd__decap_3
X_4012_ _8316_/Q _3767_/A _3817_/A _8235_/Q _4525_/S VGND VGND VPWR VPWR _4012_/X
+ sky130_fd_sc_hd__o221a_2
XFILLER_38_734 VGND VGND VPWR VPWR sky130_fd_sc_hd__fill_1
XFILLER_53_704 VGND VGND VPWR VPWR sky130_fd_sc_hd__decap_3
XFILLER_65_564 VGND VGND VPWR VPWR sky130_fd_sc_hd__decap_3
XFILLER_65_597 VGND VGND VPWR VPWR sky130_fd_sc_hd__decap_3
X_8751_ _8751_/CLK _8751_/D load_slew628/X VGND VGND VPWR VPWR _8751_/Q sky130_fd_sc_hd__dfrtp_2
X_5963_ _8046_/D _5963_/B VGND VGND VPWR VPWR _5963_/X sky130_fd_sc_hd__xor2_2
X_7702_ _8638_/CLK _7702_/D load_slew582/X VGND VGND VPWR VPWR _7702_/Q sky130_fd_sc_hd__dfrtp_2
X_4914_ _4913_/X hold990/X _7453_/S VGND VGND VPWR VPWR _4915_/A sky130_fd_sc_hd__mux2_2
XFILLER_33_472 VGND VGND VPWR VPWR sky130_fd_sc_hd__decap_3
XFILLER_80_578 VGND VGND VPWR VPWR sky130_fd_sc_hd__decap_3
XFILLER_80_589 VGND VGND VPWR VPWR sky130_fd_sc_hd__decap_3
XTAP_TAPCELL_ROW_23_618 VGND VPWR sky130_fd_sc_hd__tapvpwrvgnd_1
X_8682_ _8728_/CLK _8682_/D fanout556/X VGND VGND VPWR VPWR _8682_/Q sky130_fd_sc_hd__dfrtp_2
X_5894_ _5907_/A VGND VGND VPWR VPWR _5894_/X sky130_fd_sc_hd__clkbuf_1
XFILLER_32_29 VGND VGND VPWR VPWR sky130_fd_sc_hd__decap_3
X_7633_ _8777_/CLK _7633_/D load_slew750/X VGND VGND VPWR VPWR _7633_/Q sky130_fd_sc_hd__dfrtp_2
X_4845_ _4845_/A VGND VGND VPWR VPWR _4845_/X sky130_fd_sc_hd__buf_1
XFILLER_119_500 VGND VGND VPWR VPWR sky130_fd_sc_hd__decap_3
XFILLER_20_144 VGND VGND VPWR VPWR sky130_fd_sc_hd__decap_3
XFILLER_21_667 VGND VGND VPWR VPWR sky130_fd_sc_hd__decap_3
X_7564_ _8709_/CLK _7564_/D load_slew671/X VGND VGND VPWR VPWR _7564_/Q sky130_fd_sc_hd__dfrtp_2
X_4776_ _4776_/A _4776_/B VGND VGND VPWR VPWR _4777_/A sky130_fd_sc_hd__and2_2
X_3727_ _3890_/A _3727_/B VGND VGND VPWR VPWR _8046_/D sky130_fd_sc_hd__xnor2_2
X_6515_ _6515_/A VGND VGND VPWR VPWR _8309_/D sky130_fd_sc_hd__buf_2
XFILLER_119_577 VGND VGND VPWR VPWR sky130_fd_sc_hd__fill_1
X_7495_ _5031_/X _8803_/Q _7495_/S VGND VGND VPWR VPWR _7496_/A sky130_fd_sc_hd__mux2_2
XFILLER_134_525 VGND VGND VPWR VPWR sky130_fd_sc_hd__decap_3
XFILLER_134_536 VGND VGND VPWR VPWR sky130_fd_sc_hd__decap_3
XTAP_TAPCELL_ROW_132_2142 VGND VPWR sky130_fd_sc_hd__tapvpwrvgnd_1
X_6446_ _6446_/A VGND VGND VPWR VPWR _8277_/D sky130_fd_sc_hd__buf_2
XFILLER_134_569 VGND VGND VPWR VPWR sky130_fd_sc_hd__decap_3
X_6377_ _4727_/X hold975/X _6377_/S VGND VGND VPWR VPWR _6378_/A sky130_fd_sc_hd__mux2_1
X_8116_ _8768_/CLK _8116_/D fanout562/X VGND VGND VPWR VPWR _8116_/Q sky130_fd_sc_hd__dfrtp_2
X_5328_ _5328_/A VGND VGND VPWR VPWR _7716_/D sky130_fd_sc_hd__buf_1
XFILLER_130_731 VGND VGND VPWR VPWR sky130_fd_sc_hd__decap_3
XFILLER_88_645 VGND VGND VPWR VPWR sky130_fd_sc_hd__decap_3
X_8047_ _8763_/CLK _8047_/D wire555/X VGND VGND VPWR VPWR _8047_/Q sky130_fd_sc_hd__dfrtp_2
XFILLER_130_775 VGND VGND VPWR VPWR sky130_fd_sc_hd__decap_3
X_5259_ _5259_/A VGND VGND VPWR VPWR _7683_/D sky130_fd_sc_hd__buf_1
XFILLER_102_499 VGND VGND VPWR VPWR sky130_fd_sc_hd__decap_3
XFILLER_28_200 VGND VGND VPWR VPWR sky130_fd_sc_hd__fill_2
XFILLER_56_531 VGND VGND VPWR VPWR sky130_fd_sc_hd__fill_1
XTAP_TAPCELL_ROW_3_332 VGND VPWR sky130_fd_sc_hd__tapvpwrvgnd_1
XFILLER_113_32 VGND VGND VPWR VPWR sky130_fd_sc_hd__decap_3
XFILLER_113_54 VGND VGND VPWR VPWR sky130_fd_sc_hd__fill_2
XFILLER_56_553 VGND VGND VPWR VPWR sky130_fd_sc_hd__decap_3
XFILLER_90_309 VGND VGND VPWR VPWR sky130_fd_sc_hd__decap_3
XFILLER_16_417 VGND VGND VPWR VPWR sky130_fd_sc_hd__decap_3
XFILLER_28_299 VGND VGND VPWR VPWR sky130_fd_sc_hd__decap_3
XFILLER_73_36 VGND VGND VPWR VPWR sky130_fd_sc_hd__decap_3
XFILLER_71_556 VGND VGND VPWR VPWR sky130_fd_sc_hd__decap_3
XFILLER_71_567 VGND VGND VPWR VPWR sky130_fd_sc_hd__decap_3
XFILLER_73_69 VGND VGND VPWR VPWR sky130_fd_sc_hd__decap_3
XFILLER_12_601 VGND VGND VPWR VPWR sky130_fd_sc_hd__decap_3
XFILLER_11_122 VGND VGND VPWR VPWR sky130_fd_sc_hd__fill_1
XFILLER_12_634 VGND VGND VPWR VPWR sky130_fd_sc_hd__decap_3
XFILLER_12_645 VGND VGND VPWR VPWR sky130_fd_sc_hd__fill_1
XFILLER_24_483 VGND VGND VPWR VPWR sky130_fd_sc_hd__decap_3
XTAP_TAPCELL_ROW_61_1148 VGND VPWR sky130_fd_sc_hd__tapvpwrvgnd_1
XFILLER_11_144 VGND VGND VPWR VPWR sky130_fd_sc_hd__decap_3
XFILLER_12_689 VGND VGND VPWR VPWR sky130_fd_sc_hd__decap_3
XFILLER_8_616 VGND VGND VPWR VPWR sky130_fd_sc_hd__decap_3
XTAP_TAPCELL_ROW_50_993 VGND VPWR sky130_fd_sc_hd__tapvpwrvgnd_1
XFILLER_22_62 VGND VGND VPWR VPWR sky130_fd_sc_hd__decap_3
XTAP_TAPCELL_ROW_117_1926 VGND VPWR sky130_fd_sc_hd__tapvpwrvgnd_1
XTAP_TAPCELL_ROW_117_1937 VGND VPWR sky130_fd_sc_hd__tapvpwrvgnd_1
XFILLER_98_44 VGND VGND VPWR VPWR sky130_fd_sc_hd__fill_1
XFILLER_106_750 VGND VGND VPWR VPWR sky130_fd_sc_hd__decap_3
XFILLER_79_623 VGND VGND VPWR VPWR sky130_fd_sc_hd__decap_3
XFILLER_105_293 VGND VGND VPWR VPWR sky130_fd_sc_hd__fill_2
XFILLER_120_230 VGND VGND VPWR VPWR sky130_fd_sc_hd__decap_3
XFILLER_133_591 VGND VGND VPWR VPWR sky130_fd_sc_hd__decap_3
XFILLER_21_9 VGND VGND VPWR VPWR sky130_fd_sc_hd__decap_3
XFILLER_78_155 VGND VGND VPWR VPWR sky130_fd_sc_hd__decap_3
XTAP_TAPCELL_ROW_72_1299 VGND VPWR sky130_fd_sc_hd__tapvpwrvgnd_1
XFILLER_120_285 VGND VGND VPWR VPWR sky130_fd_sc_hd__decap_3
XFILLER_59_391 VGND VGND VPWR VPWR sky130_fd_sc_hd__fill_1
XFILLER_78_188 VGND VGND VPWR VPWR sky130_fd_sc_hd__decap_3
XFILLER_94_648 VGND VGND VPWR VPWR sky130_fd_sc_hd__decap_3
XFILLER_47_564 VGND VGND VPWR VPWR sky130_fd_sc_hd__decap_3
XFILLER_19_277 VGND VGND VPWR VPWR sky130_fd_sc_hd__decap_3
XFILLER_34_203 VGND VGND VPWR VPWR sky130_fd_sc_hd__decap_3
XFILLER_74_361 VGND VGND VPWR VPWR sky130_fd_sc_hd__decap_3
XFILLER_74_383 VGND VGND VPWR VPWR sky130_fd_sc_hd__decap_3
Xclkbuf_leaf_4_CLK clkbuf_leaf_8_CLK/A VGND VGND VPWR VPWR _8648_/CLK sky130_fd_sc_hd__clkbuf_8
XFILLER_35_759 VGND VGND VPWR VPWR sky130_fd_sc_hd__fill_2
XFILLER_15_461 VGND VGND VPWR VPWR sky130_fd_sc_hd__decap_3
X_4630_ _7796_/Q _7877_/Q _4630_/S VGND VGND VPWR VPWR _4630_/X sky130_fd_sc_hd__mux2_2
XFILLER_8_53 VGND VGND VPWR VPWR sky130_fd_sc_hd__decap_3
XPHY_EDGE_ROW_7_Left_143 VGND VGND VPWR VPWR sky130_fd_sc_hd__decap_3
X_6300_ _4917_/X _8209_/Q _6310_/S VGND VGND VPWR VPWR _6301_/A sky130_fd_sc_hd__mux2_4
X_4561_ _7952_/Q _4660_/A2 _4560_/X VGND VGND VPWR VPWR _4561_/X sky130_fd_sc_hd__o21a_2
XFILLER_116_525 VGND VGND VPWR VPWR sky130_fd_sc_hd__decap_3
XFILLER_7_671 VGND VGND VPWR VPWR sky130_fd_sc_hd__fill_1
XFILLER_7_682 VGND VGND VPWR VPWR sky130_fd_sc_hd__decap_3
X_7280_ _5946_/A _4937_/X _7280_/A3 _7280_/B1 hold915/X VGND VGND VPWR VPWR _8700_/D
+ sky130_fd_sc_hd__a32o_2
X_4492_ _8603_/Q _3800_/X _4491_/X _4503_/A _4534_/A VGND VGND VPWR VPWR _4492_/X
+ sky130_fd_sc_hd__o221a_2
X_6231_ _4777_/X _8176_/Q _6247_/S VGND VGND VPWR VPWR _6232_/A sky130_fd_sc_hd__mux2_4
XFILLER_131_517 VGND VGND VPWR VPWR sky130_fd_sc_hd__decap_3
Xclkbuf_5_18__f_CLK clkbuf_4_9_0_CLK/X VGND VGND VPWR VPWR clkbuf_leaf_91_CLK/A sky130_fd_sc_hd__clkbuf_16
X_6162_ _6162_/A VGND VGND VPWR VPWR _8143_/D sky130_fd_sc_hd__buf_6
XFILLER_111_230 VGND VGND VPWR VPWR sky130_fd_sc_hd__fill_2
XFILLER_112_753 VGND VGND VPWR VPWR sky130_fd_sc_hd__decap_3
Xload_slew541 fanout540/X VGND VGND VPWR VPWR load_slew541/X sky130_fd_sc_hd__buf_2
X_5113_ _5113_/A VGND VGND VPWR VPWR _7615_/D sky130_fd_sc_hd__buf_1
XFILLER_111_252 VGND VGND VPWR VPWR sky130_fd_sc_hd__decap_3
XFILLER_57_317 VGND VGND VPWR VPWR sky130_fd_sc_hd__fill_2
XFILLER_69_166 VGND VGND VPWR VPWR sky130_fd_sc_hd__fill_2
XFILLER_85_615 VGND VGND VPWR VPWR sky130_fd_sc_hd__fill_1
Xload_slew563 fanout562/X VGND VGND VPWR VPWR load_slew563/X sky130_fd_sc_hd__buf_4
X_6093_ _8112_/Q _4848_/A _6095_/S VGND VGND VPWR VPWR _6094_/A sky130_fd_sc_hd__mux2_2
XFILLER_27_18 VGND VGND VPWR VPWR sky130_fd_sc_hd__decap_3
Xload_slew596 fanout595/X VGND VGND VPWR VPWR load_slew596/X sky130_fd_sc_hd__buf_2
X_5044_ _5044_/A VGND VGND VPWR VPWR _7582_/D sky130_fd_sc_hd__buf_1
XFILLER_26_704 VGND VGND VPWR VPWR sky130_fd_sc_hd__decap_3
XFILLER_26_737 VGND VGND VPWR VPWR sky130_fd_sc_hd__fill_1
XFILLER_38_575 VGND VGND VPWR VPWR sky130_fd_sc_hd__decap_3
X_8803_ _8803_/CLK _8803_/D wire547/X VGND VGND VPWR VPWR _8803_/Q sky130_fd_sc_hd__dfrtp_2
X_6995_ _6995_/A VGND VGND VPWR VPWR _8535_/D sky130_fd_sc_hd__buf_6
XFILLER_41_729 VGND VGND VPWR VPWR sky130_fd_sc_hd__decap_3
XFILLER_43_28 VGND VGND VPWR VPWR sky130_fd_sc_hd__decap_3
XTAP_TAPCELL_ROW_101_1705 VGND VPWR sky130_fd_sc_hd__tapvpwrvgnd_1
X_8734_ _8734_/CLK _8734_/D fanout527/X VGND VGND VPWR VPWR _8734_/Q sky130_fd_sc_hd__dfrtp_2
X_5946_ _5946_/A VGND VGND VPWR VPWR _5946_/X sky130_fd_sc_hd__clkbuf_1
XFILLER_34_781 VGND VGND VPWR VPWR sky130_fd_sc_hd__fill_2
XTAP_TAPCELL_ROW_36_798 VGND VPWR sky130_fd_sc_hd__tapvpwrvgnd_1
X_8665_ _8668_/CLK _8665_/D wire638/X VGND VGND VPWR VPWR _8665_/Q sky130_fd_sc_hd__dfrtp_2
X_5877_ _5880_/A1 _5879_/A2 _5015_/X _5879_/B1 hold814/X VGND VGND VPWR VPWR _7979_/D
+ sky130_fd_sc_hd__a32o_2
X_7616_ _8274_/CLK _7616_/D fanout697/X VGND VGND VPWR VPWR _7616_/Q sky130_fd_sc_hd__dfrtp_2
X_4828_ _4828_/A _4852_/B VGND VGND VPWR VPWR _4829_/A sky130_fd_sc_hd__and2_2
XFILLER_21_486 VGND VGND VPWR VPWR sky130_fd_sc_hd__decap_3
X_8596_ _8676_/CLK _8596_/D load_slew699/X VGND VGND VPWR VPWR _8596_/Q sky130_fd_sc_hd__dfrtp_2
XFILLER_119_363 VGND VGND VPWR VPWR sky130_fd_sc_hd__decap_3
XFILLER_5_608 VGND VGND VPWR VPWR sky130_fd_sc_hd__decap_3
X_7547_ _8697_/CLK _7547_/D load_slew718/X VGND VGND VPWR VPWR _7547_/Q sky130_fd_sc_hd__dfrtp_2
X_4759_ _4759_/A VGND VGND VPWR VPWR _7513_/D sky130_fd_sc_hd__buf_1
XFILLER_107_514 VGND VGND VPWR VPWR sky130_fd_sc_hd__decap_3
XFILLER_107_536 VGND VGND VPWR VPWR sky130_fd_sc_hd__decap_3
XFILLER_4_129 VGND VGND VPWR VPWR sky130_fd_sc_hd__decap_3
X_7478_ _7478_/A VGND VGND VPWR VPWR _8794_/D sky130_fd_sc_hd__buf_1
XFILLER_134_344 VGND VGND VPWR VPWR sky130_fd_sc_hd__decap_3
XTAP_TAPCELL_ROW_8_402 VGND VPWR sky130_fd_sc_hd__tapvpwrvgnd_1
X_6429_ _6429_/A VGND VGND VPWR VPWR _8269_/D sky130_fd_sc_hd__buf_2
XFILLER_122_528 VGND VGND VPWR VPWR sky130_fd_sc_hd__decap_3
XFILLER_122_539 VGND VGND VPWR VPWR sky130_fd_sc_hd__decap_3
XFILLER_134_377 VGND VGND VPWR VPWR sky130_fd_sc_hd__decap_3
XFILLER_1_803 VGND VGND VPWR VPWR sky130_fd_sc_hd__fill_1
XFILLER_115_591 VGND VGND VPWR VPWR sky130_fd_sc_hd__decap_3
XFILLER_68_69 VGND VGND VPWR VPWR sky130_fd_sc_hd__decap_3
XTAP_TAPCELL_ROW_112_1856 VGND VPWR sky130_fd_sc_hd__tapvpwrvgnd_1
XTAP_TAPCELL_ROW_112_1867 VGND VPWR sky130_fd_sc_hd__tapvpwrvgnd_1
XFILLER_130_572 VGND VGND VPWR VPWR sky130_fd_sc_hd__decap_3
XFILLER_88_464 VGND VGND VPWR VPWR sky130_fd_sc_hd__decap_3
XFILLER_88_475 VGND VGND VPWR VPWR sky130_fd_sc_hd__fill_1
XFILLER_124_75 VGND VGND VPWR VPWR sky130_fd_sc_hd__decap_3
XFILLER_17_704 VGND VGND VPWR VPWR sky130_fd_sc_hd__fill_2
XFILLER_63_309 VGND VGND VPWR VPWR sky130_fd_sc_hd__decap_3
XFILLER_84_35 VGND VGND VPWR VPWR sky130_fd_sc_hd__fill_1
XFILLER_56_361 VGND VGND VPWR VPWR sky130_fd_sc_hd__decap_3
XFILLER_84_57 VGND VGND VPWR VPWR sky130_fd_sc_hd__decap_3
XFILLER_17_51 VGND VGND VPWR VPWR sky130_fd_sc_hd__decap_3
XFILLER_83_180 VGND VGND VPWR VPWR sky130_fd_sc_hd__decap_3
XFILLER_90_139 VGND VGND VPWR VPWR sky130_fd_sc_hd__fill_1
XFILLER_129_105 VGND VGND VPWR VPWR sky130_fd_sc_hd__decap_3
XFILLER_129_116 VGND VGND VPWR VPWR sky130_fd_sc_hd__decap_3
XFILLER_8_413 VGND VGND VPWR VPWR sky130_fd_sc_hd__decap_3
XFILLER_129_149 VGND VGND VPWR VPWR sky130_fd_sc_hd__decap_3
XFILLER_12_475 VGND VGND VPWR VPWR sky130_fd_sc_hd__fill_1
XFILLER_33_72 VGND VGND VPWR VPWR sky130_fd_sc_hd__decap_3
XFILLER_8_457 VGND VGND VPWR VPWR sky130_fd_sc_hd__fill_2
XTAP_TAPCELL_ROW_74_1328 VGND VPWR sky130_fd_sc_hd__tapvpwrvgnd_1
XFILLER_4_663 VGND VGND VPWR VPWR sky130_fd_sc_hd__decap_3
XFILLER_4_696 VGND VGND VPWR VPWR sky130_fd_sc_hd__decap_3
XFILLER_79_420 VGND VGND VPWR VPWR sky130_fd_sc_hd__decap_3
XFILLER_98_239 VGND VGND VPWR VPWR sky130_fd_sc_hd__decap_3
XFILLER_121_561 VGND VGND VPWR VPWR sky130_fd_sc_hd__decap_3
XFILLER_58_80 VGND VGND VPWR VPWR sky130_fd_sc_hd__decap_3
XFILLER_66_114 VGND VGND VPWR VPWR sky130_fd_sc_hd__decap_3
XFILLER_67_648 VGND VGND VPWR VPWR sky130_fd_sc_hd__fill_2
XFILLER_54_309 VGND VGND VPWR VPWR sky130_fd_sc_hd__decap_3
XFILLER_22_206 VGND VGND VPWR VPWR sky130_fd_sc_hd__decap_3
XFILLER_90_673 VGND VGND VPWR VPWR sky130_fd_sc_hd__decap_3
XTAP_TAPCELL_ROW_85_1479 VGND VPWR sky130_fd_sc_hd__tapvpwrvgnd_1
X_3992_ _8396_/Q _8477_/Q _3996_/S VGND VGND VPWR VPWR _3993_/B sky130_fd_sc_hd__mux2_2
X_6780_ _8434_/Q _4840_/A _6786_/S VGND VGND VPWR VPWR _6781_/A sky130_fd_sc_hd__mux2_2
X_5800_ _5800_/A VGND VGND VPWR VPWR _7938_/D sky130_fd_sc_hd__buf_1
X_5731_ _5731_/A VGND VGND VPWR VPWR _7905_/D sky130_fd_sc_hd__buf_1
XTAP_TAPCELL_ROW_33_757 VGND VPWR sky130_fd_sc_hd__tapvpwrvgnd_1
XTAP_TAPCELL_ROW_13_470 VGND VPWR sky130_fd_sc_hd__tapvpwrvgnd_1
X_8450_ _8450_/CLK _8450_/D load_slew742/X VGND VGND VPWR VPWR _8450_/Q sky130_fd_sc_hd__dfrtp_2
X_5662_ _5662_/A VGND VGND VPWR VPWR _7873_/D sky130_fd_sc_hd__buf_1
XFILLER_129_650 VGND VGND VPWR VPWR sky130_fd_sc_hd__decap_3
XTAP_TAPCELL_ROW_13_481 VGND VPWR sky130_fd_sc_hd__tapvpwrvgnd_1
X_8381_ _8627_/CLK _8381_/D wire669/X VGND VGND VPWR VPWR _8381_/Q sky130_fd_sc_hd__dfrtp_2
X_7401_ _8758_/Q _4840_/A _7407_/S VGND VGND VPWR VPWR _7402_/A sky130_fd_sc_hd__mux2_2
X_5593_ _5677_/S VGND VGND VPWR VPWR _5612_/S sky130_fd_sc_hd__buf_2
X_4613_ _7794_/Q _7875_/Q _4630_/S VGND VGND VPWR VPWR _4613_/X sky130_fd_sc_hd__mux2_2
XFILLER_128_171 VGND VGND VPWR VPWR sky130_fd_sc_hd__decap_3
XFILLER_129_694 VGND VGND VPWR VPWR sky130_fd_sc_hd__decap_3
XFILLER_135_119 VGND VGND VPWR VPWR sky130_fd_sc_hd__decap_3
X_7332_ _8725_/Q _4702_/A _7344_/S VGND VGND VPWR VPWR _7333_/A sky130_fd_sc_hd__mux2_2
X_4544_ _8446_/Q _8527_/Q _8608_/Q _8689_/Q _4544_/S0 _4498_/A VGND VGND VPWR VPWR
+ _4544_/X sky130_fd_sc_hd__mux4_2
XFILLER_7_490 VGND VGND VPWR VPWR sky130_fd_sc_hd__decap_3
X_7263_ _7254_/X _4879_/X _7266_/A3 _7266_/B1 hold761/X VGND VGND VPWR VPWR _8686_/D
+ sky130_fd_sc_hd__a32o_2
XFILLER_116_388 VGND VGND VPWR VPWR sky130_fd_sc_hd__decap_3
XFILLER_131_314 VGND VGND VPWR VPWR sky130_fd_sc_hd__fill_1
XFILLER_89_228 VGND VGND VPWR VPWR sky130_fd_sc_hd__decap_3
Xmax_cap176 _7204_/X VGND VGND VPWR VPWR _7216_/A3 sky130_fd_sc_hd__buf_4
X_6214_ _4745_/X _8168_/Q _6226_/S VGND VGND VPWR VPWR _6215_/A sky130_fd_sc_hd__mux2_4
X_4475_ _8115_/Q _8196_/Q _4497_/S VGND VGND VPWR VPWR _4475_/X sky130_fd_sc_hd__mux2_2
XFILLER_131_358 VGND VGND VPWR VPWR sky130_fd_sc_hd__decap_3
XFILLER_98_751 VGND VGND VPWR VPWR sky130_fd_sc_hd__fill_2
Xmax_cap198 _7497_/S VGND VGND VPWR VPWR _7455_/A sky130_fd_sc_hd__buf_2
Xmax_cap187 _5896_/X VGND VGND VPWR VPWR _5906_/B1 sky130_fd_sc_hd__buf_2
X_7194_ _7189_/X _4995_/X _7191_/X wire207/X hold854/X VGND VGND VPWR VPWR _8632_/D
+ sky130_fd_sc_hd__a32o_2
XFILLER_100_701 VGND VGND VPWR VPWR sky130_fd_sc_hd__decap_3
X_6145_ _4945_/X _8135_/Q _6163_/S VGND VGND VPWR VPWR _6146_/A sky130_fd_sc_hd__mux2_4
XFILLER_38_39 VGND VGND VPWR VPWR sky130_fd_sc_hd__decap_3
Xload_slew360 _3958_/A VGND VGND VPWR VPWR _4552_/A1 sky130_fd_sc_hd__clkbuf_2
X_6076_ _6139_/S VGND VGND VPWR VPWR _6095_/S sky130_fd_sc_hd__buf_2
Xload_slew393 _4412_/B2 VGND VGND VPWR VPWR _4636_/S1 sky130_fd_sc_hd__buf_4
X_5027_ _5027_/A VGND VGND VPWR VPWR _5027_/X sky130_fd_sc_hd__buf_1
XFILLER_66_681 VGND VGND VPWR VPWR sky130_fd_sc_hd__decap_3
XFILLER_72_128 VGND VGND VPWR VPWR sky130_fd_sc_hd__fill_1
XTAP_TAPCELL_ROW_127_2074 VGND VPWR sky130_fd_sc_hd__tapvpwrvgnd_1
XFILLER_53_331 VGND VGND VPWR VPWR sky130_fd_sc_hd__fill_2
XFILLER_14_729 VGND VGND VPWR VPWR sky130_fd_sc_hd__decap_3
XFILLER_53_364 VGND VGND VPWR VPWR sky130_fd_sc_hd__decap_3
XFILLER_81_662 VGND VGND VPWR VPWR sky130_fd_sc_hd__fill_1
XFILLER_53_386 VGND VGND VPWR VPWR sky130_fd_sc_hd__decap_3
X_8717_ _8795_/CLK _8717_/D fanout601/X VGND VGND VPWR VPWR _8717_/Q sky130_fd_sc_hd__dfrtp_2
X_6978_ _6978_/A VGND VGND VPWR VPWR _8527_/D sky130_fd_sc_hd__buf_6
X_5929_ _5920_/X _5932_/A2 _4841_/X _5932_/B1 hold795/X VGND VGND VPWR VPWR _8019_/D
+ sky130_fd_sc_hd__a32o_2
X_8648_ _8648_/CLK _8648_/D fanout492/X VGND VGND VPWR VPWR _8648_/Q sky130_fd_sc_hd__dfrtp_2
XFILLER_127_609 VGND VGND VPWR VPWR sky130_fd_sc_hd__decap_3
X_8579_ _8734_/CLK _8579_/D fanout522/X VGND VGND VPWR VPWR _8579_/Q sky130_fd_sc_hd__dfrtp_2
XFILLER_119_42 VGND VGND VPWR VPWR sky130_fd_sc_hd__decap_3
XFILLER_135_631 VGND VGND VPWR VPWR sky130_fd_sc_hd__decap_3
XFILLER_134_130 VGND VGND VPWR VPWR sky130_fd_sc_hd__decap_3
XFILLER_134_141 VGND VGND VPWR VPWR sky130_fd_sc_hd__decap_3
XFILLER_5_449 VGND VGND VPWR VPWR sky130_fd_sc_hd__decap_3
XFILLER_107_377 VGND VGND VPWR VPWR sky130_fd_sc_hd__fill_2
XFILLER_107_388 VGND VGND VPWR VPWR sky130_fd_sc_hd__decap_3
XFILLER_134_174 VGND VGND VPWR VPWR sky130_fd_sc_hd__decap_3
XFILLER_79_57 VGND VGND VPWR VPWR sky130_fd_sc_hd__fill_2
XFILLER_135_41 VGND VGND VPWR VPWR sky130_fd_sc_hd__decap_3
XFILLER_1_644 VGND VGND VPWR VPWR sky130_fd_sc_hd__decap_3
XPHY_EDGE_ROW_79_Left_215 VGND VGND VPWR VPWR sky130_fd_sc_hd__decap_3
Xhold980 _7853_/Q VGND VGND VPWR VPWR hold980/X sky130_fd_sc_hd__dlygate4sd3_1
Xhold991 _7510_/Q VGND VGND VPWR VPWR hold991/X sky130_fd_sc_hd__dlygate4sd3_1
XFILLER_135_63 VGND VGND VPWR VPWR sky130_fd_sc_hd__decap_3
XFILLER_135_85 VGND VGND VPWR VPWR sky130_fd_sc_hd__decap_3
XFILLER_1_688 VGND VGND VPWR VPWR sky130_fd_sc_hd__decap_3
XFILLER_49_648 VGND VGND VPWR VPWR sky130_fd_sc_hd__decap_3
XFILLER_130_391 VGND VGND VPWR VPWR sky130_fd_sc_hd__decap_3
XFILLER_28_50 VGND VGND VPWR VPWR sky130_fd_sc_hd__decap_3
XFILLER_64_607 VGND VGND VPWR VPWR sky130_fd_sc_hd__fill_2
XFILLER_95_78 VGND VGND VPWR VPWR sky130_fd_sc_hd__fill_1
XFILLER_91_437 VGND VGND VPWR VPWR sky130_fd_sc_hd__decap_3
XFILLER_17_545 VGND VGND VPWR VPWR sky130_fd_sc_hd__decap_3
XFILLER_28_94 VGND VGND VPWR VPWR sky130_fd_sc_hd__decap_3
XFILLER_63_139 VGND VGND VPWR VPWR sky130_fd_sc_hd__decap_3
XFILLER_72_640 VGND VGND VPWR VPWR sky130_fd_sc_hd__decap_3
XFILLER_44_353 VGND VGND VPWR VPWR sky130_fd_sc_hd__decap_3
XPHY_EDGE_ROW_88_Left_224 VGND VGND VPWR VPWR sky130_fd_sc_hd__decap_3
XFILLER_71_194 VGND VGND VPWR VPWR sky130_fd_sc_hd__decap_3
XFILLER_13_762 VGND VGND VPWR VPWR sky130_fd_sc_hd__decap_3
XFILLER_9_700 VGND VGND VPWR VPWR sky130_fd_sc_hd__decap_3
XFILLER_9_744 VGND VGND VPWR VPWR sky130_fd_sc_hd__decap_3
XTAP_TAPCELL_ROW_30_716 VGND VPWR sky130_fd_sc_hd__tapvpwrvgnd_1
XFILLER_9_777 VGND VGND VPWR VPWR sky130_fd_sc_hd__decap_3
XFILLER_8_265 VGND VGND VPWR VPWR sky130_fd_sc_hd__decap_3
XFILLER_9_788 VGND VGND VPWR VPWR sky130_fd_sc_hd__decap_3
XFILLER_5_21 VGND VGND VPWR VPWR sky130_fd_sc_hd__decap_3
XPHY_EDGE_ROW_97_Left_233 VGND VGND VPWR VPWR sky130_fd_sc_hd__decap_3
XFILLER_125_163 VGND VGND VPWR VPWR sky130_fd_sc_hd__decap_3
XFILLER_126_686 VGND VGND VPWR VPWR sky130_fd_sc_hd__decap_3
XFILLER_5_54 VGND VGND VPWR VPWR sky130_fd_sc_hd__fill_2
XFILLER_113_325 VGND VGND VPWR VPWR sky130_fd_sc_hd__fill_2
XFILLER_5_87 VGND VGND VPWR VPWR sky130_fd_sc_hd__decap_3
X_4260_ _8745_/Q _7520_/Q _4260_/S VGND VGND VPWR VPWR _4261_/B sky130_fd_sc_hd__mux2_2
X_4191_ _3760_/X _4186_/X _4190_/X VGND VGND VPWR VPWR _4191_/X sky130_fd_sc_hd__a21o_2
XFILLER_95_732 VGND VGND VPWR VPWR sky130_fd_sc_hd__decap_3
XFILLER_39_136 VGND VGND VPWR VPWR sky130_fd_sc_hd__decap_3
XFILLER_94_253 VGND VGND VPWR VPWR sky130_fd_sc_hd__decap_3
XFILLER_95_776 VGND VGND VPWR VPWR sky130_fd_sc_hd__decap_3
XTAP_TAPCELL_ROW_87_1508 VGND VPWR sky130_fd_sc_hd__tapvpwrvgnd_1
XFILLER_55_629 VGND VGND VPWR VPWR sky130_fd_sc_hd__fill_1
XTAP_TAPCELL_ROW_38_827 VGND VPWR sky130_fd_sc_hd__tapvpwrvgnd_1
X_7950_ _8608_/CLK _7950_/D wire552/X VGND VGND VPWR VPWR _7950_/Q sky130_fd_sc_hd__dfrtp_2
XFILLER_35_331 VGND VGND VPWR VPWR sky130_fd_sc_hd__decap_3
X_7881_ _8782_/CLK _7881_/D load_slew649/X VGND VGND VPWR VPWR _7881_/Q sky130_fd_sc_hd__dfrtp_2
X_6901_ _6901_/A VGND VGND VPWR VPWR _8490_/D sky130_fd_sc_hd__buf_6
XFILLER_63_651 VGND VGND VPWR VPWR sky130_fd_sc_hd__fill_1
XFILLER_63_673 VGND VGND VPWR VPWR sky130_fd_sc_hd__fill_1
XTAP_TAPCELL_ROW_18_540 VGND VPWR sky130_fd_sc_hd__tapvpwrvgnd_1
XTAP_TAPCELL_ROW_18_551 VGND VPWR sky130_fd_sc_hd__tapvpwrvgnd_1
X_6832_ _8049_/Q _7004_/C _7004_/D _7004_/A VGND VGND VPWR VPWR _6833_/A sky130_fd_sc_hd__or4b_4
XFILLER_23_526 VGND VGND VPWR VPWR sky130_fd_sc_hd__fill_2
XFILLER_50_312 VGND VGND VPWR VPWR sky130_fd_sc_hd__decap_3
XFILLER_62_183 VGND VGND VPWR VPWR sky130_fd_sc_hd__decap_3
XFILLER_90_492 VGND VGND VPWR VPWR sky130_fd_sc_hd__decap_3
X_3975_ _3993_/A _3973_/X _3974_/X VGND VGND VPWR VPWR _3975_/X sky130_fd_sc_hd__o21a_2
X_6763_ _8426_/Q _4806_/A _6765_/S VGND VGND VPWR VPWR _6764_/A sky130_fd_sc_hd__mux2_2
XFILLER_10_209 VGND VGND VPWR VPWR sky130_fd_sc_hd__decap_3
XFILLER_31_570 VGND VGND VPWR VPWR sky130_fd_sc_hd__decap_3
XFILLER_50_389 VGND VGND VPWR VPWR sky130_fd_sc_hd__fill_2
X_8502_ _8751_/CLK _8502_/D fanout629/X VGND VGND VPWR VPWR _8502_/Q sky130_fd_sc_hd__dfrtp_2
X_6694_ _8393_/Q input9/X _6702_/S VGND VGND VPWR VPWR _6695_/A sky130_fd_sc_hd__mux2_2
X_5714_ _5714_/A VGND VGND VPWR VPWR _7897_/D sky130_fd_sc_hd__buf_1
X_8433_ _8758_/CLK _8433_/D load_slew712/X VGND VGND VPWR VPWR _8433_/Q sky130_fd_sc_hd__dfrtp_2
X_5645_ _5645_/A VGND VGND VPWR VPWR _7865_/D sky130_fd_sc_hd__buf_1
XFILLER_117_620 VGND VGND VPWR VPWR sky130_fd_sc_hd__decap_3
XTAP_TAPCELL_ROW_98_1659 VGND VPWR sky130_fd_sc_hd__tapvpwrvgnd_1
XFILLER_129_491 VGND VGND VPWR VPWR sky130_fd_sc_hd__decap_3
X_8364_ _8764_/CLK _8364_/D load_slew563/X VGND VGND VPWR VPWR _8364_/Q sky130_fd_sc_hd__dfrtp_2
X_5576_ _5576_/A VGND VGND VPWR VPWR _7832_/D sky130_fd_sc_hd__buf_1
XFILLER_116_141 VGND VGND VPWR VPWR sky130_fd_sc_hd__decap_3
XFILLER_116_152 VGND VGND VPWR VPWR sky130_fd_sc_hd__decap_3
XFILLER_132_601 VGND VGND VPWR VPWR sky130_fd_sc_hd__decap_3
X_8295_ _8777_/CLK _8295_/D load_slew750/X VGND VGND VPWR VPWR _8295_/Q sky130_fd_sc_hd__dfrtp_2
X_7315_ _8717_/Q input9/X _7323_/S VGND VGND VPWR VPWR _7316_/A sky130_fd_sc_hd__mux2_2
X_4527_ _4527_/A VGND VGND VPWR VPWR _4527_/X sky130_fd_sc_hd__buf_1
XFILLER_131_111 VGND VGND VPWR VPWR sky130_fd_sc_hd__fill_1
XFILLER_131_122 VGND VGND VPWR VPWR sky130_fd_sc_hd__decap_3
XFILLER_132_634 VGND VGND VPWR VPWR sky130_fd_sc_hd__decap_3
XFILLER_132_645 VGND VGND VPWR VPWR sky130_fd_sc_hd__decap_3
X_7246_ _7253_/A1 _4819_/X _7243_/X _7244_/X hold862/X VGND VGND VPWR VPWR _8672_/D
+ sky130_fd_sc_hd__a32o_2
X_4458_ _4448_/X _4452_/X _4457_/X _4458_/B2 VGND VGND VPWR VPWR _4458_/X sky130_fd_sc_hd__o22a_2
XFILLER_104_358 VGND VGND VPWR VPWR sky130_fd_sc_hd__decap_3
XFILLER_131_155 VGND VGND VPWR VPWR sky130_fd_sc_hd__decap_3
XFILLER_132_678 VGND VGND VPWR VPWR sky130_fd_sc_hd__decap_3
XTAP_TAPCELL_ROW_129_2103 VGND VPWR sky130_fd_sc_hd__tapvpwrvgnd_1
Xfanout723 fanout725/X VGND VGND VPWR VPWR fanout723/X sky130_fd_sc_hd__clkdlybuf4s25_1
X_7177_ _7177_/A _8051_/Q _3712_/A VGND VGND VPWR VPWR _7178_/A sky130_fd_sc_hd__or3b_2
XFILLER_112_380 VGND VGND VPWR VPWR sky130_fd_sc_hd__decap_3
XFILLER_131_199 VGND VGND VPWR VPWR sky130_fd_sc_hd__decap_3
XFILLER_86_710 VGND VGND VPWR VPWR sky130_fd_sc_hd__fill_1
Xfanout734 fanout736/X VGND VGND VPWR VPWR fanout734/X sky130_fd_sc_hd__clkdlybuf4s25_1
Xfanout745 fanout753/X VGND VGND VPWR VPWR wire746/A sky130_fd_sc_hd__clkdlybuf4s25_1
X_6128_ _6128_/A VGND VGND VPWR VPWR _8128_/D sky130_fd_sc_hd__buf_1
X_4389_ _8756_/Q _7531_/Q _4662_/S VGND VGND VPWR VPWR _4389_/X sky130_fd_sc_hd__mux2_2
XFILLER_100_531 VGND VGND VPWR VPWR sky130_fd_sc_hd__fill_1
XFILLER_46_607 VGND VGND VPWR VPWR sky130_fd_sc_hd__decap_3
XFILLER_58_445 VGND VGND VPWR VPWR sky130_fd_sc_hd__decap_3
XFILLER_85_231 VGND VGND VPWR VPWR sky130_fd_sc_hd__fill_1
XFILLER_85_242 VGND VGND VPWR VPWR sky130_fd_sc_hd__decap_3
XFILLER_18_309 VGND VGND VPWR VPWR sky130_fd_sc_hd__decap_3
XFILLER_65_26 VGND VGND VPWR VPWR sky130_fd_sc_hd__decap_3
XFILLER_73_415 VGND VGND VPWR VPWR sky130_fd_sc_hd__decap_3
X_6059_ _6059_/A VGND VGND VPWR VPWR _8095_/D sky130_fd_sc_hd__buf_1
XFILLER_73_437 VGND VGND VPWR VPWR sky130_fd_sc_hd__decap_3
XFILLER_73_459 VGND VGND VPWR VPWR sky130_fd_sc_hd__decap_3
XFILLER_54_651 VGND VGND VPWR VPWR sky130_fd_sc_hd__decap_3
XFILLER_53_172 VGND VGND VPWR VPWR sky130_fd_sc_hd__decap_3
XFILLER_81_492 VGND VGND VPWR VPWR sky130_fd_sc_hd__fill_2
XTAP_TAPCELL_ROW_107_1788 VGND VPWR sky130_fd_sc_hd__tapvpwrvgnd_1
XFILLER_10_710 VGND VGND VPWR VPWR sky130_fd_sc_hd__decap_3
XFILLER_14_41 VGND VGND VPWR VPWR sky130_fd_sc_hd__decap_3
XTAP_TAPCELL_ROW_120_1966 VGND VPWR sky130_fd_sc_hd__tapvpwrvgnd_1
XTAP_TAPCELL_ROW_120_1977 VGND VPWR sky130_fd_sc_hd__tapvpwrvgnd_1
XFILLER_10_743 VGND VGND VPWR VPWR sky130_fd_sc_hd__decap_3
XFILLER_14_74 VGND VGND VPWR VPWR sky130_fd_sc_hd__decap_3
XFILLER_14_85 VGND VGND VPWR VPWR sky130_fd_sc_hd__decap_3
XFILLER_22_592 VGND VGND VPWR VPWR sky130_fd_sc_hd__decap_3
XFILLER_10_787 VGND VGND VPWR VPWR sky130_fd_sc_hd__decap_3
XFILLER_127_439 VGND VGND VPWR VPWR sky130_fd_sc_hd__decap_3
XFILLER_5_213 VGND VGND VPWR VPWR sky130_fd_sc_hd__fill_2
XFILLER_6_725 VGND VGND VPWR VPWR sky130_fd_sc_hd__decap_3
XFILLER_6_769 VGND VGND VPWR VPWR sky130_fd_sc_hd__decap_3
XTAP_TAPCELL_ROW_58_1109 VGND VPWR sky130_fd_sc_hd__tapvpwrvgnd_1
XFILLER_107_141 VGND VGND VPWR VPWR sky130_fd_sc_hd__decap_3
XFILLER_107_163 VGND VGND VPWR VPWR sky130_fd_sc_hd__decap_3
XFILLER_108_686 VGND VGND VPWR VPWR sky130_fd_sc_hd__fill_1
XFILLER_123_623 VGND VGND VPWR VPWR sky130_fd_sc_hd__decap_3
XFILLER_135_483 VGND VGND VPWR VPWR sky130_fd_sc_hd__decap_3
XFILLER_122_144 VGND VGND VPWR VPWR sky130_fd_sc_hd__decap_3
XFILLER_39_60 VGND VGND VPWR VPWR sky130_fd_sc_hd__fill_2
XFILLER_49_423 VGND VGND VPWR VPWR sky130_fd_sc_hd__fill_2
XFILLER_77_732 VGND VGND VPWR VPWR sky130_fd_sc_hd__decap_3
XFILLER_89_570 VGND VGND VPWR VPWR sky130_fd_sc_hd__decap_3
XFILLER_103_380 VGND VGND VPWR VPWR sky130_fd_sc_hd__decap_3
XFILLER_77_776 VGND VGND VPWR VPWR sky130_fd_sc_hd__decap_3
XFILLER_76_253 VGND VGND VPWR VPWR sky130_fd_sc_hd__decap_3
XFILLER_76_286 VGND VGND VPWR VPWR sky130_fd_sc_hd__decap_3
XFILLER_36_139 VGND VGND VPWR VPWR sky130_fd_sc_hd__fill_1
XFILLER_91_212 VGND VGND VPWR VPWR sky130_fd_sc_hd__decap_3
XFILLER_92_746 VGND VGND VPWR VPWR sky130_fd_sc_hd__decap_3
XFILLER_92_757 VGND VGND VPWR VPWR sky130_fd_sc_hd__decap_3
XFILLER_33_802 VGND VGND VPWR VPWR sky130_fd_sc_hd__fill_2
XFILLER_45_673 VGND VGND VPWR VPWR sky130_fd_sc_hd__decap_3
XTAP_TAPCELL_ROW_82_1438 VGND VPWR sky130_fd_sc_hd__tapvpwrvgnd_1
XTAP_TAPCELL_ROW_43_896 VGND VPWR sky130_fd_sc_hd__tapvpwrvgnd_1
X_3760_ _4112_/S VGND VGND VPWR VPWR _3760_/X sky130_fd_sc_hd__clkbuf_2
XFILLER_9_530 VGND VGND VPWR VPWR sky130_fd_sc_hd__decap_3
X_5430_ _7764_/Q _4790_/A _5440_/S VGND VGND VPWR VPWR _5431_/A sky130_fd_sc_hd__mux2_2
XFILLER_114_601 VGND VGND VPWR VPWR sky130_fd_sc_hd__decap_3
X_5361_ _7731_/Q input5/X _5377_/S VGND VGND VPWR VPWR _5362_/A sky130_fd_sc_hd__mux2_2
XFILLER_113_111 VGND VGND VPWR VPWR sky130_fd_sc_hd__fill_1
XFILLER_114_645 VGND VGND VPWR VPWR sky130_fd_sc_hd__fill_2
XFILLER_126_483 VGND VGND VPWR VPWR sky130_fd_sc_hd__decap_3
XFILLER_5_780 VGND VGND VPWR VPWR sky130_fd_sc_hd__decap_3
XFILLER_5_791 VGND VGND VPWR VPWR sky130_fd_sc_hd__decap_3
X_8080_ _8161_/CLK _8080_/D fanout580/X VGND VGND VPWR VPWR _8080_/Q sky130_fd_sc_hd__dfrtp_2
X_7100_ _7100_/A VGND VGND VPWR VPWR _8584_/D sky130_fd_sc_hd__buf_2
X_5292_ _7699_/Q _4857_/X _5310_/S VGND VGND VPWR VPWR _5293_/A sky130_fd_sc_hd__mux2_2
X_4312_ _4336_/C1 _4308_/X _4309_/X _4311_/X _4252_/A VGND VGND VPWR VPWR _4312_/X
+ sky130_fd_sc_hd__a221o_2
XFILLER_59_209 VGND VGND VPWR VPWR sky130_fd_sc_hd__decap_3
XTAP_TAPCELL_ROW_93_1589 VGND VPWR sky130_fd_sc_hd__tapvpwrvgnd_1
X_7031_ _7031_/A VGND VGND VPWR VPWR _8551_/D sky130_fd_sc_hd__buf_2
X_4243_ _8096_/Q _8177_/Q _4247_/S VGND VGND VPWR VPWR _4244_/B sky130_fd_sc_hd__mux2_2
XFILLER_101_317 VGND VGND VPWR VPWR sky130_fd_sc_hd__decap_3
XFILLER_99_389 VGND VGND VPWR VPWR sky130_fd_sc_hd__decap_3
XFILLER_67_220 VGND VGND VPWR VPWR sky130_fd_sc_hd__decap_3
XFILLER_68_743 VGND VGND VPWR VPWR sky130_fd_sc_hd__fill_1
X_4174_ _8656_/Q _4195_/A2 _4600_/A2 _8575_/Q _3955_/A VGND VGND VPWR VPWR _4174_/X
+ sky130_fd_sc_hd__o221a_2
XFILLER_95_573 VGND VGND VPWR VPWR sky130_fd_sc_hd__decap_3
XFILLER_27_139 VGND VGND VPWR VPWR sky130_fd_sc_hd__decap_3
XFILLER_83_746 VGND VGND VPWR VPWR sky130_fd_sc_hd__fill_2
XTAP_TAPCELL_ROW_124_2022 VGND VPWR sky130_fd_sc_hd__tapvpwrvgnd_1
XTAP_TAPCELL_ROW_124_2033 VGND VPWR sky130_fd_sc_hd__tapvpwrvgnd_1
X_7933_ _8274_/CLK _7933_/D load_slew696/X VGND VGND VPWR VPWR _7933_/Q sky130_fd_sc_hd__dfrtp_2
XFILLER_35_18 VGND VGND VPWR VPWR sky130_fd_sc_hd__fill_1
XFILLER_36_651 VGND VGND VPWR VPWR sky130_fd_sc_hd__fill_2
XFILLER_70_407 VGND VGND VPWR VPWR sky130_fd_sc_hd__decap_3
X_7864_ _8765_/CLK _7864_/D load_slew560/X VGND VGND VPWR VPWR _7864_/Q sky130_fd_sc_hd__dfrtp_2
X_7795_ _8700_/CLK _7795_/D load_slew750/X VGND VGND VPWR VPWR _7795_/Q sky130_fd_sc_hd__dfrtp_2
X_6815_ _6815_/A VGND VGND VPWR VPWR _8450_/D sky130_fd_sc_hd__buf_2
X_6746_ _6830_/S VGND VGND VPWR VPWR _6765_/S sky130_fd_sc_hd__buf_2
XFILLER_50_197 VGND VGND VPWR VPWR sky130_fd_sc_hd__fill_1
X_3958_ _3958_/A _3958_/B VGND VGND VPWR VPWR _3958_/X sky130_fd_sc_hd__or2_2
XFILLER_109_417 VGND VGND VPWR VPWR sky130_fd_sc_hd__decap_3
X_3889_ _3889_/A VGND VGND VPWR VPWR _3889_/X sky130_fd_sc_hd__clkbuf_2
X_6677_ _8385_/Q _4976_/A _6681_/S VGND VGND VPWR VPWR _6678_/A sky130_fd_sc_hd__mux2_2
X_8416_ _8735_/CLK _8416_/D load_slew536/X VGND VGND VPWR VPWR _8416_/Q sky130_fd_sc_hd__dfrtp_2
X_5628_ _5628_/A VGND VGND VPWR VPWR _7857_/D sky130_fd_sc_hd__buf_1
XFILLER_3_706 VGND VGND VPWR VPWR sky130_fd_sc_hd__decap_3
XTAP_TAPCELL_ROW_135_2184 VGND VPWR sky130_fd_sc_hd__tapvpwrvgnd_1
XTAP_TAPCELL_ROW_135_2195 VGND VPWR sky130_fd_sc_hd__tapvpwrvgnd_1
X_8347_ _8712_/CLK _8347_/D load_slew689/X VGND VGND VPWR VPWR _8347_/Q sky130_fd_sc_hd__dfrtp_2
X_5559_ _5559_/A VGND VGND VPWR VPWR _7824_/D sky130_fd_sc_hd__buf_1
XFILLER_104_111 VGND VGND VPWR VPWR sky130_fd_sc_hd__decap_3
XFILLER_117_494 VGND VGND VPWR VPWR sky130_fd_sc_hd__decap_3
XFILLER_105_656 VGND VGND VPWR VPWR sky130_fd_sc_hd__decap_3
XFILLER_116_21 VGND VGND VPWR VPWR sky130_fd_sc_hd__decap_3
XFILLER_132_442 VGND VGND VPWR VPWR sky130_fd_sc_hd__decap_3
XTAP_TAPCELL_ROW_53_1028 VGND VPWR sky130_fd_sc_hd__tapvpwrvgnd_1
X_8278_ _8764_/CLK _8278_/D load_slew563/X VGND VGND VPWR VPWR _8278_/Q sky130_fd_sc_hd__dfrtp_2
XFILLER_116_65 VGND VGND VPWR VPWR sky130_fd_sc_hd__fill_1
XFILLER_132_475 VGND VGND VPWR VPWR sky130_fd_sc_hd__fill_1
XFILLER_132_486 VGND VGND VPWR VPWR sky130_fd_sc_hd__decap_3
XFILLER_59_732 VGND VGND VPWR VPWR sky130_fd_sc_hd__fill_1
XFILLER_76_14 VGND VGND VPWR VPWR sky130_fd_sc_hd__fill_1
XTAP_TAPCELL_ROW_53_1039 VGND VPWR sky130_fd_sc_hd__tapvpwrvgnd_1
Xfanout520 fanout522/X VGND VGND VPWR VPWR fanout520/X sky130_fd_sc_hd__clkdlybuf4s25_1
Xfanout542 fanout543/X VGND VGND VPWR VPWR fanout542/X sky130_fd_sc_hd__clkdlybuf4s25_1
X_7229_ _7239_/A1 _4769_/X wire175/X wire205/X hold799/X VGND VGND VPWR VPWR _8660_/D
+ sky130_fd_sc_hd__a32o_2
XFILLER_120_648 VGND VGND VPWR VPWR sky130_fd_sc_hd__decap_3
Xfanout553 fanout613/X VGND VGND VPWR VPWR fanout553/X sky130_fd_sc_hd__clkdlybuf4s25_1
Xfanout564 fanout566/X VGND VGND VPWR VPWR fanout564/X sky130_fd_sc_hd__clkdlybuf4s25_1
Xfanout575 fanout576/X VGND VGND VPWR VPWR fanout575/X sky130_fd_sc_hd__clkdlybuf4s25_1
XFILLER_19_607 VGND VGND VPWR VPWR sky130_fd_sc_hd__decap_3
XFILLER_46_404 VGND VGND VPWR VPWR sky130_fd_sc_hd__decap_3
XTAP_TAPCELL_ROW_109_1817 VGND VPWR sky130_fd_sc_hd__tapvpwrvgnd_1
Xfanout586 fanout594/X VGND VGND VPWR VPWR fanout586/X sky130_fd_sc_hd__clkdlybuf4s25_1
Xfanout597 fanout609/A VGND VGND VPWR VPWR fanout597/X sky130_fd_sc_hd__clkdlybuf4s25_1
XFILLER_132_53 VGND VGND VPWR VPWR sky130_fd_sc_hd__decap_3
XFILLER_18_128 VGND VGND VPWR VPWR sky130_fd_sc_hd__decap_3
XFILLER_18_139 VGND VGND VPWR VPWR sky130_fd_sc_hd__fill_1
XFILLER_58_297 VGND VGND VPWR VPWR sky130_fd_sc_hd__decap_3
XFILLER_74_735 VGND VGND VPWR VPWR sky130_fd_sc_hd__decap_3
XFILLER_74_757 VGND VGND VPWR VPWR sky130_fd_sc_hd__decap_3
XFILLER_86_595 VGND VGND VPWR VPWR sky130_fd_sc_hd__decap_3
XFILLER_132_97 VGND VGND VPWR VPWR sky130_fd_sc_hd__decap_3
XFILLER_14_312 VGND VGND VPWR VPWR sky130_fd_sc_hd__decap_3
XFILLER_26_150 VGND VGND VPWR VPWR sky130_fd_sc_hd__fill_1
XFILLER_26_172 VGND VGND VPWR VPWR sky130_fd_sc_hd__decap_3
XFILLER_27_673 VGND VGND VPWR VPWR sky130_fd_sc_hd__decap_3
XFILLER_42_610 VGND VGND VPWR VPWR sky130_fd_sc_hd__decap_3
XFILLER_25_51 VGND VGND VPWR VPWR sky130_fd_sc_hd__decap_3
XFILLER_42_643 VGND VGND VPWR VPWR sky130_fd_sc_hd__fill_1
XFILLER_42_654 VGND VGND VPWR VPWR sky130_fd_sc_hd__decap_3
XFILLER_25_84 VGND VGND VPWR VPWR sky130_fd_sc_hd__decap_3
XFILLER_41_142 VGND VGND VPWR VPWR sky130_fd_sc_hd__decap_3
XFILLER_128_704 VGND VGND VPWR VPWR sky130_fd_sc_hd__decap_3
XFILLER_41_197 VGND VGND VPWR VPWR sky130_fd_sc_hd__decap_3
XFILLER_10_551 VGND VGND VPWR VPWR sky130_fd_sc_hd__fill_1
XFILLER_128_737 VGND VGND VPWR VPWR sky130_fd_sc_hd__decap_3
XTAP_TAPCELL_ROW_40_855 VGND VPWR sky130_fd_sc_hd__tapvpwrvgnd_1
XFILLER_10_573 VGND VGND VPWR VPWR sky130_fd_sc_hd__decap_3
XFILLER_127_225 VGND VGND VPWR VPWR sky130_fd_sc_hd__decap_3
XFILLER_6_533 VGND VGND VPWR VPWR sky130_fd_sc_hd__decap_3
Xclkbuf_0_CLK CLK VGND VGND VPWR VPWR clkbuf_0_CLK/X sky130_fd_sc_hd__clkbuf_16
XFILLER_123_431 VGND VGND VPWR VPWR sky130_fd_sc_hd__decap_3
XFILLER_135_291 VGND VGND VPWR VPWR sky130_fd_sc_hd__decap_3
XFILLER_111_626 VGND VGND VPWR VPWR sky130_fd_sc_hd__decap_3
XFILLER_123_497 VGND VGND VPWR VPWR sky130_fd_sc_hd__decap_3
XFILLER_2_772 VGND VGND VPWR VPWR sky130_fd_sc_hd__decap_3
XFILLER_96_315 VGND VGND VPWR VPWR sky130_fd_sc_hd__decap_3
XFILLER_110_125 VGND VGND VPWR VPWR sky130_fd_sc_hd__decap_3
XFILLER_2_44 VGND VGND VPWR VPWR sky130_fd_sc_hd__decap_3
XFILLER_77_551 VGND VGND VPWR VPWR sky130_fd_sc_hd__fill_1
XFILLER_2_77 VGND VGND VPWR VPWR sky130_fd_sc_hd__decap_3
XFILLER_77_584 VGND VGND VPWR VPWR sky130_fd_sc_hd__decap_3
XFILLER_2_88 VGND VGND VPWR VPWR sky130_fd_sc_hd__decap_3
XFILLER_64_223 VGND VGND VPWR VPWR sky130_fd_sc_hd__fill_1
XFILLER_66_80 VGND VGND VPWR VPWR sky130_fd_sc_hd__decap_3
XFILLER_18_640 VGND VGND VPWR VPWR sky130_fd_sc_hd__decap_3
XFILLER_18_651 VGND VGND VPWR VPWR sky130_fd_sc_hd__decap_3
XFILLER_64_245 VGND VGND VPWR VPWR sky130_fd_sc_hd__decap_3
XFILLER_64_267 VGND VGND VPWR VPWR sky130_fd_sc_hd__decap_3
XFILLER_66_91 VGND VGND VPWR VPWR sky130_fd_sc_hd__decap_3
XTAP_TAPCELL_ROW_48_966 VGND VPWR sky130_fd_sc_hd__tapvpwrvgnd_1
XFILLER_17_172 VGND VGND VPWR VPWR sky130_fd_sc_hd__decap_3
XFILLER_80_738 VGND VGND VPWR VPWR sky130_fd_sc_hd__fill_1
X_4930_ _4929_/X hold998/X _7453_/S VGND VGND VPWR VPWR _4931_/A sky130_fd_sc_hd__mux2_2
XFILLER_33_632 VGND VGND VPWR VPWR sky130_fd_sc_hd__decap_3
XFILLER_33_665 VGND VGND VPWR VPWR sky130_fd_sc_hd__decap_3
XTAP_TAPCELL_ROW_28_690 VGND VPWR sky130_fd_sc_hd__tapvpwrvgnd_1
X_4861_ _4861_/A VGND VGND VPWR VPWR _4861_/X sky130_fd_sc_hd__buf_1
XFILLER_33_687 VGND VGND VPWR VPWR sky130_fd_sc_hd__decap_3
X_3812_ _7966_/Q _3811_/X _3805_/A _7885_/Q _3894_/A1 VGND VGND VPWR VPWR _3812_/X
+ sky130_fd_sc_hd__o221a_2
X_6600_ _7248_/A2 _8350_/Q _6612_/S VGND VGND VPWR VPWR _6601_/A sky130_fd_sc_hd__mux2_2
XFILLER_32_197 VGND VGND VPWR VPWR sky130_fd_sc_hd__decap_3
XFILLER_60_495 VGND VGND VPWR VPWR sky130_fd_sc_hd__decap_3
XPHY_EDGE_ROW_120_Right_120 VGND VGND VPWR VPWR sky130_fd_sc_hd__decap_3
X_7580_ _8400_/CLK _7580_/D wire555/A VGND VGND VPWR VPWR _7580_/Q sky130_fd_sc_hd__dfrtp_2
X_4792_ _4791_/X _7521_/Q _4820_/S VGND VGND VPWR VPWR _4793_/A sky130_fd_sc_hd__mux2_2
X_3743_ _3751_/A VGND VGND VPWR VPWR _4065_/A sky130_fd_sc_hd__clkbuf_1
X_6531_ _5031_/X _8317_/Q _6549_/S VGND VGND VPWR VPWR _6532_/A sky130_fd_sc_hd__mux2_2
XFILLER_9_371 VGND VGND VPWR VPWR sky130_fd_sc_hd__fill_1
XFILLER_9_393 VGND VGND VPWR VPWR sky130_fd_sc_hd__decap_3
XTAP_TAPCELL_ROW_95_1618 VGND VPWR sky130_fd_sc_hd__tapvpwrvgnd_1
X_6462_ _6462_/A VGND VGND VPWR VPWR _8285_/D sky130_fd_sc_hd__buf_2
XFILLER_134_707 VGND VGND VPWR VPWR sky130_fd_sc_hd__decap_3
XTAP_TAPCELL_ROW_95_1629 VGND VPWR sky130_fd_sc_hd__tapvpwrvgnd_1
Xoutput101 _4043_/X VGND VGND VPWR VPWR rdata[22] sky130_fd_sc_hd__clkdlybuf4s25_1
X_8201_ _8687_/CLK _8201_/D load_slew568/X VGND VGND VPWR VPWR _8201_/Q sky130_fd_sc_hd__dfrtp_2
X_6393_ _6393_/A VGND VGND VPWR VPWR _8252_/D sky130_fd_sc_hd__buf_2
X_5413_ _7756_/Q _4756_/A _5419_/S VGND VGND VPWR VPWR _5414_/A sky130_fd_sc_hd__mux2_2
XFILLER_133_217 VGND VGND VPWR VPWR sky130_fd_sc_hd__decap_3
XFILLER_133_228 VGND VGND VPWR VPWR sky130_fd_sc_hd__decap_3
XFILLER_99_120 VGND VGND VPWR VPWR sky130_fd_sc_hd__fill_1
Xoutput134 _4372_/X VGND VGND VPWR VPWR rdata[52] sky130_fd_sc_hd__clkdlybuf4s25_1
Xoutput123 _4254_/X VGND VGND VPWR VPWR rdata[42] sky130_fd_sc_hd__clkdlybuf4s25_1
Xoutput112 _4144_/X VGND VGND VPWR VPWR rdata[32] sky130_fd_sc_hd__clkdlybuf4s25_1
X_8132_ _8695_/CLK _8132_/D load_slew724/X VGND VGND VPWR VPWR _8132_/Q sky130_fd_sc_hd__dfrtp_2
X_5344_ _7723_/Q _4960_/A _5356_/S VGND VGND VPWR VPWR _5345_/A sky130_fd_sc_hd__mux2_2
Xoutput145 _4487_/X VGND VGND VPWR VPWR rdata[62] sky130_fd_sc_hd__clkdlybuf4s25_1
Xoutput156 _4592_/X VGND VGND VPWR VPWR rdata[72] sky130_fd_sc_hd__clkdlybuf4s25_1
Xoutput167 _3894_/X VGND VGND VPWR VPWR rdata[9] sky130_fd_sc_hd__clkdlybuf4s25_1
XFILLER_114_486 VGND VGND VPWR VPWR sky130_fd_sc_hd__fill_1
XFILLER_99_175 VGND VGND VPWR VPWR sky130_fd_sc_hd__decap_3
X_8063_ _8427_/CLK _8063_/D fanout654/X VGND VGND VPWR VPWR _8063_/Q sky130_fd_sc_hd__dfrtp_2
X_5275_ _7691_/Q _4824_/X _5289_/S VGND VGND VPWR VPWR _5276_/A sky130_fd_sc_hd__mux2_2
XFILLER_102_659 VGND VGND VPWR VPWR sky130_fd_sc_hd__decap_3
XFILLER_68_540 VGND VGND VPWR VPWR sky130_fd_sc_hd__decap_3
X_7014_ _7014_/A VGND VGND VPWR VPWR _8543_/D sky130_fd_sc_hd__buf_2
X_4226_ _8742_/Q _7517_/Q _4226_/S VGND VGND VPWR VPWR _4227_/B sky130_fd_sc_hd__mux2_2
XFILLER_101_169 VGND VGND VPWR VPWR sky130_fd_sc_hd__fill_1
XFILLER_28_415 VGND VGND VPWR VPWR sky130_fd_sc_hd__decap_3
XFILLER_68_562 VGND VGND VPWR VPWR sky130_fd_sc_hd__decap_3
X_4157_ _8412_/Q _8493_/Q _4193_/S VGND VGND VPWR VPWR _4158_/B sky130_fd_sc_hd__mux2_2
XFILLER_110_692 VGND VGND VPWR VPWR sky130_fd_sc_hd__decap_3
XFILLER_56_768 VGND VGND VPWR VPWR sky130_fd_sc_hd__decap_3
XFILLER_71_705 VGND VGND VPWR VPWR sky130_fd_sc_hd__decap_3
X_4088_ _8729_/Q _7504_/Q _7585_/Q _7666_/Q _4088_/S0 _4125_/A VGND VGND VPWR VPWR
+ _4088_/X sky130_fd_sc_hd__mux4_2
XFILLER_71_727 VGND VGND VPWR VPWR sky130_fd_sc_hd__fill_1
X_7916_ _8732_/CLK _7916_/D fanout479/A VGND VGND VPWR VPWR _7916_/Q sky130_fd_sc_hd__dfrtp_2
XFILLER_24_643 VGND VGND VPWR VPWR sky130_fd_sc_hd__fill_1
XFILLER_62_27 VGND VGND VPWR VPWR sky130_fd_sc_hd__fill_1
XTAP_TAPCELL_ROW_104_1747 VGND VPWR sky130_fd_sc_hd__tapvpwrvgnd_1
X_7847_ _8793_/CLK _7847_/D fanout639/X VGND VGND VPWR VPWR _7847_/Q sky130_fd_sc_hd__dfrtp_2
XFILLER_24_665 VGND VGND VPWR VPWR sky130_fd_sc_hd__decap_3
XFILLER_24_698 VGND VGND VPWR VPWR sky130_fd_sc_hd__fill_2
XPHY_EDGE_ROW_43_Left_179 VGND VGND VPWR VPWR sky130_fd_sc_hd__decap_3
XFILLER_11_337 VGND VGND VPWR VPWR sky130_fd_sc_hd__decap_3
X_7778_ _8679_/CLK _7778_/D load_slew696/X VGND VGND VPWR VPWR _7778_/Q sky130_fd_sc_hd__dfrtp_2
XFILLER_134_6 VGND VGND VPWR VPWR sky130_fd_sc_hd__decap_3
X_6729_ _6729_/A VGND VGND VPWR VPWR _8409_/D sky130_fd_sc_hd__buf_2
XFILLER_109_225 VGND VGND VPWR VPWR sky130_fd_sc_hd__decap_3
XFILLER_109_269 VGND VGND VPWR VPWR sky130_fd_sc_hd__fill_1
XFILLER_11_42 VGND VGND VPWR VPWR sky130_fd_sc_hd__decap_3
XFILLER_124_206 VGND VGND VPWR VPWR sky130_fd_sc_hd__decap_3
XFILLER_11_75 VGND VGND VPWR VPWR sky130_fd_sc_hd__decap_3
XFILLER_127_42 VGND VGND VPWR VPWR sky130_fd_sc_hd__decap_3
XFILLER_127_75 VGND VGND VPWR VPWR sky130_fd_sc_hd__decap_3
XFILLER_133_762 VGND VGND VPWR VPWR sky130_fd_sc_hd__decap_3
XFILLER_3_569 VGND VGND VPWR VPWR sky130_fd_sc_hd__decap_3
XFILLER_105_464 VGND VGND VPWR VPWR sky130_fd_sc_hd__decap_3
XFILLER_78_326 VGND VGND VPWR VPWR sky130_fd_sc_hd__decap_3
XFILLER_87_57 VGND VGND VPWR VPWR sky130_fd_sc_hd__decap_3
XPHY_EDGE_ROW_52_Left_188 VGND VGND VPWR VPWR sky130_fd_sc_hd__decap_3
XTAP_TAPCELL_ROW_115_1898 VGND VPWR sky130_fd_sc_hd__tapvpwrvgnd_1
XFILLER_132_283 VGND VGND VPWR VPWR sky130_fd_sc_hd__decap_3
Xfanout350 _4524_/S1 VGND VGND VPWR VPWR _4529_/A sky130_fd_sc_hd__clkdlybuf4s25_1
XTAP_TAPCELL_ROW_6_374 VGND VPWR sky130_fd_sc_hd__tapvpwrvgnd_1
Xfanout361 _4013_/A1 VGND VGND VPWR VPWR _3943_/S1 sky130_fd_sc_hd__clkdlybuf4s25_1
Xfanout383 _4450_/A VGND VGND VPWR VPWR _4415_/A sky130_fd_sc_hd__clkdlybuf4s25_1
XFILLER_46_223 VGND VGND VPWR VPWR sky130_fd_sc_hd__fill_1
XFILLER_47_746 VGND VGND VPWR VPWR sky130_fd_sc_hd__fill_1
XFILLER_86_392 VGND VGND VPWR VPWR sky130_fd_sc_hd__decap_3
Xfanout394 fanout414/X VGND VGND VPWR VPWR _4088_/S0 sky130_fd_sc_hd__clkdlybuf4s25_1
XFILLER_100_191 VGND VGND VPWR VPWR sky130_fd_sc_hd__decap_3
XFILLER_46_256 VGND VGND VPWR VPWR sky130_fd_sc_hd__decap_3
XFILLER_47_768 VGND VGND VPWR VPWR sky130_fd_sc_hd__decap_3
XFILLER_74_554 VGND VGND VPWR VPWR sky130_fd_sc_hd__decap_3
XFILLER_46_289 VGND VGND VPWR VPWR sky130_fd_sc_hd__decap_3
XTAP_TAPCELL_ROW_45_925 VGND VPWR sky130_fd_sc_hd__tapvpwrvgnd_1
XTAP_TAPCELL_ROW_66_1219 VGND VPWR sky130_fd_sc_hd__tapvpwrvgnd_1
XPHY_EDGE_ROW_61_Left_197 VGND VGND VPWR VPWR sky130_fd_sc_hd__decap_3
XFILLER_15_676 VGND VGND VPWR VPWR sky130_fd_sc_hd__decap_3
XFILLER_42_462 VGND VGND VPWR VPWR sky130_fd_sc_hd__fill_2
XFILLER_42_473 VGND VGND VPWR VPWR sky130_fd_sc_hd__decap_3
XFILLER_14_175 VGND VGND VPWR VPWR sky130_fd_sc_hd__decap_3
XFILLER_128_501 VGND VGND VPWR VPWR sky130_fd_sc_hd__decap_3
XFILLER_52_71 VGND VGND VPWR VPWR sky130_fd_sc_hd__decap_3
XFILLER_128_545 VGND VGND VPWR VPWR sky130_fd_sc_hd__decap_3
Xinput14 wdata[1] VGND VGND VPWR VPWR _4952_/A sky130_fd_sc_hd__clkdlybuf4s25_1
Xinput25 wdata[2] VGND VGND VPWR VPWR _4956_/A sky130_fd_sc_hd__clkdlybuf4s25_1
Xinput36 wdata[3] VGND VGND VPWR VPWR _4960_/A sky130_fd_sc_hd__clkdlybuf4s25_1
XFILLER_116_707 VGND VGND VPWR VPWR sky130_fd_sc_hd__fill_1
XFILLER_128_578 VGND VGND VPWR VPWR sky130_fd_sc_hd__decap_3
XFILLER_128_589 VGND VGND VPWR VPWR sky130_fd_sc_hd__decap_3
Xhold809 _8697_/Q VGND VGND VPWR VPWR hold809/X sky130_fd_sc_hd__dlygate4sd3_1
Xinput47 wdata[4] VGND VGND VPWR VPWR _4964_/A sky130_fd_sc_hd__clkdlybuf4s25_1
Xinput58 wdata[5] VGND VGND VPWR VPWR _4968_/A sky130_fd_sc_hd__clkdlybuf4s25_1
Xinput69 wdata[6] VGND VGND VPWR VPWR _4972_/A sky130_fd_sc_hd__clkdlybuf4s25_1
XFILLER_109_781 VGND VGND VPWR VPWR sky130_fd_sc_hd__decap_3
XFILLER_115_228 VGND VGND VPWR VPWR sky130_fd_sc_hd__decap_3
XFILLER_115_239 VGND VGND VPWR VPWR sky130_fd_sc_hd__decap_3
XFILLER_130_209 VGND VGND VPWR VPWR sky130_fd_sc_hd__decap_3
XFILLER_69_326 VGND VGND VPWR VPWR sky130_fd_sc_hd__decap_3
XTAP_TAPCELL_ROW_90_1548 VGND VPWR sky130_fd_sc_hd__tapvpwrvgnd_1
Xload_slew712 fanout711/X VGND VGND VPWR VPWR load_slew712/X sky130_fd_sc_hd__buf_2
XFILLER_111_434 VGND VGND VPWR VPWR sky130_fd_sc_hd__decap_3
XFILLER_69_337 VGND VGND VPWR VPWR sky130_fd_sc_hd__fill_2
XTAP_TAPCELL_ROW_90_1559 VGND VPWR sky130_fd_sc_hd__tapvpwrvgnd_1
X_5060_ _4740_/X _7590_/Q _5074_/S VGND VGND VPWR VPWR _5061_/A sky130_fd_sc_hd__mux2_2
XFILLER_111_467 VGND VGND VPWR VPWR sky130_fd_sc_hd__decap_3
XFILLER_28_3 VGND VGND VPWR VPWR sky130_fd_sc_hd__decap_3
XFILLER_77_90 VGND VGND VPWR VPWR sky130_fd_sc_hd__fill_2
XFILLER_97_679 VGND VGND VPWR VPWR sky130_fd_sc_hd__fill_1
X_4011_ _8073_/Q _8154_/Q _4209_/S VGND VGND VPWR VPWR _4011_/X sky130_fd_sc_hd__mux2_2
XFILLER_38_757 VGND VGND VPWR VPWR sky130_fd_sc_hd__decap_3
XFILLER_65_532 VGND VGND VPWR VPWR sky130_fd_sc_hd__decap_3
XFILLER_25_407 VGND VGND VPWR VPWR sky130_fd_sc_hd__decap_3
XFILLER_37_234 VGND VGND VPWR VPWR sky130_fd_sc_hd__fill_1
XFILLER_65_576 VGND VGND VPWR VPWR sky130_fd_sc_hd__decap_3
XFILLER_92_362 VGND VGND VPWR VPWR sky130_fd_sc_hd__fill_2
X_8750_ _8750_/CLK _8750_/D fanout641/X VGND VGND VPWR VPWR _8750_/Q sky130_fd_sc_hd__dfrtp_2
X_5962_ _5962_/A _5962_/B _5962_/C _5962_/D VGND VGND VPWR VPWR _5962_/Y sky130_fd_sc_hd__nor4_2
XFILLER_46_790 VGND VGND VPWR VPWR sky130_fd_sc_hd__decap_3
X_7701_ _8764_/CLK _7701_/D load_slew563/X VGND VGND VPWR VPWR _7701_/Q sky130_fd_sc_hd__dfrtp_2
X_4913_ _4913_/A VGND VGND VPWR VPWR _4913_/X sky130_fd_sc_hd__buf_1
XTAP_TAPCELL_ROW_23_608 VGND VPWR sky130_fd_sc_hd__tapvpwrvgnd_1
XTAP_TAPCELL_ROW_23_619 VGND VPWR sky130_fd_sc_hd__tapvpwrvgnd_1
X_8681_ _8766_/CLK _8681_/D fanout575/X VGND VGND VPWR VPWR _8681_/Q sky130_fd_sc_hd__dfrtp_2
X_5893_ _5893_/A1 _5893_/A2 _4727_/X _5893_/B1 hold793/X VGND VGND VPWR VPWR _7992_/D
+ sky130_fd_sc_hd__a32o_2
XFILLER_60_281 VGND VGND VPWR VPWR sky130_fd_sc_hd__fill_1
X_7632_ _8699_/CLK _7632_/D load_slew724/X VGND VGND VPWR VPWR _7632_/Q sky130_fd_sc_hd__dfrtp_2
X_4844_ _4844_/A _4852_/B VGND VGND VPWR VPWR _4845_/A sky130_fd_sc_hd__and2_2
XFILLER_21_679 VGND VGND VPWR VPWR sky130_fd_sc_hd__decap_3
X_7563_ _8788_/CLK _7563_/D load_slew663/X VGND VGND VPWR VPWR _7563_/Q sky130_fd_sc_hd__dfrtp_2
X_4775_ _4775_/A VGND VGND VPWR VPWR _7517_/D sky130_fd_sc_hd__buf_1
XFILLER_119_534 VGND VGND VPWR VPWR sky130_fd_sc_hd__fill_2
XFILLER_20_189 VGND VGND VPWR VPWR sky130_fd_sc_hd__decap_3
X_3726_ _3726_/A VGND VGND VPWR VPWR _3890_/A sky130_fd_sc_hd__inv_4
X_6514_ _4999_/X _8309_/Q _6528_/S VGND VGND VPWR VPWR _6515_/A sky130_fd_sc_hd__mux2_2
XFILLER_107_729 VGND VGND VPWR VPWR sky130_fd_sc_hd__decap_3
XFILLER_119_589 VGND VGND VPWR VPWR sky130_fd_sc_hd__fill_1
XFILLER_134_504 VGND VGND VPWR VPWR sky130_fd_sc_hd__decap_3
X_7494_ _7494_/A VGND VGND VPWR VPWR _8802_/D sky130_fd_sc_hd__buf_1
XFILLER_134_548 VGND VGND VPWR VPWR sky130_fd_sc_hd__decap_3
XTAP_TAPCELL_ROW_132_2143 VGND VPWR sky130_fd_sc_hd__tapvpwrvgnd_1
X_6445_ _4861_/X _8277_/Q _6461_/S VGND VGND VPWR VPWR _6446_/A sky130_fd_sc_hd__mux2_2
X_6376_ _6376_/A VGND VGND VPWR VPWR _8244_/D sky130_fd_sc_hd__buf_2
XFILLER_114_250 VGND VGND VPWR VPWR sky130_fd_sc_hd__fill_2
XFILLER_115_773 VGND VGND VPWR VPWR sky130_fd_sc_hd__decap_3
XFILLER_130_710 VGND VGND VPWR VPWR sky130_fd_sc_hd__decap_3
XFILLER_88_635 VGND VGND VPWR VPWR sky130_fd_sc_hd__decap_3
X_8115_ _8689_/CLK _8115_/D load_slew558/X VGND VGND VPWR VPWR _8115_/Q sky130_fd_sc_hd__dfrtp_2
X_5327_ _7716_/Q _4929_/X _5331_/S VGND VGND VPWR VPWR _5328_/A sky130_fd_sc_hd__mux2_2
XFILLER_130_743 VGND VGND VPWR VPWR sky130_fd_sc_hd__decap_3
XFILLER_88_657 VGND VGND VPWR VPWR sky130_fd_sc_hd__fill_1
X_8046_ _8400_/CLK _8046_/D wire555/X VGND VGND VPWR VPWR _8046_/Q sky130_fd_sc_hd__dfrtp_2
XFILLER_130_787 VGND VGND VPWR VPWR sky130_fd_sc_hd__decap_3
XFILLER_29_713 VGND VGND VPWR VPWR sky130_fd_sc_hd__decap_3
XFILLER_87_178 VGND VGND VPWR VPWR sky130_fd_sc_hd__decap_3
X_5258_ _7683_/Q _4791_/X _5268_/S VGND VGND VPWR VPWR _5259_/A sky130_fd_sc_hd__mux2_2
XFILLER_102_489 VGND VGND VPWR VPWR sky130_fd_sc_hd__decap_3
XFILLER_28_223 VGND VGND VPWR VPWR sky130_fd_sc_hd__decap_3
XFILLER_29_735 VGND VGND VPWR VPWR sky130_fd_sc_hd__decap_3
XTAP_TAPCELL_ROW_3_333 VGND VPWR sky130_fd_sc_hd__tapvpwrvgnd_1
X_5189_ _7650_/Q _4995_/X _5205_/S VGND VGND VPWR VPWR _5190_/A sky130_fd_sc_hd__mux2_2
X_4209_ _7758_/Q _7839_/Q _4209_/S VGND VGND VPWR VPWR _4209_/X sky130_fd_sc_hd__mux2_2
XFILLER_28_256 VGND VGND VPWR VPWR sky130_fd_sc_hd__fill_1
XFILLER_83_340 VGND VGND VPWR VPWR sky130_fd_sc_hd__fill_1
XFILLER_83_362 VGND VGND VPWR VPWR sky130_fd_sc_hd__decap_3
XFILLER_43_237 VGND VGND VPWR VPWR sky130_fd_sc_hd__decap_3
XFILLER_12_613 VGND VGND VPWR VPWR sky130_fd_sc_hd__decap_3
XFILLER_24_462 VGND VGND VPWR VPWR sky130_fd_sc_hd__decap_3
XFILLER_51_281 VGND VGND VPWR VPWR sky130_fd_sc_hd__decap_3
XFILLER_11_156 VGND VGND VPWR VPWR sky130_fd_sc_hd__decap_3
XFILLER_132_3 VGND VGND VPWR VPWR sky130_fd_sc_hd__decap_3
XFILLER_8_628 VGND VGND VPWR VPWR sky130_fd_sc_hd__decap_3
XTAP_TAPCELL_ROW_61_1149 VGND VPWR sky130_fd_sc_hd__tapvpwrvgnd_1
XFILLER_22_41 VGND VGND VPWR VPWR sky130_fd_sc_hd__decap_3
XFILLER_7_116 VGND VGND VPWR VPWR sky130_fd_sc_hd__decap_3
XTAP_TAPCELL_ROW_50_994 VGND VPWR sky130_fd_sc_hd__tapvpwrvgnd_1
XFILLER_22_74 VGND VGND VPWR VPWR sky130_fd_sc_hd__decap_3
XFILLER_22_85 VGND VGND VPWR VPWR sky130_fd_sc_hd__decap_3
XTAP_TAPCELL_ROW_117_1927 VGND VPWR sky130_fd_sc_hd__tapvpwrvgnd_1
XFILLER_125_559 VGND VGND VPWR VPWR sky130_fd_sc_hd__fill_1
XFILLER_133_570 VGND VGND VPWR VPWR sky130_fd_sc_hd__decap_3
XFILLER_79_602 VGND VGND VPWR VPWR sky130_fd_sc_hd__decap_3
XFILLER_79_635 VGND VGND VPWR VPWR sky130_fd_sc_hd__decap_3
XFILLER_120_253 VGND VGND VPWR VPWR sky130_fd_sc_hd__decap_3
XFILLER_78_167 VGND VGND VPWR VPWR sky130_fd_sc_hd__decap_3
XFILLER_14_9 VGND VGND VPWR VPWR sky130_fd_sc_hd__decap_3
XFILLER_47_521 VGND VGND VPWR VPWR sky130_fd_sc_hd__decap_3
XFILLER_47_532 VGND VGND VPWR VPWR sky130_fd_sc_hd__fill_2
XFILLER_66_329 VGND VGND VPWR VPWR sky130_fd_sc_hd__decap_3
XFILLER_47_60 VGND VGND VPWR VPWR sky130_fd_sc_hd__decap_3
XFILLER_74_340 VGND VGND VPWR VPWR sky130_fd_sc_hd__decap_3
XFILLER_35_727 VGND VGND VPWR VPWR sky130_fd_sc_hd__fill_1
XFILLER_62_502 VGND VGND VPWR VPWR sky130_fd_sc_hd__decap_3
XFILLER_30_421 VGND VGND VPWR VPWR sky130_fd_sc_hd__decap_3
XFILLER_42_270 VGND VGND VPWR VPWR sky130_fd_sc_hd__decap_3
XFILLER_30_443 VGND VGND VPWR VPWR sky130_fd_sc_hd__decap_3
XFILLER_8_21 VGND VGND VPWR VPWR sky130_fd_sc_hd__decap_3
XFILLER_8_32 VGND VGND VPWR VPWR sky130_fd_sc_hd__decap_3
XFILLER_8_65 VGND VGND VPWR VPWR sky130_fd_sc_hd__decap_3
X_4560_ _8033_/Q _4560_/A2 _4559_/X _4569_/A wire326/X VGND VGND VPWR VPWR _4560_/X
+ sky130_fd_sc_hd__o221a_2
XFILLER_128_342 VGND VGND VPWR VPWR sky130_fd_sc_hd__decap_3
XFILLER_7_650 VGND VGND VPWR VPWR sky130_fd_sc_hd__decap_3
XFILLER_7_694 VGND VGND VPWR VPWR sky130_fd_sc_hd__decap_3
X_4491_ _8441_/Q _8522_/Q _4497_/S VGND VGND VPWR VPWR _4491_/X sky130_fd_sc_hd__mux2_2
X_6230_ _6230_/A VGND VGND VPWR VPWR _8175_/D sky130_fd_sc_hd__buf_6
XFILLER_112_710 VGND VGND VPWR VPWR sky130_fd_sc_hd__fill_2
XFILLER_131_529 VGND VGND VPWR VPWR sky130_fd_sc_hd__decap_3
X_6161_ _4981_/X _8143_/Q _6163_/S VGND VGND VPWR VPWR _6162_/A sky130_fd_sc_hd__mux2_4
XFILLER_124_581 VGND VGND VPWR VPWR sky130_fd_sc_hd__decap_3
XFILLER_124_592 VGND VGND VPWR VPWR sky130_fd_sc_hd__decap_3
X_5112_ _4845_/X _7615_/Q _5116_/S VGND VGND VPWR VPWR _5113_/A sky130_fd_sc_hd__mux2_2
X_6092_ _6092_/A VGND VGND VPWR VPWR _8111_/D sky130_fd_sc_hd__buf_1
XFILLER_84_104 VGND VGND VPWR VPWR sky130_fd_sc_hd__fill_2
XFILLER_85_638 VGND VGND VPWR VPWR sky130_fd_sc_hd__decap_3
X_5043_ _4707_/X _7582_/Q _5053_/S VGND VGND VPWR VPWR _5044_/A sky130_fd_sc_hd__mux2_2
XFILLER_65_340 VGND VGND VPWR VPWR sky130_fd_sc_hd__decap_3
XFILLER_81_800 VGND VGND VPWR VPWR sky130_fd_sc_hd__decap_3
XFILLER_84_148 VGND VGND VPWR VPWR sky130_fd_sc_hd__fill_1
XPHY_EDGE_ROW_108_Left_244 VGND VGND VPWR VPWR sky130_fd_sc_hd__decap_3
XFILLER_38_587 VGND VGND VPWR VPWR sky130_fd_sc_hd__fill_1
XFILLER_53_502 VGND VGND VPWR VPWR sky130_fd_sc_hd__fill_2
XFILLER_93_682 VGND VGND VPWR VPWR sky130_fd_sc_hd__fill_2
X_8802_ _8802_/CLK _8802_/D load_slew587/X VGND VGND VPWR VPWR _8802_/Q sky130_fd_sc_hd__dfrtp_2
XFILLER_80_343 VGND VGND VPWR VPWR sky130_fd_sc_hd__decap_3
X_6994_ _4925_/X _8535_/Q _7000_/S VGND VGND VPWR VPWR _6995_/A sky130_fd_sc_hd__mux2_4
XFILLER_34_760 VGND VGND VPWR VPWR sky130_fd_sc_hd__decap_3
XFILLER_80_365 VGND VGND VPWR VPWR sky130_fd_sc_hd__fill_1
XTAP_TAPCELL_ROW_101_1706 VGND VPWR sky130_fd_sc_hd__tapvpwrvgnd_1
X_8733_ _8733_/CLK _8733_/D load_slew486/X VGND VGND VPWR VPWR _8733_/Q sky130_fd_sc_hd__dfrtp_2
X_5945_ _5933_/X _5934_/X _4895_/X _5935_/X hold848/X VGND VGND VPWR VPWR _8032_/D
+ sky130_fd_sc_hd__a32o_2
XTAP_TAPCELL_ROW_36_799 VGND VPWR sky130_fd_sc_hd__tapvpwrvgnd_1
X_8664_ _8670_/CLK _8664_/D fanout622/X VGND VGND VPWR VPWR _8664_/Q sky130_fd_sc_hd__dfrtp_2
X_5876_ _5868_/X _5879_/A2 _5011_/X _5879_/B1 hold916/X VGND VGND VPWR VPWR _7978_/D
+ sky130_fd_sc_hd__a32o_2
XFILLER_21_443 VGND VGND VPWR VPWR sky130_fd_sc_hd__decap_3
X_7615_ _8518_/CLK _7615_/D fanout705/X VGND VGND VPWR VPWR _7615_/Q sky130_fd_sc_hd__dfrtp_2
X_4827_ _4827_/A VGND VGND VPWR VPWR _7529_/D sky130_fd_sc_hd__buf_1
XFILLER_119_320 VGND VGND VPWR VPWR sky130_fd_sc_hd__decap_3
XPHY_EDGE_ROW_117_Left_253 VGND VGND VPWR VPWR sky130_fd_sc_hd__decap_3
X_8595_ _8676_/CLK _8595_/D fanout702/X VGND VGND VPWR VPWR _8595_/Q sky130_fd_sc_hd__dfrtp_2
X_7546_ _8771_/CLK _7546_/D fanout595/X VGND VGND VPWR VPWR _7546_/Q sky130_fd_sc_hd__dfrtp_2
X_4758_ _4757_/X _4758_/A1 _4778_/S VGND VGND VPWR VPWR _4759_/A sky130_fd_sc_hd__mux2_2
XFILLER_119_397 VGND VGND VPWR VPWR sky130_fd_sc_hd__decap_3
XFILLER_134_301 VGND VGND VPWR VPWR sky130_fd_sc_hd__decap_3
XFILLER_134_312 VGND VGND VPWR VPWR sky130_fd_sc_hd__decap_3
X_3709_ _7004_/A _8049_/Q _6314_/C VGND VGND VPWR VPWR _3712_/A sky130_fd_sc_hd__and3_2
X_7477_ _4995_/X _7477_/A1 _7495_/S VGND VGND VPWR VPWR _7478_/A sky130_fd_sc_hd__mux2_2
X_4689_ _5970_/B VGND VGND VPWR VPWR _4734_/B sky130_fd_sc_hd__clkbuf_1
XFILLER_134_356 VGND VGND VPWR VPWR sky130_fd_sc_hd__decap_3
XTAP_TAPCELL_ROW_8_403 VGND VPWR sky130_fd_sc_hd__tapvpwrvgnd_1
X_6428_ _7248_/A2 _8269_/Q _6440_/S VGND VGND VPWR VPWR _6429_/A sky130_fd_sc_hd__mux2_2
XFILLER_108_55 VGND VGND VPWR VPWR sky130_fd_sc_hd__decap_3
XFILLER_134_389 VGND VGND VPWR VPWR sky130_fd_sc_hd__decap_3
XFILLER_68_15 VGND VGND VPWR VPWR sky130_fd_sc_hd__decap_3
XFILLER_108_99 VGND VGND VPWR VPWR sky130_fd_sc_hd__decap_3
XFILLER_88_421 VGND VGND VPWR VPWR sky130_fd_sc_hd__decap_3
XTAP_TAPCELL_ROW_112_1857 VGND VPWR sky130_fd_sc_hd__tapvpwrvgnd_1
X_6359_ _5031_/X _8236_/Q _6377_/S VGND VGND VPWR VPWR _6360_/A sky130_fd_sc_hd__mux2_2
XFILLER_124_21 VGND VGND VPWR VPWR sky130_fd_sc_hd__decap_3
XFILLER_130_551 VGND VGND VPWR VPWR sky130_fd_sc_hd__decap_3
XPHY_EDGE_ROW_126_Left_262 VGND VGND VPWR VPWR sky130_fd_sc_hd__decap_3
XFILLER_102_286 VGND VGND VPWR VPWR sky130_fd_sc_hd__fill_2
XFILLER_124_32 VGND VGND VPWR VPWR sky130_fd_sc_hd__decap_3
XFILLER_130_584 VGND VGND VPWR VPWR sky130_fd_sc_hd__decap_3
XFILLER_130_595 VGND VGND VPWR VPWR sky130_fd_sc_hd__decap_3
X_8029_ _8029_/CLK _8029_/D load_slew565/X VGND VGND VPWR VPWR _8029_/Q sky130_fd_sc_hd__dfrtp_2
XFILLER_75_148 VGND VGND VPWR VPWR sky130_fd_sc_hd__decap_3
XFILLER_84_25 VGND VGND VPWR VPWR sky130_fd_sc_hd__decap_3
XFILLER_91_608 VGND VGND VPWR VPWR sky130_fd_sc_hd__decap_3
XFILLER_17_30 VGND VGND VPWR VPWR sky130_fd_sc_hd__decap_3
XFILLER_17_727 VGND VGND VPWR VPWR sky130_fd_sc_hd__fill_1
XFILLER_17_738 VGND VGND VPWR VPWR sky130_fd_sc_hd__decap_3
XFILLER_29_576 VGND VGND VPWR VPWR sky130_fd_sc_hd__decap_3
XFILLER_44_502 VGND VGND VPWR VPWR sky130_fd_sc_hd__fill_2
XFILLER_44_513 VGND VGND VPWR VPWR sky130_fd_sc_hd__decap_3
XFILLER_84_671 VGND VGND VPWR VPWR sky130_fd_sc_hd__decap_3
XFILLER_90_107 VGND VGND VPWR VPWR sky130_fd_sc_hd__fill_2
XFILLER_17_63 VGND VGND VPWR VPWR sky130_fd_sc_hd__decap_3
XFILLER_71_343 VGND VGND VPWR VPWR sky130_fd_sc_hd__fill_1
XFILLER_83_192 VGND VGND VPWR VPWR sky130_fd_sc_hd__decap_3
XFILLER_71_365 VGND VGND VPWR VPWR sky130_fd_sc_hd__fill_2
XFILLER_71_376 VGND VGND VPWR VPWR sky130_fd_sc_hd__decap_3
XFILLER_12_410 VGND VGND VPWR VPWR sky130_fd_sc_hd__decap_3
XFILLER_12_421 VGND VGND VPWR VPWR sky130_fd_sc_hd__decap_3
XFILLER_40_741 VGND VGND VPWR VPWR sky130_fd_sc_hd__decap_3
XFILLER_40_763 VGND VGND VPWR VPWR sky130_fd_sc_hd__fill_1
XPHY_EDGE_ROW_135_Left_271 VGND VGND VPWR VPWR sky130_fd_sc_hd__decap_3
Xclkbuf_5_24__f_CLK clkbuf_4_12_0_CLK/X VGND VGND VPWR VPWR clkbuf_leaf_89_CLK/A sky130_fd_sc_hd__clkbuf_16
XFILLER_129_128 VGND VGND VPWR VPWR sky130_fd_sc_hd__decap_3
XFILLER_126_802 VGND VGND VPWR VPWR sky130_fd_sc_hd__fill_2
XFILLER_125_312 VGND VGND VPWR VPWR sky130_fd_sc_hd__decap_3
XFILLER_125_323 VGND VGND VPWR VPWR sky130_fd_sc_hd__decap_3
XFILLER_4_631 VGND VGND VPWR VPWR sky130_fd_sc_hd__decap_3
XTAP_TAPCELL_ROW_74_1329 VGND VPWR sky130_fd_sc_hd__tapvpwrvgnd_1
XFILLER_125_389 VGND VGND VPWR VPWR sky130_fd_sc_hd__decap_3
XFILLER_4_675 VGND VGND VPWR VPWR sky130_fd_sc_hd__decap_3
XFILLER_106_581 VGND VGND VPWR VPWR sky130_fd_sc_hd__decap_3
XFILLER_106_592 VGND VGND VPWR VPWR sky130_fd_sc_hd__decap_3
XFILLER_79_432 VGND VGND VPWR VPWR sky130_fd_sc_hd__decap_3
XFILLER_39_307 VGND VGND VPWR VPWR sky130_fd_sc_hd__decap_3
XFILLER_121_573 VGND VGND VPWR VPWR sky130_fd_sc_hd__fill_1
XFILLER_121_595 VGND VGND VPWR VPWR sky130_fd_sc_hd__fill_1
XFILLER_66_126 VGND VGND VPWR VPWR sky130_fd_sc_hd__decap_3
XFILLER_94_424 VGND VGND VPWR VPWR sky130_fd_sc_hd__decap_3
XFILLER_12_6 VGND VGND VPWR VPWR sky130_fd_sc_hd__decap_3
XFILLER_82_608 VGND VGND VPWR VPWR sky130_fd_sc_hd__decap_3
XFILLER_63_800 VGND VGND VPWR VPWR sky130_fd_sc_hd__decap_3
XFILLER_75_660 VGND VGND VPWR VPWR sky130_fd_sc_hd__decap_3
XFILLER_75_682 VGND VGND VPWR VPWR sky130_fd_sc_hd__decap_3
XFILLER_35_557 VGND VGND VPWR VPWR sky130_fd_sc_hd__decap_3
XFILLER_62_365 VGND VGND VPWR VPWR sky130_fd_sc_hd__decap_3
XFILLER_74_91 VGND VGND VPWR VPWR sky130_fd_sc_hd__decap_3
XFILLER_90_685 VGND VGND VPWR VPWR sky130_fd_sc_hd__decap_3
X_3991_ _3925_/A _3986_/X _3988_/X _3990_/X VGND VGND VPWR VPWR _3991_/X sky130_fd_sc_hd__a22o_2
X_5730_ _7905_/Q _4703_/A _5742_/S VGND VGND VPWR VPWR _5731_/A sky130_fd_sc_hd__mux2_2
XFILLER_15_281 VGND VGND VPWR VPWR sky130_fd_sc_hd__fill_1
XFILLER_31_741 VGND VGND VPWR VPWR sky130_fd_sc_hd__decap_3
XTAP_TAPCELL_ROW_33_758 VGND VPWR sky130_fd_sc_hd__tapvpwrvgnd_1
XFILLER_30_262 VGND VGND VPWR VPWR sky130_fd_sc_hd__decap_3
XFILLER_31_785 VGND VGND VPWR VPWR sky130_fd_sc_hd__decap_3
X_7400_ _7400_/A VGND VGND VPWR VPWR _8757_/D sky130_fd_sc_hd__buf_1
X_5661_ hold984/X _4908_/A _5675_/S VGND VGND VPWR VPWR _5662_/A sky130_fd_sc_hd__mux2_2
XFILLER_129_662 VGND VGND VPWR VPWR sky130_fd_sc_hd__decap_3
XFILLER_135_109 VGND VGND VPWR VPWR sky130_fd_sc_hd__decap_3
XFILLER_30_284 VGND VGND VPWR VPWR sky130_fd_sc_hd__decap_3
XTAP_TAPCELL_ROW_13_471 VGND VPWR sky130_fd_sc_hd__tapvpwrvgnd_1
X_8380_ _8623_/CLK _8380_/D load_slew676/X VGND VGND VPWR VPWR _8380_/Q sky130_fd_sc_hd__dfrtp_2
X_5592_ _5592_/A VGND VGND VPWR VPWR _7840_/D sky130_fd_sc_hd__buf_1
X_4612_ _4633_/A _4610_/X _4611_/X VGND VGND VPWR VPWR _4612_/X sky130_fd_sc_hd__o21a_2
XFILLER_116_301 VGND VGND VPWR VPWR sky130_fd_sc_hd__decap_3
XFILLER_116_312 VGND VGND VPWR VPWR sky130_fd_sc_hd__decap_3
XFILLER_128_150 VGND VGND VPWR VPWR sky130_fd_sc_hd__decap_3
XFILLER_129_673 VGND VGND VPWR VPWR sky130_fd_sc_hd__decap_3
X_7331_ _7331_/A VGND VGND VPWR VPWR _8724_/D sky130_fd_sc_hd__buf_1
X_4543_ _4543_/A _4543_/B VGND VGND VPWR VPWR _4543_/X sky130_fd_sc_hd__or2_2
XFILLER_128_183 VGND VGND VPWR VPWR sky130_fd_sc_hd__decap_3
X_7262_ _7254_/X _4875_/X _7266_/A3 _7266_/B1 hold768/X VGND VGND VPWR VPWR _8685_/D
+ sky130_fd_sc_hd__a32o_2
XFILLER_104_529 VGND VGND VPWR VPWR sky130_fd_sc_hd__decap_3
XFILLER_89_207 VGND VGND VPWR VPWR sky130_fd_sc_hd__fill_1
Xmax_cap177 _7191_/X VGND VGND VPWR VPWR _7201_/A3 sky130_fd_sc_hd__buf_2
X_6213_ _6213_/A VGND VGND VPWR VPWR _8167_/D sky130_fd_sc_hd__buf_6
X_4474_ _8763_/Q _7538_/Q _7619_/Q _7700_/Q _4497_/S _4498_/A VGND VGND VPWR VPWR
+ _4474_/X sky130_fd_sc_hd__mux4_2
XFILLER_131_337 VGND VGND VPWR VPWR sky130_fd_sc_hd__decap_3
Xmax_cap199 _3805_/X VGND VGND VPWR VPWR _4660_/A2 sky130_fd_sc_hd__buf_6
Xmax_cap188 _5895_/X VGND VGND VPWR VPWR _5906_/A2 sky130_fd_sc_hd__buf_2
X_7193_ _7189_/X _4989_/X _7191_/X _7192_/X hold777/X VGND VGND VPWR VPWR _8631_/D
+ sky130_fd_sc_hd__a32o_2
XFILLER_38_18 VGND VGND VPWR VPWR sky130_fd_sc_hd__decap_3
XFILLER_58_605 VGND VGND VPWR VPWR sky130_fd_sc_hd__decap_3
XFILLER_98_763 VGND VGND VPWR VPWR sky130_fd_sc_hd__decap_3
X_6144_ _6312_/S VGND VGND VPWR VPWR _6163_/S sky130_fd_sc_hd__buf_6
XFILLER_100_713 VGND VGND VPWR VPWR sky130_fd_sc_hd__decap_3
XFILLER_38_29 VGND VGND VPWR VPWR sky130_fd_sc_hd__fill_1
XFILLER_57_126 VGND VGND VPWR VPWR sky130_fd_sc_hd__decap_3
XFILLER_97_284 VGND VGND VPWR VPWR sky130_fd_sc_hd__fill_1
Xload_slew372 fanout371/X VGND VGND VPWR VPWR _4344_/A sky130_fd_sc_hd__buf_4
X_6075_ _6075_/A VGND VGND VPWR VPWR _8103_/D sky130_fd_sc_hd__buf_1
XTAP_TAPCELL_ROW_127_2064 VGND VPWR sky130_fd_sc_hd__tapvpwrvgnd_1
X_5026_ _5026_/A _5026_/B VGND VGND VPWR VPWR _5027_/A sky130_fd_sc_hd__and2_2
XFILLER_66_660 VGND VGND VPWR VPWR sky130_fd_sc_hd__decap_3
XTAP_TAPCELL_ROW_127_2075 VGND VPWR sky130_fd_sc_hd__tapvpwrvgnd_1
XFILLER_65_181 VGND VGND VPWR VPWR sky130_fd_sc_hd__decap_3
XFILLER_26_579 VGND VGND VPWR VPWR sky130_fd_sc_hd__decap_3
XFILLER_41_505 VGND VGND VPWR VPWR sky130_fd_sc_hd__decap_3
X_6977_ _4891_/X _8527_/Q _6979_/S VGND VGND VPWR VPWR _6978_/A sky130_fd_sc_hd__mux2_4
XFILLER_81_696 VGND VGND VPWR VPWR sky130_fd_sc_hd__fill_1
X_8716_ _8800_/CLK _8716_/D load_slew593/X VGND VGND VPWR VPWR _8716_/Q sky130_fd_sc_hd__dfrtp_2
X_5928_ _5931_/A1 _5932_/A2 _4837_/X _5932_/B1 hold823/X VGND VGND VPWR VPWR _8018_/D
+ sky130_fd_sc_hd__a32o_2
XFILLER_110_56 VGND VGND VPWR VPWR sky130_fd_sc_hd__decap_3
XFILLER_22_763 VGND VGND VPWR VPWR sky130_fd_sc_hd__fill_2
XFILLER_70_27 VGND VGND VPWR VPWR sky130_fd_sc_hd__fill_1
XFILLER_70_49 VGND VGND VPWR VPWR sky130_fd_sc_hd__decap_3
X_8647_ _8647_/CLK _8647_/D fanout534/X VGND VGND VPWR VPWR _8647_/Q sky130_fd_sc_hd__dfrtp_2
X_5859_ _5867_/A1 _5867_/A2 _4953_/X _5857_/X hold838/X VGND VGND VPWR VPWR _7964_/D
+ sky130_fd_sc_hd__a32o_2
XFILLER_21_284 VGND VGND VPWR VPWR sky130_fd_sc_hd__decap_3
X_8578_ _8735_/CLK _8578_/D fanout539/X VGND VGND VPWR VPWR _8578_/Q sky130_fd_sc_hd__dfrtp_2
XFILLER_119_21 VGND VGND VPWR VPWR sky130_fd_sc_hd__decap_3
XFILLER_119_54 VGND VGND VPWR VPWR sky130_fd_sc_hd__fill_2
XFILLER_126_109 VGND VGND VPWR VPWR sky130_fd_sc_hd__decap_3
X_7529_ _8680_/CLK _7529_/D wire693/X VGND VGND VPWR VPWR _7529_/Q sky130_fd_sc_hd__dfrtp_2
XFILLER_135_643 VGND VGND VPWR VPWR sky130_fd_sc_hd__fill_1
XFILLER_135_654 VGND VGND VPWR VPWR sky130_fd_sc_hd__decap_3
XFILLER_134_153 VGND VGND VPWR VPWR sky130_fd_sc_hd__decap_3
XFILLER_135_687 VGND VGND VPWR VPWR sky130_fd_sc_hd__decap_3
XFILLER_1_601 VGND VGND VPWR VPWR sky130_fd_sc_hd__decap_3
XFILLER_0_100 VGND VGND VPWR VPWR sky130_fd_sc_hd__decap_3
XFILLER_134_186 VGND VGND VPWR VPWR sky130_fd_sc_hd__decap_3
XFILLER_134_197 VGND VGND VPWR VPWR sky130_fd_sc_hd__decap_3
XFILLER_1_623 VGND VGND VPWR VPWR sky130_fd_sc_hd__decap_3
Xhold970 _8789_/Q VGND VGND VPWR VPWR hold970/X sky130_fd_sc_hd__dlygate4sd3_1
Xhold981 _7592_/Q VGND VGND VPWR VPWR hold981/X sky130_fd_sc_hd__dlygate4sd3_1
XFILLER_0_122 VGND VGND VPWR VPWR sky130_fd_sc_hd__fill_2
XFILLER_135_53 VGND VGND VPWR VPWR sky130_fd_sc_hd__decap_3
XFILLER_1_656 VGND VGND VPWR VPWR sky130_fd_sc_hd__decap_3
XFILLER_88_251 VGND VGND VPWR VPWR sky130_fd_sc_hd__fill_1
Xhold992 _7713_/Q VGND VGND VPWR VPWR hold992/X sky130_fd_sc_hd__dlygate4sd3_1
XFILLER_0_166 VGND VGND VPWR VPWR sky130_fd_sc_hd__fill_2
XFILLER_130_370 VGND VGND VPWR VPWR sky130_fd_sc_hd__decap_3
XFILLER_135_75 VGND VGND VPWR VPWR sky130_fd_sc_hd__decap_3
XFILLER_135_97 VGND VGND VPWR VPWR sky130_fd_sc_hd__decap_3
XFILLER_76_424 VGND VGND VPWR VPWR sky130_fd_sc_hd__decap_3
XFILLER_88_262 VGND VGND VPWR VPWR sky130_fd_sc_hd__decap_3
XFILLER_89_785 VGND VGND VPWR VPWR sky130_fd_sc_hd__fill_2
XFILLER_95_57 VGND VGND VPWR VPWR sky130_fd_sc_hd__decap_3
XFILLER_45_800 VGND VGND VPWR VPWR sky130_fd_sc_hd__decap_3
XFILLER_57_671 VGND VGND VPWR VPWR sky130_fd_sc_hd__fill_1
XFILLER_91_405 VGND VGND VPWR VPWR sky130_fd_sc_hd__fill_2
XFILLER_91_449 VGND VGND VPWR VPWR sky130_fd_sc_hd__decap_3
XFILLER_17_557 VGND VGND VPWR VPWR sky130_fd_sc_hd__decap_3
XFILLER_60_803 VGND VGND VPWR VPWR sky130_fd_sc_hd__fill_1
XFILLER_44_376 VGND VGND VPWR VPWR sky130_fd_sc_hd__decap_3
XFILLER_13_741 VGND VGND VPWR VPWR sky130_fd_sc_hd__decap_3
XFILLER_44_72 VGND VGND VPWR VPWR sky130_fd_sc_hd__decap_3
XFILLER_44_94 VGND VGND VPWR VPWR sky130_fd_sc_hd__fill_1
XFILLER_13_774 VGND VGND VPWR VPWR sky130_fd_sc_hd__decap_3
XFILLER_13_785 VGND VGND VPWR VPWR sky130_fd_sc_hd__decap_3
XFILLER_8_200 VGND VGND VPWR VPWR sky130_fd_sc_hd__fill_2
XFILLER_8_211 VGND VGND VPWR VPWR sky130_fd_sc_hd__decap_3
XFILLER_9_712 VGND VGND VPWR VPWR sky130_fd_sc_hd__decap_3
XTAP_TAPCELL_ROW_30_706 VGND VPWR sky130_fd_sc_hd__tapvpwrvgnd_1
XTAP_TAPCELL_ROW_30_717 VGND VPWR sky130_fd_sc_hd__tapvpwrvgnd_1
XFILLER_9_756 VGND VGND VPWR VPWR sky130_fd_sc_hd__decap_3
XFILLER_126_610 VGND VGND VPWR VPWR sky130_fd_sc_hd__decap_3
XTAP_TAPCELL_ROW_10_430 VGND VPWR sky130_fd_sc_hd__tapvpwrvgnd_1
XFILLER_126_654 VGND VGND VPWR VPWR sky130_fd_sc_hd__fill_2
XFILLER_5_33 VGND VGND VPWR VPWR sky130_fd_sc_hd__decap_3
XFILLER_99_505 VGND VGND VPWR VPWR sky130_fd_sc_hd__decap_3
XFILLER_126_698 VGND VGND VPWR VPWR sky130_fd_sc_hd__fill_2
XFILLER_5_66 VGND VGND VPWR VPWR sky130_fd_sc_hd__decap_3
XFILLER_5_99 VGND VGND VPWR VPWR sky130_fd_sc_hd__decap_3
XFILLER_69_91 VGND VGND VPWR VPWR sky130_fd_sc_hd__decap_3
XFILLER_79_240 VGND VGND VPWR VPWR sky130_fd_sc_hd__decap_3
X_4190_ _3820_/X _4187_/X _4189_/X _3733_/A VGND VGND VPWR VPWR _4190_/X sky130_fd_sc_hd__o211a_2
XFILLER_121_370 VGND VGND VPWR VPWR sky130_fd_sc_hd__decap_3
XFILLER_79_284 VGND VGND VPWR VPWR sky130_fd_sc_hd__fill_1
XFILLER_10_3 VGND VGND VPWR VPWR sky130_fd_sc_hd__decap_3
XFILLER_67_446 VGND VGND VPWR VPWR sky130_fd_sc_hd__fill_2
XFILLER_94_221 VGND VGND VPWR VPWR sky130_fd_sc_hd__decap_3
XFILLER_95_744 VGND VGND VPWR VPWR sky130_fd_sc_hd__fill_1
XTAP_TAPCELL_ROW_87_1509 VGND VPWR sky130_fd_sc_hd__tapvpwrvgnd_1
XTAP_TAPCELL_ROW_38_828 VGND VPWR sky130_fd_sc_hd__tapvpwrvgnd_1
XFILLER_35_321 VGND VGND VPWR VPWR sky130_fd_sc_hd__fill_1
XFILLER_63_641 VGND VGND VPWR VPWR sky130_fd_sc_hd__decap_3
X_7880_ _8700_/CLK _7880_/D wire746/X VGND VGND VPWR VPWR _7880_/Q sky130_fd_sc_hd__dfrtp_2
X_6900_ _4735_/X _8490_/Q _6916_/S VGND VGND VPWR VPWR _6901_/A sky130_fd_sc_hd__mux2_4
XFILLER_23_505 VGND VGND VPWR VPWR sky130_fd_sc_hd__decap_3
XFILLER_51_803 VGND VGND VPWR VPWR sky130_fd_sc_hd__fill_1
XTAP_TAPCELL_ROW_18_541 VGND VPWR sky130_fd_sc_hd__tapvpwrvgnd_1
X_6831_ _6831_/A VGND VGND VPWR VPWR _8458_/D sky130_fd_sc_hd__buf_1
XFILLER_23_538 VGND VGND VPWR VPWR sky130_fd_sc_hd__decap_3
XFILLER_35_376 VGND VGND VPWR VPWR sky130_fd_sc_hd__decap_3
XFILLER_50_324 VGND VGND VPWR VPWR sky130_fd_sc_hd__decap_3
XFILLER_62_162 VGND VGND VPWR VPWR sky130_fd_sc_hd__decap_3
X_3974_ _7979_/Q _4652_/A2 _4551_/B1 _7898_/Q _4000_/A VGND VGND VPWR VPWR _3974_/X
+ sky130_fd_sc_hd__o221a_2
X_8501_ _8751_/CLK _8501_/D fanout629/X VGND VGND VPWR VPWR _8501_/Q sky130_fd_sc_hd__dfrtp_2
X_6762_ _6762_/A VGND VGND VPWR VPWR _8425_/D sky130_fd_sc_hd__buf_2
X_6693_ _6693_/A VGND VGND VPWR VPWR _8392_/D sky130_fd_sc_hd__buf_2
X_5713_ _7897_/Q _5011_/A _5721_/S VGND VGND VPWR VPWR _5714_/A sky130_fd_sc_hd__mux2_2
X_8432_ _8679_/CLK _8432_/D fanout702/X VGND VGND VPWR VPWR _8432_/Q sky130_fd_sc_hd__dfrtp_2
X_5644_ _7865_/Q _4875_/A _5654_/S VGND VGND VPWR VPWR _5645_/A sky130_fd_sc_hd__mux2_2
XFILLER_117_610 VGND VGND VPWR VPWR sky130_fd_sc_hd__decap_3
XFILLER_129_470 VGND VGND VPWR VPWR sky130_fd_sc_hd__decap_3
X_8363_ _8687_/CLK _8363_/D load_slew568/X VGND VGND VPWR VPWR _8363_/Q sky130_fd_sc_hd__dfrtp_2
X_7314_ _7314_/A VGND VGND VPWR VPWR _8716_/D sky130_fd_sc_hd__buf_1
X_5575_ _7832_/Q _4735_/A _5591_/S VGND VGND VPWR VPWR _5576_/A sky130_fd_sc_hd__mux2_2
XFILLER_117_676 VGND VGND VPWR VPWR sky130_fd_sc_hd__decap_3
XFILLER_132_613 VGND VGND VPWR VPWR sky130_fd_sc_hd__decap_3
X_8294_ _8780_/CLK _8294_/D load_slew722/X VGND VGND VPWR VPWR _8294_/Q sky130_fd_sc_hd__dfrtp_2
X_4526_ _4522_/X _4525_/X _4526_/S VGND VGND VPWR VPWR _4527_/A sky130_fd_sc_hd__mux2_2
XFILLER_49_17 VGND VGND VPWR VPWR sky130_fd_sc_hd__decap_3
X_7245_ _7241_/X _4815_/X _7243_/X _7244_/X hold864/X VGND VGND VPWR VPWR _8671_/D
+ sky130_fd_sc_hd__a32o_2
X_4457_ _4393_/A _4453_/X _4455_/X _4456_/X VGND VGND VPWR VPWR _4457_/X sky130_fd_sc_hd__a22o_2
XFILLER_131_134 VGND VGND VPWR VPWR sky130_fd_sc_hd__decap_3
XFILLER_132_657 VGND VGND VPWR VPWR sky130_fd_sc_hd__decap_3
XTAP_TAPCELL_ROW_129_2104 VGND VPWR sky130_fd_sc_hd__tapvpwrvgnd_1
Xfanout702 fanout754/X VGND VGND VPWR VPWR fanout702/X sky130_fd_sc_hd__clkdlybuf4s25_1
Xfanout713 fanout716/X VGND VGND VPWR VPWR fanout713/X sky130_fd_sc_hd__clkdlybuf4s25_1
X_7176_ _7269_/A VGND VGND VPWR VPWR _7176_/X sky130_fd_sc_hd__clkbuf_1
XFILLER_131_167 VGND VGND VPWR VPWR sky130_fd_sc_hd__fill_1
XFILLER_131_178 VGND VGND VPWR VPWR sky130_fd_sc_hd__decap_3
X_6127_ _8128_/Q _4916_/A _6137_/S VGND VGND VPWR VPWR _6128_/A sky130_fd_sc_hd__mux2_2
X_4388_ _7612_/Q _4388_/B VGND VGND VPWR VPWR _4388_/X sky130_fd_sc_hd__or2_2
XFILLER_58_457 VGND VGND VPWR VPWR sky130_fd_sc_hd__decap_3
XFILLER_86_766 VGND VGND VPWR VPWR sky130_fd_sc_hd__decap_3
XFILLER_39_671 VGND VGND VPWR VPWR sky130_fd_sc_hd__fill_1
XFILLER_46_619 VGND VGND VPWR VPWR sky130_fd_sc_hd__decap_3
XFILLER_65_38 VGND VGND VPWR VPWR sky130_fd_sc_hd__decap_3
XFILLER_73_427 VGND VGND VPWR VPWR sky130_fd_sc_hd__fill_1
X_6058_ _8095_/Q _4776_/A _6074_/S VGND VGND VPWR VPWR _6059_/A sky130_fd_sc_hd__mux2_2
XFILLER_121_11 VGND VGND VPWR VPWR sky130_fd_sc_hd__decap_3
XFILLER_38_181 VGND VGND VPWR VPWR sky130_fd_sc_hd__decap_3
XFILLER_39_682 VGND VGND VPWR VPWR sky130_fd_sc_hd__fill_2
XFILLER_54_630 VGND VGND VPWR VPWR sky130_fd_sc_hd__decap_3
XFILLER_73_449 VGND VGND VPWR VPWR sky130_fd_sc_hd__fill_1
XPHY_EDGE_ROW_134_Right_134 VGND VGND VPWR VPWR sky130_fd_sc_hd__decap_3
X_5009_ _5009_/A VGND VGND VPWR VPWR _7572_/D sky130_fd_sc_hd__buf_1
XFILLER_38_192 VGND VGND VPWR VPWR sky130_fd_sc_hd__decap_3
XFILLER_54_663 VGND VGND VPWR VPWR sky130_fd_sc_hd__decap_3
XFILLER_81_26 VGND VGND VPWR VPWR sky130_fd_sc_hd__decap_3
XTAP_TAPCELL_ROW_107_1789 VGND VPWR sky130_fd_sc_hd__tapvpwrvgnd_1
XFILLER_41_335 VGND VGND VPWR VPWR sky130_fd_sc_hd__fill_1
XFILLER_41_346 VGND VGND VPWR VPWR sky130_fd_sc_hd__decap_3
XFILLER_14_53 VGND VGND VPWR VPWR sky130_fd_sc_hd__decap_3
XFILLER_22_571 VGND VGND VPWR VPWR sky130_fd_sc_hd__decap_3
XTAP_TAPCELL_ROW_120_1967 VGND VPWR sky130_fd_sc_hd__tapvpwrvgnd_1
XTAP_TAPCELL_ROW_120_1978 VGND VPWR sky130_fd_sc_hd__tapvpwrvgnd_1
XFILLER_10_722 VGND VGND VPWR VPWR sky130_fd_sc_hd__decap_3
XFILLER_10_755 VGND VGND VPWR VPWR sky130_fd_sc_hd__fill_1
XFILLER_10_766 VGND VGND VPWR VPWR sky130_fd_sc_hd__decap_3
XFILLER_14_97 VGND VGND VPWR VPWR sky130_fd_sc_hd__decap_3
XFILLER_6_704 VGND VGND VPWR VPWR sky130_fd_sc_hd__decap_3
XFILLER_108_654 VGND VGND VPWR VPWR sky130_fd_sc_hd__fill_2
XFILLER_10_799 VGND VGND VPWR VPWR sky130_fd_sc_hd__decap_3
XFILLER_6_737 VGND VGND VPWR VPWR sky130_fd_sc_hd__decap_3
XFILLER_107_153 VGND VGND VPWR VPWR sky130_fd_sc_hd__decap_3
XFILLER_5_269 VGND VGND VPWR VPWR sky130_fd_sc_hd__decap_3
XFILLER_107_175 VGND VGND VPWR VPWR sky130_fd_sc_hd__decap_3
XFILLER_122_112 VGND VGND VPWR VPWR sky130_fd_sc_hd__decap_3
XFILLER_123_657 VGND VGND VPWR VPWR sky130_fd_sc_hd__fill_1
XFILLER_122_178 VGND VGND VPWR VPWR sky130_fd_sc_hd__decap_3
XFILLER_89_582 VGND VGND VPWR VPWR sky130_fd_sc_hd__decap_3
XFILLER_76_221 VGND VGND VPWR VPWR sky130_fd_sc_hd__decap_3
XFILLER_76_232 VGND VGND VPWR VPWR sky130_fd_sc_hd__decap_3
XFILLER_77_744 VGND VGND VPWR VPWR sky130_fd_sc_hd__decap_3
XFILLER_77_766 VGND VGND VPWR VPWR sky130_fd_sc_hd__decap_3
XFILLER_37_608 VGND VGND VPWR VPWR sky130_fd_sc_hd__decap_3
XFILLER_76_265 VGND VGND VPWR VPWR sky130_fd_sc_hd__decap_3
XFILLER_91_202 VGND VGND VPWR VPWR sky130_fd_sc_hd__decap_3
XFILLER_29_181 VGND VGND VPWR VPWR sky130_fd_sc_hd__decap_3
XPHY_EDGE_ROW_101_Right_101 VGND VGND VPWR VPWR sky130_fd_sc_hd__decap_3
XFILLER_17_365 VGND VGND VPWR VPWR sky130_fd_sc_hd__decap_3
XFILLER_45_696 VGND VGND VPWR VPWR sky130_fd_sc_hd__decap_3
XFILLER_72_460 VGND VGND VPWR VPWR sky130_fd_sc_hd__fill_2
XTAP_TAPCELL_ROW_15_500 VGND VPWR sky130_fd_sc_hd__tapvpwrvgnd_1
XTAP_TAPCELL_ROW_82_1439 VGND VPWR sky130_fd_sc_hd__tapvpwrvgnd_1
XFILLER_44_195 VGND VGND VPWR VPWR sky130_fd_sc_hd__fill_1
XFILLER_32_379 VGND VGND VPWR VPWR sky130_fd_sc_hd__fill_2
XFILLER_71_92 VGND VGND VPWR VPWR sky130_fd_sc_hd__decap_3
XTAP_TAPCELL_ROW_43_897 VGND VPWR sky130_fd_sc_hd__tapvpwrvgnd_1
XFILLER_118_418 VGND VGND VPWR VPWR sky130_fd_sc_hd__fill_2
XFILLER_9_564 VGND VGND VPWR VPWR sky130_fd_sc_hd__decap_3
XFILLER_9_597 VGND VGND VPWR VPWR sky130_fd_sc_hd__decap_3
XFILLER_126_451 VGND VGND VPWR VPWR sky130_fd_sc_hd__decap_3
X_5360_ _5360_/A VGND VGND VPWR VPWR _7730_/D sky130_fd_sc_hd__buf_1
XFILLER_99_313 VGND VGND VPWR VPWR sky130_fd_sc_hd__fill_2
X_5291_ _5291_/A VGND VGND VPWR VPWR _5310_/S sky130_fd_sc_hd__buf_2
X_4311_ _4330_/A _4311_/B VGND VGND VPWR VPWR _4311_/X sky130_fd_sc_hd__or2_2
XFILLER_87_519 VGND VGND VPWR VPWR sky130_fd_sc_hd__fill_2
X_7030_ _4995_/X hold964/X _7046_/S VGND VGND VPWR VPWR _7031_/A sky130_fd_sc_hd__mux2_1
X_4242_ _4242_/A VGND VGND VPWR VPWR _4242_/X sky130_fd_sc_hd__buf_1
XFILLER_113_178 VGND VGND VPWR VPWR sky130_fd_sc_hd__fill_2
XFILLER_95_530 VGND VGND VPWR VPWR sky130_fd_sc_hd__decap_3
X_4173_ _4198_/A _4173_/B VGND VGND VPWR VPWR _4173_/X sky130_fd_sc_hd__or2_2
XFILLER_55_405 VGND VGND VPWR VPWR sky130_fd_sc_hd__decap_3
XFILLER_68_799 VGND VGND VPWR VPWR sky130_fd_sc_hd__decap_3
XFILLER_95_585 VGND VGND VPWR VPWR sky130_fd_sc_hd__decap_3
XFILLER_67_287 VGND VGND VPWR VPWR sky130_fd_sc_hd__fill_2
XFILLER_67_298 VGND VGND VPWR VPWR sky130_fd_sc_hd__decap_3
XTAP_TAPCELL_ROW_124_2023 VGND VPWR sky130_fd_sc_hd__tapvpwrvgnd_1
XTAP_TAPCELL_ROW_124_2034 VGND VPWR sky130_fd_sc_hd__tapvpwrvgnd_1
X_7932_ _8753_/CLK _7932_/D load_slew687/X VGND VGND VPWR VPWR _7932_/Q sky130_fd_sc_hd__dfrtp_2
XFILLER_36_663 VGND VGND VPWR VPWR sky130_fd_sc_hd__decap_3
XFILLER_51_611 VGND VGND VPWR VPWR sky130_fd_sc_hd__fill_1
XFILLER_70_419 VGND VGND VPWR VPWR sky130_fd_sc_hd__fill_1
XFILLER_91_780 VGND VGND VPWR VPWR sky130_fd_sc_hd__decap_3
X_7863_ _8683_/CLK _7863_/D load_slew565/X VGND VGND VPWR VPWR _7863_/Q sky130_fd_sc_hd__dfrtp_2
XFILLER_35_195 VGND VGND VPWR VPWR sky130_fd_sc_hd__fill_1
X_7794_ _8776_/CLK _7794_/D load_slew731/X VGND VGND VPWR VPWR _7794_/Q sky130_fd_sc_hd__dfrtp_2
X_6814_ _8450_/Q _4907_/A _6828_/S VGND VGND VPWR VPWR _6815_/A sky130_fd_sc_hd__mux2_2
XFILLER_11_508 VGND VGND VPWR VPWR sky130_fd_sc_hd__decap_3
XFILLER_50_165 VGND VGND VPWR VPWR sky130_fd_sc_hd__decap_3
X_3957_ _7735_/Q _7816_/Q _3957_/S VGND VGND VPWR VPWR _3958_/B sky130_fd_sc_hd__mux2_2
X_6745_ _6745_/A VGND VGND VPWR VPWR _8417_/D sky130_fd_sc_hd__buf_2
XFILLER_109_407 VGND VGND VPWR VPWR sky130_fd_sc_hd__fill_2
XFILLER_129_9 VGND VGND VPWR VPWR sky130_fd_sc_hd__decap_3
X_3888_ _3888_/A _3888_/B VGND VGND VPWR VPWR _3888_/X sky130_fd_sc_hd__or2_2
X_8415_ _8736_/CLK _8415_/D fanout487/X VGND VGND VPWR VPWR _8415_/Q sky130_fd_sc_hd__dfrtp_2
X_6676_ _6676_/A VGND VGND VPWR VPWR _8384_/D sky130_fd_sc_hd__buf_2
X_5627_ _7857_/Q _4841_/A _5633_/S VGND VGND VPWR VPWR _5628_/A sky130_fd_sc_hd__mux2_2
XFILLER_3_718 VGND VGND VPWR VPWR sky130_fd_sc_hd__decap_3
XTAP_TAPCELL_ROW_135_2185 VGND VPWR sky130_fd_sc_hd__tapvpwrvgnd_1
XTAP_TAPCELL_ROW_135_2196 VGND VPWR sky130_fd_sc_hd__tapvpwrvgnd_1
X_8346_ _8747_/CLK _8346_/D wire631/X VGND VGND VPWR VPWR _8346_/Q sky130_fd_sc_hd__dfrtp_2
X_5558_ _7824_/Q _4703_/A _5570_/S VGND VGND VPWR VPWR _5559_/A sky130_fd_sc_hd__mux2_2
XFILLER_132_421 VGND VGND VPWR VPWR sky130_fd_sc_hd__decap_3
XFILLER_3_729 VGND VGND VPWR VPWR sky130_fd_sc_hd__decap_3
X_8277_ _8763_/CLK _8277_/D fanout556/X VGND VGND VPWR VPWR _8277_/Q sky130_fd_sc_hd__dfrtp_2
X_4509_ _8766_/Q _7541_/Q _7622_/Q _7703_/Q _4524_/S0 _4524_/S1 VGND VGND VPWR VPWR
+ _4509_/X sky130_fd_sc_hd__mux4_2
XFILLER_105_668 VGND VGND VPWR VPWR sky130_fd_sc_hd__decap_3
XFILLER_105_679 VGND VGND VPWR VPWR sky130_fd_sc_hd__decap_3
XFILLER_132_454 VGND VGND VPWR VPWR sky130_fd_sc_hd__decap_3
XFILLER_78_508 VGND VGND VPWR VPWR sky130_fd_sc_hd__decap_3
XTAP_TAPCELL_ROW_53_1029 VGND VPWR sky130_fd_sc_hd__tapvpwrvgnd_1
X_7228_ _7267_/A VGND VGND VPWR VPWR _7228_/X sky130_fd_sc_hd__clkbuf_1
X_5489_ _7792_/Q _4907_/A _5503_/S VGND VGND VPWR VPWR _5490_/A sky130_fd_sc_hd__mux2_2
XFILLER_132_498 VGND VGND VPWR VPWR sky130_fd_sc_hd__decap_3
Xfanout510 fanout517/X VGND VGND VPWR VPWR fanout510/X sky130_fd_sc_hd__clkdlybuf4s25_1
Xfanout532 fanout543/X VGND VGND VPWR VPWR fanout532/X sky130_fd_sc_hd__clkdlybuf4s25_1
Xfanout543 fanout614/X VGND VGND VPWR VPWR fanout543/X sky130_fd_sc_hd__clkdlybuf4s25_1
Xfanout554 fanout561/X VGND VGND VPWR VPWR wire555/A sky130_fd_sc_hd__clkdlybuf4s25_1
X_7159_ _7159_/A VGND VGND VPWR VPWR _8612_/D sky130_fd_sc_hd__buf_2
XFILLER_100_340 VGND VGND VPWR VPWR sky130_fd_sc_hd__decap_3
XFILLER_58_265 VGND VGND VPWR VPWR sky130_fd_sc_hd__fill_2
XFILLER_59_788 VGND VGND VPWR VPWR sky130_fd_sc_hd__fill_2
XFILLER_59_799 VGND VGND VPWR VPWR sky130_fd_sc_hd__decap_3
XFILLER_86_552 VGND VGND VPWR VPWR sky130_fd_sc_hd__decap_3
XFILLER_86_585 VGND VGND VPWR VPWR sky130_fd_sc_hd__decap_3
XTAP_TAPCELL_ROW_109_1818 VGND VPWR sky130_fd_sc_hd__tapvpwrvgnd_1
Xfanout576 fanout577/X VGND VGND VPWR VPWR fanout576/X sky130_fd_sc_hd__clkdlybuf4s25_1
XFILLER_132_21 VGND VGND VPWR VPWR sky130_fd_sc_hd__decap_3
XFILLER_132_32 VGND VGND VPWR VPWR sky130_fd_sc_hd__decap_3
XFILLER_74_747 VGND VGND VPWR VPWR sky130_fd_sc_hd__decap_3
XFILLER_132_65 VGND VGND VPWR VPWR sky130_fd_sc_hd__decap_3
XFILLER_92_25 VGND VGND VPWR VPWR sky130_fd_sc_hd__decap_3
XTAP_TAPCELL_ROW_68_1250 VGND VPWR sky130_fd_sc_hd__tapvpwrvgnd_1
XFILLER_14_302 VGND VGND VPWR VPWR sky130_fd_sc_hd__decap_3
XFILLER_25_30 VGND VGND VPWR VPWR sky130_fd_sc_hd__decap_3
XFILLER_42_622 VGND VGND VPWR VPWR sky130_fd_sc_hd__decap_3
XFILLER_54_471 VGND VGND VPWR VPWR sky130_fd_sc_hd__decap_3
XFILLER_14_324 VGND VGND VPWR VPWR sky130_fd_sc_hd__decap_3
XFILLER_25_63 VGND VGND VPWR VPWR sky130_fd_sc_hd__decap_3
XFILLER_14_368 VGND VGND VPWR VPWR sky130_fd_sc_hd__decap_3
XFILLER_41_154 VGND VGND VPWR VPWR sky130_fd_sc_hd__decap_3
XFILLER_128_716 VGND VGND VPWR VPWR sky130_fd_sc_hd__decap_3
XTAP_TAPCELL_ROW_40_856 VGND VPWR sky130_fd_sc_hd__tapvpwrvgnd_1
XFILLER_127_237 VGND VGND VPWR VPWR sky130_fd_sc_hd__decap_3
XFILLER_128_749 VGND VGND VPWR VPWR sky130_fd_sc_hd__decap_3
XFILLER_41_51 VGND VGND VPWR VPWR sky130_fd_sc_hd__decap_3
XFILLER_41_84 VGND VGND VPWR VPWR sky130_fd_sc_hd__decap_3
XFILLER_6_556 VGND VGND VPWR VPWR sky130_fd_sc_hd__decap_3
XFILLER_108_473 VGND VGND VPWR VPWR sky130_fd_sc_hd__decap_3
XFILLER_135_281 VGND VGND VPWR VPWR sky130_fd_sc_hd__fill_2
XFILLER_6_589 VGND VGND VPWR VPWR sky130_fd_sc_hd__decap_3
XFILLER_2_740 VGND VGND VPWR VPWR sky130_fd_sc_hd__decap_3
XFILLER_44_9 VGND VGND VPWR VPWR sky130_fd_sc_hd__decap_3
XFILLER_111_638 VGND VGND VPWR VPWR sky130_fd_sc_hd__decap_3
XFILLER_123_476 VGND VGND VPWR VPWR sky130_fd_sc_hd__decap_3
XFILLER_2_784 VGND VGND VPWR VPWR sky130_fd_sc_hd__decap_3
XFILLER_96_305 VGND VGND VPWR VPWR sky130_fd_sc_hd__decap_3
XFILLER_96_327 VGND VGND VPWR VPWR sky130_fd_sc_hd__decap_3
XFILLER_2_12 VGND VGND VPWR VPWR sky130_fd_sc_hd__decap_3
XFILLER_2_56 VGND VGND VPWR VPWR sky130_fd_sc_hd__decap_3
XFILLER_37_405 VGND VGND VPWR VPWR sky130_fd_sc_hd__decap_3
XFILLER_37_449 VGND VGND VPWR VPWR sky130_fd_sc_hd__decap_3
XFILLER_49_276 VGND VGND VPWR VPWR sky130_fd_sc_hd__decap_3
XFILLER_65_725 VGND VGND VPWR VPWR sky130_fd_sc_hd__decap_3
XTAP_TAPCELL_ROW_48_967 VGND VPWR sky130_fd_sc_hd__tapvpwrvgnd_1
XFILLER_33_644 VGND VGND VPWR VPWR sky130_fd_sc_hd__decap_3
XFILLER_72_290 VGND VGND VPWR VPWR sky130_fd_sc_hd__decap_3
XTAP_TAPCELL_ROW_28_680 VGND VPWR sky130_fd_sc_hd__tapvpwrvgnd_1
XTAP_TAPCELL_ROW_28_691 VGND VPWR sky130_fd_sc_hd__tapvpwrvgnd_1
X_4860_ _4860_/A _4860_/B VGND VGND VPWR VPWR _4861_/A sky130_fd_sc_hd__and2_2
XFILLER_60_474 VGND VGND VPWR VPWR sky130_fd_sc_hd__fill_2
XFILLER_82_80 VGND VGND VPWR VPWR sky130_fd_sc_hd__decap_3
XFILLER_82_91 VGND VGND VPWR VPWR sky130_fd_sc_hd__decap_3
X_3811_ _3811_/A VGND VGND VPWR VPWR _3811_/X sky130_fd_sc_hd__clkbuf_2
XFILLER_33_699 VGND VGND VPWR VPWR sky130_fd_sc_hd__decap_3
X_6530_ _6656_/S VGND VGND VPWR VPWR _6549_/S sky130_fd_sc_hd__buf_6
X_4791_ _4791_/A VGND VGND VPWR VPWR _4791_/X sky130_fd_sc_hd__buf_1
XFILLER_119_716 VGND VGND VPWR VPWR sky130_fd_sc_hd__fill_2
XFILLER_119_727 VGND VGND VPWR VPWR sky130_fd_sc_hd__fill_1
XFILLER_119_738 VGND VGND VPWR VPWR sky130_fd_sc_hd__decap_3
XFILLER_20_349 VGND VGND VPWR VPWR sky130_fd_sc_hd__decap_3
X_3742_ _4314_/S _3742_/B_N VGND VGND VPWR VPWR _3751_/A sky130_fd_sc_hd__or2b_2
XFILLER_118_248 VGND VGND VPWR VPWR sky130_fd_sc_hd__decap_3
XTAP_TAPCELL_ROW_95_1619 VGND VPWR sky130_fd_sc_hd__tapvpwrvgnd_1
X_6461_ _4895_/X _8285_/Q _6461_/S VGND VGND VPWR VPWR _6462_/A sky130_fd_sc_hd__mux2_2
XFILLER_127_771 VGND VGND VPWR VPWR sky130_fd_sc_hd__decap_3
XFILLER_134_719 VGND VGND VPWR VPWR sky130_fd_sc_hd__decap_3
X_8200_ _8769_/CLK _8200_/D load_slew550/X VGND VGND VPWR VPWR _8200_/Q sky130_fd_sc_hd__dfrtp_2
X_6392_ _4757_/X _8252_/Q _6398_/S VGND VGND VPWR VPWR _6393_/A sky130_fd_sc_hd__mux2_2
X_5412_ _5412_/A VGND VGND VPWR VPWR _7755_/D sky130_fd_sc_hd__buf_1
XFILLER_114_421 VGND VGND VPWR VPWR sky130_fd_sc_hd__decap_3
XFILLER_99_110 VGND VGND VPWR VPWR sky130_fd_sc_hd__fill_2
Xoutput124 _4265_/X VGND VGND VPWR VPWR rdata[43] sky130_fd_sc_hd__clkdlybuf4s25_1
Xoutput113 _4156_/X VGND VGND VPWR VPWR rdata[33] sky130_fd_sc_hd__clkdlybuf4s25_1
Xoutput102 _4051_/X VGND VGND VPWR VPWR rdata[23] sky130_fd_sc_hd__clkdlybuf4s25_1
X_8131_ _8779_/CLK _8131_/D wire746/X VGND VGND VPWR VPWR _8131_/Q sky130_fd_sc_hd__dfrtp_2
X_5343_ _5343_/A VGND VGND VPWR VPWR _7722_/D sky130_fd_sc_hd__buf_1
Xoutput135 _4384_/X VGND VGND VPWR VPWR rdata[53] sky130_fd_sc_hd__clkdlybuf4s25_1
Xoutput146 _4501_/X VGND VGND VPWR VPWR rdata[63] sky130_fd_sc_hd__clkdlybuf4s25_1
Xoutput157 _4606_/X VGND VGND VPWR VPWR rdata[73] sky130_fd_sc_hd__clkdlybuf4s25_1
XFILLER_99_187 VGND VGND VPWR VPWR sky130_fd_sc_hd__fill_2
X_8062_ _8791_/CLK _8062_/D fanout665/X VGND VGND VPWR VPWR _8062_/Q sky130_fd_sc_hd__dfrtp_2
X_5274_ _5274_/A VGND VGND VPWR VPWR _7690_/D sky130_fd_sc_hd__buf_1
XFILLER_68_530 VGND VGND VPWR VPWR sky130_fd_sc_hd__fill_2
X_7013_ _4961_/X _8543_/Q _7025_/S VGND VGND VPWR VPWR _7014_/A sky130_fd_sc_hd__mux2_2
X_4225_ _7760_/Q _7841_/Q _7922_/Q _8003_/Q _4266_/S _4261_/A VGND VGND VPWR VPWR
+ _4225_/X sky130_fd_sc_hd__mux4_2
XFILLER_110_660 VGND VGND VPWR VPWR sky130_fd_sc_hd__decap_3
Xclkbuf_leaf_110_CLK clkload7/A VGND VGND VPWR VPWR _8791_/CLK sky130_fd_sc_hd__clkbuf_8
X_4156_ _4156_/A VGND VGND VPWR VPWR _4156_/X sky130_fd_sc_hd__buf_1
XFILLER_28_427 VGND VGND VPWR VPWR sky130_fd_sc_hd__fill_2
XFILLER_95_382 VGND VGND VPWR VPWR sky130_fd_sc_hd__decap_3
X_4087_ _7747_/Q _7828_/Q _7909_/Q _7990_/Q _4090_/S0 _4091_/S1 VGND VGND VPWR VPWR
+ _4087_/X sky130_fd_sc_hd__mux4_2
XFILLER_102_35 VGND VGND VPWR VPWR sky130_fd_sc_hd__decap_3
XFILLER_55_279 VGND VGND VPWR VPWR sky130_fd_sc_hd__fill_1
X_7915_ _8335_/CLK _7915_/D fanout540/X VGND VGND VPWR VPWR _7915_/Q sky130_fd_sc_hd__dfrtp_2
XTAP_TAPCELL_ROW_104_1748 VGND VPWR sky130_fd_sc_hd__tapvpwrvgnd_1
X_7846_ _8670_/CLK _7846_/D load_slew633/X VGND VGND VPWR VPWR _7846_/Q sky130_fd_sc_hd__dfrtp_2
XFILLER_23_165 VGND VGND VPWR VPWR sky130_fd_sc_hd__decap_3
XFILLER_24_677 VGND VGND VPWR VPWR sky130_fd_sc_hd__fill_2
Xclkbuf_5_5__f_CLK clkbuf_4_2_0_CLK/X VGND VGND VPWR VPWR clkload1/A sky130_fd_sc_hd__clkbuf_16
XTAP_TAPCELL_ROW_63_1180 VGND VPWR sky130_fd_sc_hd__tapvpwrvgnd_1
X_7777_ _8019_/CLK _7777_/D wire707/A VGND VGND VPWR VPWR _7777_/Q sky130_fd_sc_hd__dfrtp_2
X_4989_ _4989_/A VGND VGND VPWR VPWR _4989_/X sky130_fd_sc_hd__buf_1
Xwire207 _7192_/X VGND VGND VPWR VPWR wire207/X sky130_fd_sc_hd__clkbuf_4
Xwire218 _5030_/B VGND VGND VPWR VPWR _5026_/B sky130_fd_sc_hd__buf_2
X_6728_ _8409_/Q _4734_/A _6744_/S VGND VGND VPWR VPWR _6729_/A sky130_fd_sc_hd__mux2_2
XFILLER_127_6 VGND VGND VPWR VPWR sky130_fd_sc_hd__decap_3
X_6659_ _6659_/A VGND VGND VPWR VPWR _7269_/A sky130_fd_sc_hd__buf_2
XFILLER_118_760 VGND VGND VPWR VPWR sky130_fd_sc_hd__decap_3
XFILLER_11_21 VGND VGND VPWR VPWR sky130_fd_sc_hd__decap_3
XFILLER_11_54 VGND VGND VPWR VPWR sky130_fd_sc_hd__fill_2
XFILLER_127_21 VGND VGND VPWR VPWR sky130_fd_sc_hd__decap_3
X_8329_ _8740_/CLK _8329_/D fanout535/X VGND VGND VPWR VPWR _8329_/Q sky130_fd_sc_hd__dfrtp_2
XFILLER_11_87 VGND VGND VPWR VPWR sky130_fd_sc_hd__fill_1
XFILLER_127_54 VGND VGND VPWR VPWR sky130_fd_sc_hd__fill_2
XFILLER_133_741 VGND VGND VPWR VPWR sky130_fd_sc_hd__decap_3
XFILLER_87_14 VGND VGND VPWR VPWR sky130_fd_sc_hd__decap_3
XFILLER_120_402 VGND VGND VPWR VPWR sky130_fd_sc_hd__decap_3
XFILLER_127_87 VGND VGND VPWR VPWR sky130_fd_sc_hd__decap_3
XFILLER_132_251 VGND VGND VPWR VPWR sky130_fd_sc_hd__fill_1
XFILLER_132_262 VGND VGND VPWR VPWR sky130_fd_sc_hd__decap_3
XFILLER_133_774 VGND VGND VPWR VPWR sky130_fd_sc_hd__decap_3
XFILLER_133_785 VGND VGND VPWR VPWR sky130_fd_sc_hd__decap_3
XTAP_TAPCELL_ROW_115_1899 VGND VPWR sky130_fd_sc_hd__tapvpwrvgnd_1
XFILLER_105_498 VGND VGND VPWR VPWR sky130_fd_sc_hd__decap_3
XFILLER_120_424 VGND VGND VPWR VPWR sky130_fd_sc_hd__decap_3
XFILLER_132_295 VGND VGND VPWR VPWR sky130_fd_sc_hd__decap_3
XFILLER_78_338 VGND VGND VPWR VPWR sky130_fd_sc_hd__decap_3
Xfanout340 _4096_/A VGND VGND VPWR VPWR _4141_/A sky130_fd_sc_hd__clkdlybuf4s25_1
XTAP_TAPCELL_ROW_6_375 VGND VPWR sky130_fd_sc_hd__tapvpwrvgnd_1
Xclkbuf_leaf_101_CLK clkload8/A VGND VGND VPWR VPWR _8621_/CLK sky130_fd_sc_hd__clkbuf_8
Xfanout373 _3849_/S1 VGND VGND VPWR VPWR _3888_/A sky130_fd_sc_hd__clkdlybuf4s25_1
Xfanout384 _4412_/B2 VGND VGND VPWR VPWR _4450_/A sky130_fd_sc_hd__clkdlybuf4s25_1
XFILLER_74_533 VGND VGND VPWR VPWR sky130_fd_sc_hd__fill_1
XFILLER_19_449 VGND VGND VPWR VPWR sky130_fd_sc_hd__fill_2
XFILLER_15_611 VGND VGND VPWR VPWR sky130_fd_sc_hd__decap_3
XFILLER_55_780 VGND VGND VPWR VPWR sky130_fd_sc_hd__decap_3
XTAP_TAPCELL_ROW_45_926 VGND VPWR sky130_fd_sc_hd__tapvpwrvgnd_1
XFILLER_27_493 VGND VGND VPWR VPWR sky130_fd_sc_hd__decap_3
XFILLER_128_513 VGND VGND VPWR VPWR sky130_fd_sc_hd__decap_3
XFILLER_52_94 VGND VGND VPWR VPWR sky130_fd_sc_hd__fill_1
XFILLER_10_371 VGND VGND VPWR VPWR sky130_fd_sc_hd__decap_3
Xinput15 wdata[20] VGND VGND VPWR VPWR _5030_/A sky130_fd_sc_hd__clkdlybuf4s25_1
Xinput26 wdata[30] VGND VGND VPWR VPWR _4730_/A sky130_fd_sc_hd__clkdlybuf4s25_1
Xinput37 wdata[40] VGND VGND VPWR VPWR _4772_/A sky130_fd_sc_hd__clkdlybuf4s25_1
XFILLER_128_557 VGND VGND VPWR VPWR sky130_fd_sc_hd__decap_3
Xinput48 wdata[50] VGND VGND VPWR VPWR _4814_/A sky130_fd_sc_hd__clkdlybuf4s25_1
Xinput59 wdata[60] VGND VGND VPWR VPWR _4856_/A sky130_fd_sc_hd__clkdlybuf4s25_1
XFILLER_108_270 VGND VGND VPWR VPWR sky130_fd_sc_hd__decap_3
XFILLER_111_413 VGND VGND VPWR VPWR sky130_fd_sc_hd__decap_3
XFILLER_96_102 VGND VGND VPWR VPWR sky130_fd_sc_hd__decap_3
XTAP_TAPCELL_ROW_90_1549 VGND VPWR sky130_fd_sc_hd__tapvpwrvgnd_1
Xload_slew735 fanout734/X VGND VGND VPWR VPWR fanout732/A sky130_fd_sc_hd__clkbuf_4
Xload_slew724 fanout723/X VGND VGND VPWR VPWR load_slew724/X sky130_fd_sc_hd__buf_4
X_4010_ _8397_/Q _8478_/Q _8559_/Q _8640_/Q _4494_/S _4082_/A VGND VGND VPWR VPWR
+ _4010_/X sky130_fd_sc_hd__mux4_2
XFILLER_37_202 VGND VGND VPWR VPWR sky130_fd_sc_hd__fill_1
XFILLER_65_511 VGND VGND VPWR VPWR sky130_fd_sc_hd__decap_3
XFILLER_77_360 VGND VGND VPWR VPWR sky130_fd_sc_hd__decap_3
XFILLER_92_341 VGND VGND VPWR VPWR sky130_fd_sc_hd__decap_3
XFILLER_18_471 VGND VGND VPWR VPWR sky130_fd_sc_hd__decap_3
XFILLER_37_279 VGND VGND VPWR VPWR sky130_fd_sc_hd__fill_1
XFILLER_65_588 VGND VGND VPWR VPWR sky130_fd_sc_hd__decap_3
X_5961_ _5962_/A _5962_/B _5962_/C _5962_/D VGND VGND VPWR VPWR _5961_/X sky130_fd_sc_hd__o22a_2
XFILLER_33_430 VGND VGND VPWR VPWR sky130_fd_sc_hd__decap_3
XFILLER_93_90 VGND VGND VPWR VPWR sky130_fd_sc_hd__fill_1
X_8680_ _8680_/CLK _8680_/D wire693/X VGND VGND VPWR VPWR _8680_/Q sky130_fd_sc_hd__dfrtp_2
X_7700_ _8689_/CLK _7700_/D load_slew558/X VGND VGND VPWR VPWR _7700_/Q sky130_fd_sc_hd__dfrtp_2
X_4912_ _4912_/A _4936_/B VGND VGND VPWR VPWR _4913_/A sky130_fd_sc_hd__and2_2
XFILLER_33_452 VGND VGND VPWR VPWR sky130_fd_sc_hd__decap_3
XFILLER_61_750 VGND VGND VPWR VPWR sky130_fd_sc_hd__decap_3
XTAP_TAPCELL_ROW_23_609 VGND VPWR sky130_fd_sc_hd__tapvpwrvgnd_1
X_7631_ _8694_/CLK _7631_/D fanout728/X VGND VGND VPWR VPWR _7631_/Q sky130_fd_sc_hd__dfrtp_2
X_5892_ _5893_/A1 _5893_/A2 _4723_/X _5893_/B1 hold820/X VGND VGND VPWR VPWR _7991_/D
+ sky130_fd_sc_hd__a32o_2
XFILLER_20_113 VGND VGND VPWR VPWR sky130_fd_sc_hd__decap_3
XFILLER_21_647 VGND VGND VPWR VPWR sky130_fd_sc_hd__decap_3
X_4843_ _4843_/A VGND VGND VPWR VPWR _7533_/D sky130_fd_sc_hd__buf_1
XFILLER_21_658 VGND VGND VPWR VPWR sky130_fd_sc_hd__decap_3
X_7562_ _8382_/CLK _7562_/D load_slew661/X VGND VGND VPWR VPWR _7562_/Q sky130_fd_sc_hd__dfrtp_2
X_4774_ _4773_/X _7517_/Q _4778_/S VGND VGND VPWR VPWR _4775_/A sky130_fd_sc_hd__mux2_2
X_3725_ _3725_/A VGND VGND VPWR VPWR _8049_/D sky130_fd_sc_hd__buf_1
X_7493_ _5027_/X _8802_/Q _7495_/S VGND VGND VPWR VPWR _7494_/A sky130_fd_sc_hd__mux2_2
X_6513_ _6513_/A VGND VGND VPWR VPWR _8308_/D sky130_fd_sc_hd__buf_2
X_6444_ _6444_/A VGND VGND VPWR VPWR _8276_/D sky130_fd_sc_hd__buf_2
XFILLER_106_207 VGND VGND VPWR VPWR sky130_fd_sc_hd__fill_1
XTAP_TAPCELL_ROW_132_2144 VGND VPWR sky130_fd_sc_hd__tapvpwrvgnd_1
X_6375_ _4723_/X _6375_/A1 _6377_/S VGND VGND VPWR VPWR _6376_/A sky130_fd_sc_hd__mux2_1
XFILLER_115_785 VGND VGND VPWR VPWR sky130_fd_sc_hd__decap_3
X_8114_ _8798_/CLK _8114_/D wire600/X VGND VGND VPWR VPWR _8114_/Q sky130_fd_sc_hd__dfrtp_2
X_5326_ _5326_/A VGND VGND VPWR VPWR _7715_/D sky130_fd_sc_hd__buf_1
XFILLER_114_295 VGND VGND VPWR VPWR sky130_fd_sc_hd__fill_1
XFILLER_130_722 VGND VGND VPWR VPWR sky130_fd_sc_hd__decap_3
XFILLER_130_755 VGND VGND VPWR VPWR sky130_fd_sc_hd__fill_1
X_8045_ _8803_/CLK _8045_/D wire547/X VGND VGND VPWR VPWR _8045_/Q sky130_fd_sc_hd__dfrtp_2
X_5257_ _5257_/A VGND VGND VPWR VPWR _7682_/D sky130_fd_sc_hd__buf_1
XFILLER_130_766 VGND VGND VPWR VPWR sky130_fd_sc_hd__decap_3
XFILLER_75_308 VGND VGND VPWR VPWR sky130_fd_sc_hd__fill_1
XFILLER_87_157 VGND VGND VPWR VPWR sky130_fd_sc_hd__fill_2
X_4208_ _4151_/A _4206_/X _4207_/X VGND VGND VPWR VPWR _4208_/X sky130_fd_sc_hd__o21a_2
XFILLER_113_12 VGND VGND VPWR VPWR sky130_fd_sc_hd__fill_2
XFILLER_130_799 VGND VGND VPWR VPWR sky130_fd_sc_hd__decap_3
XTAP_TAPCELL_ROW_3_334 VGND VPWR sky130_fd_sc_hd__tapvpwrvgnd_1
X_5188_ _5188_/A VGND VGND VPWR VPWR _7649_/D sky130_fd_sc_hd__buf_1
XFILLER_113_23 VGND VGND VPWR VPWR sky130_fd_sc_hd__decap_3
XFILLER_95_190 VGND VGND VPWR VPWR sky130_fd_sc_hd__decap_3
X_4139_ _7752_/Q _7833_/Q _7914_/Q _7995_/Q _4140_/S _4227_/A VGND VGND VPWR VPWR
+ _4139_/X sky130_fd_sc_hd__mux4_2
XFILLER_113_89 VGND VGND VPWR VPWR sky130_fd_sc_hd__decap_3
XFILLER_16_408 VGND VGND VPWR VPWR sky130_fd_sc_hd__decap_3
XFILLER_44_739 VGND VGND VPWR VPWR sky130_fd_sc_hd__fill_2
XFILLER_56_599 VGND VGND VPWR VPWR sky130_fd_sc_hd__decap_3
XFILLER_83_396 VGND VGND VPWR VPWR sky130_fd_sc_hd__decap_3
XFILLER_11_113 VGND VGND VPWR VPWR sky130_fd_sc_hd__decap_3
XFILLER_12_625 VGND VGND VPWR VPWR sky130_fd_sc_hd__decap_3
XFILLER_24_474 VGND VGND VPWR VPWR sky130_fd_sc_hd__fill_2
X_7829_ _8649_/CLK _7829_/D fanout500/X VGND VGND VPWR VPWR _7829_/Q sky130_fd_sc_hd__dfrtp_2
XFILLER_11_135 VGND VGND VPWR VPWR sky130_fd_sc_hd__decap_3
XFILLER_12_658 VGND VGND VPWR VPWR sky130_fd_sc_hd__decap_3
XFILLER_51_293 VGND VGND VPWR VPWR sky130_fd_sc_hd__decap_3
XFILLER_8_607 VGND VGND VPWR VPWR sky130_fd_sc_hd__decap_3
XFILLER_22_20 VGND VGND VPWR VPWR sky130_fd_sc_hd__decap_3
XTAP_TAPCELL_ROW_50_995 VGND VPWR sky130_fd_sc_hd__tapvpwrvgnd_1
XFILLER_125_3 VGND VGND VPWR VPWR sky130_fd_sc_hd__decap_3
XFILLER_125_505 VGND VGND VPWR VPWR sky130_fd_sc_hd__decap_3
XFILLER_22_53 VGND VGND VPWR VPWR sky130_fd_sc_hd__decap_3
XFILLER_4_802 VGND VGND VPWR VPWR sky130_fd_sc_hd__fill_2
XTAP_TAPCELL_ROW_117_1928 VGND VPWR sky130_fd_sc_hd__tapvpwrvgnd_1
XFILLER_98_24 VGND VGND VPWR VPWR sky130_fd_sc_hd__decap_3
XFILLER_3_334 VGND VGND VPWR VPWR sky130_fd_sc_hd__fill_2
XTAP_TAPCELL_ROW_76_1360 VGND VPWR sky130_fd_sc_hd__tapvpwrvgnd_1
XFILLER_106_763 VGND VGND VPWR VPWR sky130_fd_sc_hd__decap_3
XFILLER_106_774 VGND VGND VPWR VPWR sky130_fd_sc_hd__fill_2
XFILLER_121_711 VGND VGND VPWR VPWR sky130_fd_sc_hd__decap_3
XFILLER_105_284 VGND VGND VPWR VPWR sky130_fd_sc_hd__decap_3
XFILLER_120_221 VGND VGND VPWR VPWR sky130_fd_sc_hd__decap_3
XFILLER_121_722 VGND VGND VPWR VPWR sky130_fd_sc_hd__decap_3
XFILLER_133_582 VGND VGND VPWR VPWR sky130_fd_sc_hd__decap_3
XFILLER_94_606 VGND VGND VPWR VPWR sky130_fd_sc_hd__decap_3
XFILLER_120_276 VGND VGND VPWR VPWR sky130_fd_sc_hd__decap_3
XFILLER_78_179 VGND VGND VPWR VPWR sky130_fd_sc_hd__decap_3
XFILLER_93_116 VGND VGND VPWR VPWR sky130_fd_sc_hd__decap_3
XFILLER_101_490 VGND VGND VPWR VPWR sky130_fd_sc_hd__fill_1
XFILLER_47_555 VGND VGND VPWR VPWR sky130_fd_sc_hd__decap_3
XFILLER_19_257 VGND VGND VPWR VPWR sky130_fd_sc_hd__fill_2
XFILLER_47_577 VGND VGND VPWR VPWR sky130_fd_sc_hd__decap_3
XFILLER_74_352 VGND VGND VPWR VPWR sky130_fd_sc_hd__fill_2
XFILLER_90_801 VGND VGND VPWR VPWR sky130_fd_sc_hd__decap_3
XFILLER_62_536 VGND VGND VPWR VPWR sky130_fd_sc_hd__decap_3
XFILLER_62_558 VGND VGND VPWR VPWR sky130_fd_sc_hd__decap_3
XFILLER_63_60 VGND VGND VPWR VPWR sky130_fd_sc_hd__fill_2
XFILLER_43_783 VGND VGND VPWR VPWR sky130_fd_sc_hd__fill_1
XFILLER_63_71 VGND VGND VPWR VPWR sky130_fd_sc_hd__decap_3
XFILLER_129_800 VGND VGND VPWR VPWR sky130_fd_sc_hd__decap_3
XFILLER_30_455 VGND VGND VPWR VPWR sky130_fd_sc_hd__fill_1
XFILLER_128_321 VGND VGND VPWR VPWR sky130_fd_sc_hd__decap_3
XFILLER_30_477 VGND VGND VPWR VPWR sky130_fd_sc_hd__fill_2
XFILLER_8_44 VGND VGND VPWR VPWR sky130_fd_sc_hd__decap_3
XFILLER_11_691 VGND VGND VPWR VPWR sky130_fd_sc_hd__decap_3
XFILLER_8_77 VGND VGND VPWR VPWR sky130_fd_sc_hd__decap_3
XFILLER_8_88 VGND VGND VPWR VPWR sky130_fd_sc_hd__decap_3
XFILLER_116_516 VGND VGND VPWR VPWR sky130_fd_sc_hd__fill_1
XFILLER_7_662 VGND VGND VPWR VPWR sky130_fd_sc_hd__decap_3
XFILLER_7_673 VGND VGND VPWR VPWR sky130_fd_sc_hd__decap_3
X_4490_ _4498_/A _4488_/X _4489_/X VGND VGND VPWR VPWR _4490_/X sky130_fd_sc_hd__o21a_2
XFILLER_6_194 VGND VGND VPWR VPWR sky130_fd_sc_hd__fill_2
XFILLER_124_560 VGND VGND VPWR VPWR sky130_fd_sc_hd__decap_3
XFILLER_131_508 VGND VGND VPWR VPWR sky130_fd_sc_hd__decap_3
X_6160_ _6160_/A VGND VGND VPWR VPWR _8142_/D sky130_fd_sc_hd__buf_6
XFILLER_69_102 VGND VGND VPWR VPWR sky130_fd_sc_hd__fill_2
XFILLER_97_422 VGND VGND VPWR VPWR sky130_fd_sc_hd__decap_3
Xload_slew521 fanout520/X VGND VGND VPWR VPWR load_slew521/X sky130_fd_sc_hd__buf_4
X_5111_ _5111_/A VGND VGND VPWR VPWR _7614_/D sky130_fd_sc_hd__buf_1
XFILLER_85_617 VGND VGND VPWR VPWR sky130_fd_sc_hd__fill_2
Xload_slew565 fanout564/X VGND VGND VPWR VPWR load_slew565/X sky130_fd_sc_hd__buf_4
X_6091_ _8111_/Q _4844_/A _6095_/S VGND VGND VPWR VPWR _6092_/A sky130_fd_sc_hd__mux2_2
XFILLER_84_127 VGND VGND VPWR VPWR sky130_fd_sc_hd__decap_3
Xload_slew598 fanout597/X VGND VGND VPWR VPWR fanout595/A sky130_fd_sc_hd__buf_4
Xload_slew587 fanout586/X VGND VGND VPWR VPWR load_slew587/X sky130_fd_sc_hd__buf_4
X_5042_ _5042_/A VGND VGND VPWR VPWR _7581_/D sky130_fd_sc_hd__buf_1
XFILLER_38_533 VGND VGND VPWR VPWR sky130_fd_sc_hd__decap_3
XFILLER_77_190 VGND VGND VPWR VPWR sky130_fd_sc_hd__decap_3
XFILLER_26_728 VGND VGND VPWR VPWR sky130_fd_sc_hd__fill_2
XFILLER_38_566 VGND VGND VPWR VPWR sky130_fd_sc_hd__decap_3
XFILLER_53_514 VGND VGND VPWR VPWR sky130_fd_sc_hd__decap_3
XFILLER_65_352 VGND VGND VPWR VPWR sky130_fd_sc_hd__decap_3
XFILLER_65_374 VGND VGND VPWR VPWR sky130_fd_sc_hd__fill_2
X_8801_ _8801_/CLK _8801_/D fanout609/A VGND VGND VPWR VPWR _8801_/Q sky130_fd_sc_hd__dfrtp_2
XFILLER_53_547 VGND VGND VPWR VPWR sky130_fd_sc_hd__decap_3
XFILLER_92_182 VGND VGND VPWR VPWR sky130_fd_sc_hd__decap_3
X_6993_ _6993_/A VGND VGND VPWR VPWR _8534_/D sky130_fd_sc_hd__buf_6
X_8732_ _8732_/CLK _8732_/D fanout485/X VGND VGND VPWR VPWR _8732_/Q sky130_fd_sc_hd__dfrtp_2
X_5944_ _5944_/A1 _5944_/A2 _4891_/X _5944_/B1 hold880/X VGND VGND VPWR VPWR _8031_/D
+ sky130_fd_sc_hd__a32o_2
XFILLER_21_411 VGND VGND VPWR VPWR sky130_fd_sc_hd__decap_3
XTAP_TAPCELL_ROW_101_1707 VGND VPWR sky130_fd_sc_hd__tapvpwrvgnd_1
X_8663_ _8670_/CLK _8663_/D load_slew633/X VGND VGND VPWR VPWR _8663_/Q sky130_fd_sc_hd__dfrtp_2
X_5875_ _5880_/A1 _5869_/X _5007_/X _5870_/X hold877/X VGND VGND VPWR VPWR _7977_/D
+ sky130_fd_sc_hd__a32o_2
XFILLER_21_455 VGND VGND VPWR VPWR sky130_fd_sc_hd__decap_3
XFILLER_61_591 VGND VGND VPWR VPWR sky130_fd_sc_hd__fill_1
X_8594_ _8676_/CLK _8594_/D load_slew699/X VGND VGND VPWR VPWR _8594_/Q sky130_fd_sc_hd__dfrtp_2
X_7614_ _8678_/CLK _7614_/D load_slew699/X VGND VGND VPWR VPWR _7614_/Q sky130_fd_sc_hd__dfrtp_2
X_4826_ _4824_/X _7529_/Q _4862_/S VGND VGND VPWR VPWR _4827_/A sky130_fd_sc_hd__mux2_2
X_7545_ _8770_/CLK _7545_/D fanout549/X VGND VGND VPWR VPWR _7545_/Q sky130_fd_sc_hd__dfrtp_2
XFILLER_119_332 VGND VGND VPWR VPWR sky130_fd_sc_hd__decap_3
XFILLER_135_803 VGND VGND VPWR VPWR sky130_fd_sc_hd__fill_1
X_4757_ _4757_/A VGND VGND VPWR VPWR _4757_/X sky130_fd_sc_hd__buf_1
X_3708_ _5962_/A _5962_/B VGND VGND VPWR VPWR _8047_/D sky130_fd_sc_hd__nor2_2
X_7476_ _7497_/S VGND VGND VPWR VPWR _7495_/S sky130_fd_sc_hd__buf_2
X_4688_ _6658_/C VGND VGND VPWR VPWR _5970_/B sky130_fd_sc_hd__clkbuf_1
XFILLER_134_324 VGND VGND VPWR VPWR sky130_fd_sc_hd__decap_3
XFILLER_134_335 VGND VGND VPWR VPWR sky130_fd_sc_hd__decap_3
X_6427_ _6427_/A VGND VGND VPWR VPWR _8268_/D sky130_fd_sc_hd__buf_2
XFILLER_108_67 VGND VGND VPWR VPWR sky130_fd_sc_hd__decap_3
XFILLER_134_368 VGND VGND VPWR VPWR sky130_fd_sc_hd__decap_3
XTAP_TAPCELL_ROW_8_404 VGND VPWR sky130_fd_sc_hd__tapvpwrvgnd_1
X_6358_ _6484_/S VGND VGND VPWR VPWR _6377_/S sky130_fd_sc_hd__buf_4
XFILLER_0_337 VGND VGND VPWR VPWR sky130_fd_sc_hd__fill_1
XFILLER_115_582 VGND VGND VPWR VPWR sky130_fd_sc_hd__decap_3
XFILLER_68_38 VGND VGND VPWR VPWR sky130_fd_sc_hd__fill_2
XFILLER_88_411 VGND VGND VPWR VPWR sky130_fd_sc_hd__decap_3
XTAP_TAPCELL_ROW_112_1858 VGND VPWR sky130_fd_sc_hd__tapvpwrvgnd_1
X_5309_ _5309_/A VGND VGND VPWR VPWR _7707_/D sky130_fd_sc_hd__buf_1
XFILLER_130_563 VGND VGND VPWR VPWR sky130_fd_sc_hd__decap_3
X_6289_ _4895_/X _8204_/Q _6289_/S VGND VGND VPWR VPWR _6290_/A sky130_fd_sc_hd__mux2_4
XFILLER_124_44 VGND VGND VPWR VPWR sky130_fd_sc_hd__decap_3
XFILLER_75_105 VGND VGND VPWR VPWR sky130_fd_sc_hd__decap_3
XFILLER_75_116 VGND VGND VPWR VPWR sky130_fd_sc_hd__decap_3
XFILLER_88_499 VGND VGND VPWR VPWR sky130_fd_sc_hd__decap_3
XTAP_TAPCELL_ROW_71_1290 VGND VPWR sky130_fd_sc_hd__tapvpwrvgnd_1
X_8028_ _8689_/CLK _8028_/D wire552/X VGND VGND VPWR VPWR _8028_/Q sky130_fd_sc_hd__dfrtp_2
XFILLER_124_88 VGND VGND VPWR VPWR sky130_fd_sc_hd__decap_3
XFILLER_16_205 VGND VGND VPWR VPWR sky130_fd_sc_hd__decap_3
XFILLER_29_588 VGND VGND VPWR VPWR sky130_fd_sc_hd__decap_3
XFILLER_56_374 VGND VGND VPWR VPWR sky130_fd_sc_hd__fill_1
XFILLER_16_238 VGND VGND VPWR VPWR sky130_fd_sc_hd__decap_3
XFILLER_17_42 VGND VGND VPWR VPWR sky130_fd_sc_hd__decap_3
XFILLER_29_599 VGND VGND VPWR VPWR sky130_fd_sc_hd__decap_3
XFILLER_44_525 VGND VGND VPWR VPWR sky130_fd_sc_hd__decap_3
XFILLER_44_536 VGND VGND VPWR VPWR sky130_fd_sc_hd__decap_3
XFILLER_17_75 VGND VGND VPWR VPWR sky130_fd_sc_hd__fill_2
XFILLER_25_772 VGND VGND VPWR VPWR sky130_fd_sc_hd__decap_3
XFILLER_71_399 VGND VGND VPWR VPWR sky130_fd_sc_hd__decap_3
XFILLER_12_433 VGND VGND VPWR VPWR sky130_fd_sc_hd__decap_3
XFILLER_12_466 VGND VGND VPWR VPWR sky130_fd_sc_hd__decap_3
XFILLER_12_488 VGND VGND VPWR VPWR sky130_fd_sc_hd__fill_1
XFILLER_33_63 VGND VGND VPWR VPWR sky130_fd_sc_hd__decap_3
XFILLER_40_797 VGND VGND VPWR VPWR sky130_fd_sc_hd__decap_3
XFILLER_8_437 VGND VGND VPWR VPWR sky130_fd_sc_hd__decap_3
XFILLER_12_499 VGND VGND VPWR VPWR sky130_fd_sc_hd__decap_3
XFILLER_4_610 VGND VGND VPWR VPWR sky130_fd_sc_hd__decap_3
XFILLER_4_643 VGND VGND VPWR VPWR sky130_fd_sc_hd__fill_1
XFILLER_106_560 VGND VGND VPWR VPWR sky130_fd_sc_hd__decap_3
XFILLER_125_379 VGND VGND VPWR VPWR sky130_fd_sc_hd__fill_1
XFILLER_3_131 VGND VGND VPWR VPWR sky130_fd_sc_hd__fill_1
XFILLER_3_153 VGND VGND VPWR VPWR sky130_fd_sc_hd__fill_2
XFILLER_4_654 VGND VGND VPWR VPWR sky130_fd_sc_hd__decap_3
XFILLER_4_687 VGND VGND VPWR VPWR sky130_fd_sc_hd__decap_3
XFILLER_79_411 VGND VGND VPWR VPWR sky130_fd_sc_hd__fill_2
XFILLER_67_606 VGND VGND VPWR VPWR sky130_fd_sc_hd__decap_3
XFILLER_58_71 VGND VGND VPWR VPWR sky130_fd_sc_hd__decap_3
XFILLER_67_639 VGND VGND VPWR VPWR sky130_fd_sc_hd__decap_3
XFILLER_79_499 VGND VGND VPWR VPWR sky130_fd_sc_hd__decap_3
XFILLER_94_403 VGND VGND VPWR VPWR sky130_fd_sc_hd__decap_3
XTAP_TAPCELL_ROW_89_1540 VGND VPWR sky130_fd_sc_hd__tapvpwrvgnd_1
XFILLER_47_352 VGND VGND VPWR VPWR sky130_fd_sc_hd__fill_2
XFILLER_47_374 VGND VGND VPWR VPWR sky130_fd_sc_hd__decap_3
XFILLER_47_385 VGND VGND VPWR VPWR sky130_fd_sc_hd__decap_3
XFILLER_47_396 VGND VGND VPWR VPWR sky130_fd_sc_hd__fill_2
XFILLER_75_694 VGND VGND VPWR VPWR sky130_fd_sc_hd__decap_3
XFILLER_16_750 VGND VGND VPWR VPWR sky130_fd_sc_hd__decap_3
X_3990_ _3828_/X _3989_/X _3877_/X VGND VGND VPWR VPWR _3990_/X sky130_fd_sc_hd__o21a_2
XFILLER_50_517 VGND VGND VPWR VPWR sky130_fd_sc_hd__fill_1
XFILLER_50_539 VGND VGND VPWR VPWR sky130_fd_sc_hd__fill_1
XTAP_TAPCELL_ROW_33_748 VGND VPWR sky130_fd_sc_hd__tapvpwrvgnd_1
XTAP_TAPCELL_ROW_33_759 VGND VPWR sky130_fd_sc_hd__tapvpwrvgnd_1
X_5660_ _5660_/A VGND VGND VPWR VPWR _7872_/D sky130_fd_sc_hd__buf_1
XFILLER_90_91 VGND VGND VPWR VPWR sky130_fd_sc_hd__decap_3
X_4611_ _8695_/Q _3774_/X _4645_/B1 _8614_/Q wire326/X VGND VGND VPWR VPWR _4611_/X
+ sky130_fd_sc_hd__o221a_2
XFILLER_129_641 VGND VGND VPWR VPWR sky130_fd_sc_hd__decap_3
XFILLER_30_296 VGND VGND VPWR VPWR sky130_fd_sc_hd__decap_3
XTAP_TAPCELL_ROW_13_472 VGND VPWR sky130_fd_sc_hd__tapvpwrvgnd_1
X_5591_ _7840_/Q _4769_/A _5591_/S VGND VGND VPWR VPWR _5592_/A sky130_fd_sc_hd__mux2_2
XFILLER_128_162 VGND VGND VPWR VPWR sky130_fd_sc_hd__decap_3
XFILLER_129_685 VGND VGND VPWR VPWR sky130_fd_sc_hd__decap_3
Xclkbuf_leaf_90_CLK clkbuf_leaf_91_CLK/A VGND VGND VPWR VPWR _8753_/CLK sky130_fd_sc_hd__clkbuf_8
X_7330_ _8724_/Q _4690_/A _7344_/S VGND VGND VPWR VPWR _7331_/A sky130_fd_sc_hd__mux2_2
X_4542_ _8122_/Q _8203_/Q _8284_/Q _8365_/Q _3716_/A _3705_/C VGND VGND VPWR VPWR
+ _4543_/B sky130_fd_sc_hd__mux4_2
XFILLER_116_324 VGND VGND VPWR VPWR sky130_fd_sc_hd__fill_1
XFILLER_128_195 VGND VGND VPWR VPWR sky130_fd_sc_hd__fill_1
X_7261_ _7254_/X _4871_/X _7256_/X _7257_/X hold866/X VGND VGND VPWR VPWR _8684_/D
+ sky130_fd_sc_hd__a32o_2
X_4473_ _8682_/Q _3768_/X _4472_/X VGND VGND VPWR VPWR _4473_/X sky130_fd_sc_hd__o21a_2
XFILLER_116_368 VGND VGND VPWR VPWR sky130_fd_sc_hd__decap_3
XFILLER_116_379 VGND VGND VPWR VPWR sky130_fd_sc_hd__decap_3
XFILLER_131_305 VGND VGND VPWR VPWR sky130_fd_sc_hd__decap_3
XFILLER_89_219 VGND VGND VPWR VPWR sky130_fd_sc_hd__decap_3
X_6212_ _4740_/X _8167_/Q _6226_/S VGND VGND VPWR VPWR _6213_/A sky130_fd_sc_hd__mux2_4
XFILLER_131_349 VGND VGND VPWR VPWR sky130_fd_sc_hd__decap_3
XPHY_EDGE_ROW_115_Right_115 VGND VGND VPWR VPWR sky130_fd_sc_hd__decap_3
Xmax_cap189 _5883_/X VGND VGND VPWR VPWR _5893_/B1 sky130_fd_sc_hd__buf_2
Xmax_cap178 _7176_/X VGND VGND VPWR VPWR _7187_/A3 sky130_fd_sc_hd__buf_2
X_7192_ _7270_/A VGND VGND VPWR VPWR _7192_/X sky130_fd_sc_hd__clkbuf_1
XFILLER_112_530 VGND VGND VPWR VPWR sky130_fd_sc_hd__fill_2
X_6143_ _6143_/A VGND VGND VPWR VPWR _6312_/S sky130_fd_sc_hd__buf_6
XFILLER_112_596 VGND VGND VPWR VPWR sky130_fd_sc_hd__decap_3
Xload_slew362 _3943_/S1 VGND VGND VPWR VPWR _3993_/A sky130_fd_sc_hd__clkbuf_4
Xload_slew351 _4529_/A VGND VGND VPWR VPWR _4531_/S1 sky130_fd_sc_hd__buf_4
X_6074_ _8103_/Q _4810_/A _6074_/S VGND VGND VPWR VPWR _6075_/A sky130_fd_sc_hd__mux2_2
XFILLER_100_747 VGND VGND VPWR VPWR sky130_fd_sc_hd__decap_3
XFILLER_100_769 VGND VGND VPWR VPWR sky130_fd_sc_hd__fill_2
XFILLER_85_447 VGND VGND VPWR VPWR sky130_fd_sc_hd__fill_1
Xload_slew395 _4124_/S VGND VGND VPWR VPWR _4166_/S0 sky130_fd_sc_hd__buf_6
X_5025_ _5025_/A VGND VGND VPWR VPWR _7576_/D sky130_fd_sc_hd__buf_1
XFILLER_26_503 VGND VGND VPWR VPWR sky130_fd_sc_hd__decap_3
XFILLER_38_363 VGND VGND VPWR VPWR sky130_fd_sc_hd__fill_1
XFILLER_66_672 VGND VGND VPWR VPWR sky130_fd_sc_hd__decap_3
XTAP_TAPCELL_ROW_127_2065 VGND VPWR sky130_fd_sc_hd__tapvpwrvgnd_1
XTAP_TAPCELL_ROW_127_2076 VGND VPWR sky130_fd_sc_hd__tapvpwrvgnd_1
Xclkbuf_5_30__f_CLK clkbuf_4_15_0_CLK/X VGND VGND VPWR VPWR clkbuf_leaf_75_CLK/A sky130_fd_sc_hd__clkbuf_16
XFILLER_26_536 VGND VGND VPWR VPWR sky130_fd_sc_hd__fill_2
XFILLER_53_311 VGND VGND VPWR VPWR sky130_fd_sc_hd__decap_3
XFILLER_53_322 VGND VGND VPWR VPWR sky130_fd_sc_hd__decap_3
XFILLER_54_29 VGND VGND VPWR VPWR sky130_fd_sc_hd__fill_1
XFILLER_81_620 VGND VGND VPWR VPWR sky130_fd_sc_hd__decap_3
XFILLER_26_558 VGND VGND VPWR VPWR sky130_fd_sc_hd__fill_1
XFILLER_65_193 VGND VGND VPWR VPWR sky130_fd_sc_hd__decap_3
XFILLER_80_141 VGND VGND VPWR VPWR sky130_fd_sc_hd__decap_3
XFILLER_81_653 VGND VGND VPWR VPWR sky130_fd_sc_hd__decap_3
X_6976_ _6976_/A VGND VGND VPWR VPWR _8526_/D sky130_fd_sc_hd__buf_6
XFILLER_110_24 VGND VGND VPWR VPWR sky130_fd_sc_hd__decap_3
X_8715_ _8761_/CLK _8715_/D wire707/X VGND VGND VPWR VPWR _8715_/Q sky130_fd_sc_hd__dfrtp_2
X_5927_ _5931_/A1 _5932_/A2 _4833_/X _5932_/B1 hold856/X VGND VGND VPWR VPWR _8017_/D
+ sky130_fd_sc_hd__a32o_2
XFILLER_110_68 VGND VGND VPWR VPWR sky130_fd_sc_hd__fill_2
XFILLER_110_79 VGND VGND VPWR VPWR sky130_fd_sc_hd__decap_3
X_8646_ _8646_/CLK _8646_/D fanout534/X VGND VGND VPWR VPWR _8646_/Q sky130_fd_sc_hd__dfrtp_2
X_5858_ _5867_/A1 _5853_/X _4945_/X _5865_/B1 hold849/X VGND VGND VPWR VPWR _7963_/D
+ sky130_fd_sc_hd__a32o_2
XFILLER_21_274 VGND VGND VPWR VPWR sky130_fd_sc_hd__decap_3
XPHY_EDGE_ROW_17_Right_17 VGND VGND VPWR VPWR sky130_fd_sc_hd__decap_3
X_8577_ _8657_/CLK _8577_/D fanout516/X VGND VGND VPWR VPWR _8577_/Q sky130_fd_sc_hd__dfrtp_2
X_5789_ _7933_/Q _4819_/A _5805_/S VGND VGND VPWR VPWR _5790_/A sky130_fd_sc_hd__mux2_2
X_4809_ _4809_/A VGND VGND VPWR VPWR _7525_/D sky130_fd_sc_hd__buf_1
XFILLER_107_302 VGND VGND VPWR VPWR sky130_fd_sc_hd__decap_3
XFILLER_119_151 VGND VGND VPWR VPWR sky130_fd_sc_hd__decap_3
XFILLER_119_162 VGND VGND VPWR VPWR sky130_fd_sc_hd__decap_3
XFILLER_119_33 VGND VGND VPWR VPWR sky130_fd_sc_hd__decap_3
Xclkbuf_leaf_81_CLK clkbuf_leaf_84_CLK/A VGND VGND VPWR VPWR _8694_/CLK sky130_fd_sc_hd__clkbuf_8
X_7528_ _8782_/CLK _7528_/D load_slew649/X VGND VGND VPWR VPWR _7528_/Q sky130_fd_sc_hd__dfrtp_2
XFILLER_107_346 VGND VGND VPWR VPWR sky130_fd_sc_hd__decap_3
XFILLER_119_195 VGND VGND VPWR VPWR sky130_fd_sc_hd__decap_3
XFILLER_119_77 VGND VGND VPWR VPWR sky130_fd_sc_hd__decap_3
XFILLER_134_121 VGND VGND VPWR VPWR sky130_fd_sc_hd__decap_3
X_7459_ _7459_/A VGND VGND VPWR VPWR _8785_/D sky130_fd_sc_hd__buf_1
XFILLER_107_368 VGND VGND VPWR VPWR sky130_fd_sc_hd__decap_3
XFILLER_134_165 VGND VGND VPWR VPWR sky130_fd_sc_hd__decap_3
XFILLER_135_666 VGND VGND VPWR VPWR sky130_fd_sc_hd__decap_3
XFILLER_122_327 VGND VGND VPWR VPWR sky130_fd_sc_hd__decap_3
XFILLER_122_338 VGND VGND VPWR VPWR sky130_fd_sc_hd__decap_3
XFILLER_135_21 VGND VGND VPWR VPWR sky130_fd_sc_hd__decap_3
XFILLER_135_32 VGND VGND VPWR VPWR sky130_fd_sc_hd__decap_3
XFILLER_135_699 VGND VGND VPWR VPWR sky130_fd_sc_hd__fill_1
XFILLER_1_613 VGND VGND VPWR VPWR sky130_fd_sc_hd__decap_3
XFILLER_1_635 VGND VGND VPWR VPWR sky130_fd_sc_hd__decap_3
Xhold960 _7570_/Q VGND VGND VPWR VPWR hold960/X sky130_fd_sc_hd__dlygate4sd3_1
Xhold971 _8569_/Q VGND VGND VPWR VPWR hold971/X sky130_fd_sc_hd__dlygate4sd3_1
Xhold982 _7591_/Q VGND VGND VPWR VPWR hold982/X sky130_fd_sc_hd__dlygate4sd3_1
XFILLER_1_668 VGND VGND VPWR VPWR sky130_fd_sc_hd__decap_3
XFILLER_89_753 VGND VGND VPWR VPWR sky130_fd_sc_hd__fill_1
XFILLER_89_775 VGND VGND VPWR VPWR sky130_fd_sc_hd__decap_3
Xhold993 _7618_/Q VGND VGND VPWR VPWR hold993/X sky130_fd_sc_hd__dlygate4sd3_1
XFILLER_1_679 VGND VGND VPWR VPWR sky130_fd_sc_hd__decap_3
XPHY_EDGE_ROW_26_Right_26 VGND VGND VPWR VPWR sky130_fd_sc_hd__decap_3
XFILLER_28_41 VGND VGND VPWR VPWR sky130_fd_sc_hd__decap_3
XFILLER_48_127 VGND VGND VPWR VPWR sky130_fd_sc_hd__decap_3
XFILLER_95_69 VGND VGND VPWR VPWR sky130_fd_sc_hd__decap_3
XFILLER_17_503 VGND VGND VPWR VPWR sky130_fd_sc_hd__fill_1
XFILLER_91_428 VGND VGND VPWR VPWR sky130_fd_sc_hd__decap_3
XFILLER_28_85 VGND VGND VPWR VPWR sky130_fd_sc_hd__decap_3
XFILLER_44_300 VGND VGND VPWR VPWR sky130_fd_sc_hd__decap_3
XFILLER_56_193 VGND VGND VPWR VPWR sky130_fd_sc_hd__decap_3
XTAP_TAPCELL_ROW_84_1470 VGND VPWR sky130_fd_sc_hd__tapvpwrvgnd_1
XFILLER_12_230 VGND VGND VPWR VPWR sky130_fd_sc_hd__fill_1
XFILLER_13_753 VGND VGND VPWR VPWR sky130_fd_sc_hd__decap_3
XFILLER_9_724 VGND VGND VPWR VPWR sky130_fd_sc_hd__decap_3
XFILLER_9_735 VGND VGND VPWR VPWR sky130_fd_sc_hd__decap_3
XPHY_EDGE_ROW_35_Right_35 VGND VGND VPWR VPWR sky130_fd_sc_hd__decap_3
XTAP_TAPCELL_ROW_30_707 VGND VPWR sky130_fd_sc_hd__tapvpwrvgnd_1
XTAP_TAPCELL_ROW_30_718 VGND VPWR sky130_fd_sc_hd__tapvpwrvgnd_1
XFILLER_12_296 VGND VGND VPWR VPWR sky130_fd_sc_hd__decap_3
XFILLER_40_583 VGND VGND VPWR VPWR sky130_fd_sc_hd__decap_3
XFILLER_40_594 VGND VGND VPWR VPWR sky130_fd_sc_hd__fill_1
XFILLER_9_768 VGND VGND VPWR VPWR sky130_fd_sc_hd__decap_3
XTAP_TAPCELL_ROW_10_431 VGND VPWR sky130_fd_sc_hd__tapvpwrvgnd_1
Xclkbuf_leaf_72_CLK clkload11/A VGND VGND VPWR VPWR _8700_/CLK sky130_fd_sc_hd__clkbuf_8
XFILLER_125_110 VGND VGND VPWR VPWR sky130_fd_sc_hd__fill_2
XFILLER_5_12 VGND VGND VPWR VPWR sky130_fd_sc_hd__decap_3
XFILLER_60_94 VGND VGND VPWR VPWR sky130_fd_sc_hd__decap_3
XFILLER_126_677 VGND VGND VPWR VPWR sky130_fd_sc_hd__decap_3
XFILLER_5_45 VGND VGND VPWR VPWR sky130_fd_sc_hd__decap_3
XFILLER_5_78 VGND VGND VPWR VPWR sky130_fd_sc_hd__decap_3
XPHY_EDGE_ROW_44_Right_44 VGND VGND VPWR VPWR sky130_fd_sc_hd__decap_3
XFILLER_79_252 VGND VGND VPWR VPWR sky130_fd_sc_hd__fill_2
XFILLER_94_200 VGND VGND VPWR VPWR sky130_fd_sc_hd__decap_3
XFILLER_95_723 VGND VGND VPWR VPWR sky130_fd_sc_hd__decap_3
XFILLER_121_393 VGND VGND VPWR VPWR sky130_fd_sc_hd__decap_3
XFILLER_82_406 VGND VGND VPWR VPWR sky130_fd_sc_hd__decap_3
XTAP_TAPCELL_ROW_38_818 VGND VPWR sky130_fd_sc_hd__tapvpwrvgnd_1
XTAP_TAPCELL_ROW_38_829 VGND VPWR sky130_fd_sc_hd__tapvpwrvgnd_1
XFILLER_48_694 VGND VGND VPWR VPWR sky130_fd_sc_hd__decap_3
XFILLER_35_344 VGND VGND VPWR VPWR sky130_fd_sc_hd__fill_2
XFILLER_62_141 VGND VGND VPWR VPWR sky130_fd_sc_hd__decap_3
XTAP_TAPCELL_ROW_18_542 VGND VPWR sky130_fd_sc_hd__tapvpwrvgnd_1
X_6830_ _8458_/Q _4940_/A _6830_/S VGND VGND VPWR VPWR _6831_/A sky130_fd_sc_hd__mux2_2
XFILLER_23_517 VGND VGND VPWR VPWR sky130_fd_sc_hd__decap_3
XFILLER_62_174 VGND VGND VPWR VPWR sky130_fd_sc_hd__decap_3
XFILLER_90_472 VGND VGND VPWR VPWR sky130_fd_sc_hd__decap_3
X_6761_ _8425_/Q _4802_/A _6765_/S VGND VGND VPWR VPWR _6762_/A sky130_fd_sc_hd__mux2_2
XFILLER_16_580 VGND VGND VPWR VPWR sky130_fd_sc_hd__decap_3
XPHY_EDGE_ROW_53_Right_53 VGND VGND VPWR VPWR sky130_fd_sc_hd__decap_3
X_3973_ _7736_/Q _7817_/Q _3973_/S VGND VGND VPWR VPWR _3973_/X sky130_fd_sc_hd__mux2_2
X_8500_ _8583_/CLK _8500_/D load_slew616/X VGND VGND VPWR VPWR _8500_/Q sky130_fd_sc_hd__dfrtp_2
X_5712_ _5712_/A VGND VGND VPWR VPWR _7896_/D sky130_fd_sc_hd__buf_1
XFILLER_31_550 VGND VGND VPWR VPWR sky130_fd_sc_hd__fill_2
XFILLER_31_561 VGND VGND VPWR VPWR sky130_fd_sc_hd__decap_3
X_6692_ _8392_/Q input8/X _6702_/S VGND VGND VPWR VPWR _6693_/A sky130_fd_sc_hd__mux2_2
X_8431_ _8593_/CLK _8431_/D load_slew710/X VGND VGND VPWR VPWR _8431_/Q sky130_fd_sc_hd__dfrtp_2
X_5643_ _5643_/A VGND VGND VPWR VPWR _7864_/D sky130_fd_sc_hd__buf_1
Xclkbuf_leaf_63_CLK clkbuf_leaf_63_CLK/A VGND VGND VPWR VPWR _8761_/CLK sky130_fd_sc_hd__clkbuf_8
X_8362_ _8770_/CLK _8362_/D fanout553/X VGND VGND VPWR VPWR _8362_/Q sky130_fd_sc_hd__dfrtp_2
X_5574_ _5574_/A VGND VGND VPWR VPWR _7831_/D sky130_fd_sc_hd__buf_1
XFILLER_129_482 VGND VGND VPWR VPWR sky130_fd_sc_hd__decap_3
XFILLER_8_790 VGND VGND VPWR VPWR sky130_fd_sc_hd__decap_3
X_7313_ _8716_/Q input8/X _7323_/S VGND VGND VPWR VPWR _7314_/A sky130_fd_sc_hd__mux2_2
X_4525_ _4523_/X _4524_/X _4525_/S VGND VGND VPWR VPWR _4525_/X sky130_fd_sc_hd__mux2_2
X_8293_ _8530_/CLK _8293_/D fanout747/X VGND VGND VPWR VPWR _8293_/Q sky130_fd_sc_hd__dfrtp_2
XFILLER_131_102 VGND VGND VPWR VPWR sky130_fd_sc_hd__decap_3
XFILLER_131_113 VGND VGND VPWR VPWR sky130_fd_sc_hd__decap_3
XFILLER_132_625 VGND VGND VPWR VPWR sky130_fd_sc_hd__decap_3
XPHY_EDGE_ROW_62_Right_62 VGND VGND VPWR VPWR sky130_fd_sc_hd__decap_3
X_7244_ _7270_/A VGND VGND VPWR VPWR _7244_/X sky130_fd_sc_hd__clkbuf_1
X_4456_ _8680_/Q _4560_/A2 _3916_/B _8599_/Q _4456_/C1 VGND VGND VPWR VPWR _4456_/X
+ sky130_fd_sc_hd__o221a_2
XFILLER_131_146 VGND VGND VPWR VPWR sky130_fd_sc_hd__decap_3
XFILLER_132_669 VGND VGND VPWR VPWR sky130_fd_sc_hd__decap_3
XFILLER_49_29 VGND VGND VPWR VPWR sky130_fd_sc_hd__decap_3
XTAP_TAPCELL_ROW_129_2105 VGND VPWR sky130_fd_sc_hd__tapvpwrvgnd_1
XTAP_TAPCELL_ROW_55_1060 VGND VPWR sky130_fd_sc_hd__tapvpwrvgnd_1
Xfanout703 fanout716/X VGND VGND VPWR VPWR fanout703/X sky130_fd_sc_hd__clkdlybuf4s25_1
X_7175_ _7175_/A VGND VGND VPWR VPWR _8620_/D sky130_fd_sc_hd__buf_1
X_4387_ _8017_/Q _3784_/X _4631_/A2 _7936_/Q _4444_/A1 VGND VGND VPWR VPWR _4387_/X
+ sky130_fd_sc_hd__o221a_2
XFILLER_100_511 VGND VGND VPWR VPWR sky130_fd_sc_hd__decap_3
XFILLER_58_403 VGND VGND VPWR VPWR sky130_fd_sc_hd__fill_2
XFILLER_86_701 VGND VGND VPWR VPWR sky130_fd_sc_hd__decap_3
XFILLER_86_723 VGND VGND VPWR VPWR sky130_fd_sc_hd__decap_3
XFILLER_98_561 VGND VGND VPWR VPWR sky130_fd_sc_hd__decap_3
XFILLER_98_583 VGND VGND VPWR VPWR sky130_fd_sc_hd__decap_3
Xfanout725 fanout736/X VGND VGND VPWR VPWR fanout725/X sky130_fd_sc_hd__clkdlybuf4s25_1
Xfanout736 fanout754/X VGND VGND VPWR VPWR fanout736/X sky130_fd_sc_hd__clkdlybuf4s25_1
Xfanout747 fanout753/X VGND VGND VPWR VPWR fanout747/X sky130_fd_sc_hd__clkdlybuf4s25_1
X_6126_ _6126_/A VGND VGND VPWR VPWR _8127_/D sky130_fd_sc_hd__buf_1
XFILLER_105_57 VGND VGND VPWR VPWR sky130_fd_sc_hd__decap_3
XFILLER_85_222 VGND VGND VPWR VPWR sky130_fd_sc_hd__fill_2
XFILLER_86_745 VGND VGND VPWR VPWR sky130_fd_sc_hd__fill_2
XFILLER_85_266 VGND VGND VPWR VPWR sky130_fd_sc_hd__decap_3
X_6057_ _6057_/A VGND VGND VPWR VPWR _8094_/D sky130_fd_sc_hd__buf_1
XFILLER_38_171 VGND VGND VPWR VPWR sky130_fd_sc_hd__decap_3
XFILLER_66_480 VGND VGND VPWR VPWR sky130_fd_sc_hd__fill_1
X_5008_ _5007_/X hold989/X _5028_/S VGND VGND VPWR VPWR _5009_/A sky130_fd_sc_hd__mux2_2
XFILLER_121_23 VGND VGND VPWR VPWR sky130_fd_sc_hd__decap_3
XFILLER_54_642 VGND VGND VPWR VPWR sky130_fd_sc_hd__fill_2
XFILLER_26_377 VGND VGND VPWR VPWR sky130_fd_sc_hd__fill_1
XPHY_EDGE_ROW_71_Right_71 VGND VGND VPWR VPWR sky130_fd_sc_hd__decap_3
XFILLER_121_89 VGND VGND VPWR VPWR sky130_fd_sc_hd__decap_3
XFILLER_26_399 VGND VGND VPWR VPWR sky130_fd_sc_hd__decap_3
XFILLER_41_358 VGND VGND VPWR VPWR sky130_fd_sc_hd__decap_3
XFILLER_81_38 VGND VGND VPWR VPWR sky130_fd_sc_hd__decap_3
X_6959_ _6959_/A VGND VGND VPWR VPWR _8518_/D sky130_fd_sc_hd__buf_6
XFILLER_10_701 VGND VGND VPWR VPWR sky130_fd_sc_hd__decap_3
XFILLER_14_21 VGND VGND VPWR VPWR sky130_fd_sc_hd__decap_3
XFILLER_14_32 VGND VGND VPWR VPWR sky130_fd_sc_hd__decap_3
XTAP_TAPCELL_ROW_120_1968 VGND VPWR sky130_fd_sc_hd__tapvpwrvgnd_1
XTAP_TAPCELL_ROW_120_1979 VGND VPWR sky130_fd_sc_hd__tapvpwrvgnd_1
XFILLER_10_734 VGND VGND VPWR VPWR sky130_fd_sc_hd__decap_3
XFILLER_14_65 VGND VGND VPWR VPWR sky130_fd_sc_hd__decap_3
XFILLER_22_583 VGND VGND VPWR VPWR sky130_fd_sc_hd__decap_3
X_8629_ _8788_/CLK _8629_/D fanout664/X VGND VGND VPWR VPWR _8629_/Q sky130_fd_sc_hd__dfrtp_2
XFILLER_10_778 VGND VGND VPWR VPWR sky130_fd_sc_hd__decap_3
XFILLER_6_716 VGND VGND VPWR VPWR sky130_fd_sc_hd__decap_3
XFILLER_5_237 VGND VGND VPWR VPWR sky130_fd_sc_hd__decap_3
XFILLER_6_749 VGND VGND VPWR VPWR sky130_fd_sc_hd__decap_3
Xclkbuf_leaf_54_CLK clkbuf_leaf_89_CLK/A VGND VGND VPWR VPWR _8672_/CLK sky130_fd_sc_hd__clkbuf_8
XFILLER_108_677 VGND VGND VPWR VPWR sky130_fd_sc_hd__decap_3
XFILLER_123_603 VGND VGND VPWR VPWR sky130_fd_sc_hd__fill_1
XFILLER_135_441 VGND VGND VPWR VPWR sky130_fd_sc_hd__decap_3
XFILLER_135_463 VGND VGND VPWR VPWR sky130_fd_sc_hd__decap_3
XPHY_EDGE_ROW_80_Right_80 VGND VGND VPWR VPWR sky130_fd_sc_hd__decap_3
XFILLER_108_699 VGND VGND VPWR VPWR sky130_fd_sc_hd__fill_1
XFILLER_107_198 VGND VGND VPWR VPWR sky130_fd_sc_hd__decap_3
XFILLER_122_124 VGND VGND VPWR VPWR sky130_fd_sc_hd__fill_1
XFILLER_123_669 VGND VGND VPWR VPWR sky130_fd_sc_hd__decap_3
Xhold790 _8673_/Q VGND VGND VPWR VPWR hold790/X sky130_fd_sc_hd__dlygate4sd3_1
XFILLER_49_414 VGND VGND VPWR VPWR sky130_fd_sc_hd__decap_3
XFILLER_76_200 VGND VGND VPWR VPWR sky130_fd_sc_hd__decap_3
XFILLER_89_561 VGND VGND VPWR VPWR sky130_fd_sc_hd__decap_3
XFILLER_131_691 VGND VGND VPWR VPWR sky130_fd_sc_hd__decap_3
XFILLER_76_277 VGND VGND VPWR VPWR sky130_fd_sc_hd__decap_3
XFILLER_92_704 VGND VGND VPWR VPWR sky130_fd_sc_hd__decap_3
XFILLER_57_480 VGND VGND VPWR VPWR sky130_fd_sc_hd__decap_3
XFILLER_92_737 VGND VGND VPWR VPWR sky130_fd_sc_hd__decap_3
XFILLER_17_333 VGND VGND VPWR VPWR sky130_fd_sc_hd__decap_3
XFILLER_44_141 VGND VGND VPWR VPWR sky130_fd_sc_hd__decap_3
XFILLER_55_72 VGND VGND VPWR VPWR sky130_fd_sc_hd__fill_1
XFILLER_17_388 VGND VGND VPWR VPWR sky130_fd_sc_hd__decap_3
XFILLER_44_174 VGND VGND VPWR VPWR sky130_fd_sc_hd__decap_3
XTAP_TAPCELL_ROW_15_501 VGND VPWR sky130_fd_sc_hd__tapvpwrvgnd_1
XFILLER_17_399 VGND VGND VPWR VPWR sky130_fd_sc_hd__fill_1
XFILLER_32_347 VGND VGND VPWR VPWR sky130_fd_sc_hd__decap_3
XFILLER_13_561 VGND VGND VPWR VPWR sky130_fd_sc_hd__decap_3
XFILLER_32_369 VGND VGND VPWR VPWR sky130_fd_sc_hd__decap_3
XFILLER_60_667 VGND VGND VPWR VPWR sky130_fd_sc_hd__decap_3
XFILLER_9_543 VGND VGND VPWR VPWR sky130_fd_sc_hd__decap_3
XTAP_TAPCELL_ROW_43_898 VGND VPWR sky130_fd_sc_hd__tapvpwrvgnd_1
XFILLER_126_430 VGND VGND VPWR VPWR sky130_fd_sc_hd__decap_3
XTAP_TAPCELL_ROW_97_1650 VGND VPWR sky130_fd_sc_hd__tapvpwrvgnd_1
Xclkbuf_leaf_45_CLK clkload5/A VGND VGND VPWR VPWR _8477_/CLK sky130_fd_sc_hd__clkbuf_8
XFILLER_113_113 VGND VGND VPWR VPWR sky130_fd_sc_hd__decap_3
XFILLER_126_474 VGND VGND VPWR VPWR sky130_fd_sc_hd__fill_2
XFILLER_5_771 VGND VGND VPWR VPWR sky130_fd_sc_hd__decap_3
X_5290_ _5290_/A VGND VGND VPWR VPWR _7698_/D sky130_fd_sc_hd__buf_1
X_4310_ _8101_/Q _8182_/Q _4327_/S VGND VGND VPWR VPWR _4311_/B sky130_fd_sc_hd__mux2_2
XFILLER_114_658 VGND VGND VPWR VPWR sky130_fd_sc_hd__decap_3
XFILLER_4_281 VGND VGND VPWR VPWR sky130_fd_sc_hd__decap_3
X_4241_ _4237_/X _4240_/X _4241_/S VGND VGND VPWR VPWR _4242_/A sky130_fd_sc_hd__mux2_2
XFILLER_122_691 VGND VGND VPWR VPWR sky130_fd_sc_hd__decap_3
X_4172_ _8413_/Q _8494_/Q _4183_/S VGND VGND VPWR VPWR _4173_/B sky130_fd_sc_hd__mux2_2
XFILLER_67_255 VGND VGND VPWR VPWR sky130_fd_sc_hd__decap_3
XFILLER_27_108 VGND VGND VPWR VPWR sky130_fd_sc_hd__decap_3
XFILLER_55_417 VGND VGND VPWR VPWR sky130_fd_sc_hd__decap_3
XFILLER_55_428 VGND VGND VPWR VPWR sky130_fd_sc_hd__fill_2
XFILLER_55_439 VGND VGND VPWR VPWR sky130_fd_sc_hd__fill_2
XFILLER_95_597 VGND VGND VPWR VPWR sky130_fd_sc_hd__decap_3
XTAP_TAPCELL_ROW_124_2024 VGND VPWR sky130_fd_sc_hd__tapvpwrvgnd_1
XTAP_TAPCELL_ROW_124_2035 VGND VPWR sky130_fd_sc_hd__tapvpwrvgnd_1
X_7931_ _8745_/CLK _7931_/D load_slew626/X VGND VGND VPWR VPWR _7931_/Q sky130_fd_sc_hd__dfrtp_2
XFILLER_63_483 VGND VGND VPWR VPWR sky130_fd_sc_hd__decap_3
X_7862_ _8763_/CLK _7862_/D fanout559/X VGND VGND VPWR VPWR _7862_/Q sky130_fd_sc_hd__dfrtp_2
X_7793_ _8775_/CLK _7793_/D load_slew727/X VGND VGND VPWR VPWR _7793_/Q sky130_fd_sc_hd__dfrtp_2
X_6813_ _6813_/A VGND VGND VPWR VPWR _8449_/D sky130_fd_sc_hd__buf_2
X_3956_ _8393_/Q _8474_/Q _8555_/Q _8636_/Q _3957_/S _3958_/A VGND VGND VPWR VPWR
+ _3956_/X sky130_fd_sc_hd__mux4_2
X_6744_ _8417_/Q _4768_/A _6744_/S VGND VGND VPWR VPWR _6745_/A sky130_fd_sc_hd__mux2_2
X_6675_ _8384_/Q _4972_/A _6681_/S VGND VGND VPWR VPWR _6676_/A sky130_fd_sc_hd__mux2_2
XFILLER_31_391 VGND VGND VPWR VPWR sky130_fd_sc_hd__fill_1
X_3887_ _8711_/Q _8792_/Q _3887_/S VGND VGND VPWR VPWR _3888_/B sky130_fd_sc_hd__mux2_2
X_8414_ _8495_/CLK _8414_/D fanout517/X VGND VGND VPWR VPWR _8414_/Q sky130_fd_sc_hd__dfrtp_2
X_5626_ _5626_/A VGND VGND VPWR VPWR _7856_/D sky130_fd_sc_hd__buf_1
Xclkbuf_leaf_36_CLK clkload3/A VGND VGND VPWR VPWR _8685_/CLK sky130_fd_sc_hd__clkbuf_8
XFILLER_117_430 VGND VGND VPWR VPWR sky130_fd_sc_hd__decap_3
XFILLER_117_452 VGND VGND VPWR VPWR sky130_fd_sc_hd__decap_3
XFILLER_129_290 VGND VGND VPWR VPWR sky130_fd_sc_hd__decap_3
XTAP_TAPCELL_ROW_135_2186 VGND VPWR sky130_fd_sc_hd__tapvpwrvgnd_1
XTAP_TAPCELL_ROW_135_2197 VGND VPWR sky130_fd_sc_hd__tapvpwrvgnd_1
X_8345_ _8750_/CLK _8345_/D fanout641/X VGND VGND VPWR VPWR _8345_/Q sky130_fd_sc_hd__dfrtp_2
X_5557_ _5557_/A VGND VGND VPWR VPWR _7823_/D sky130_fd_sc_hd__buf_1
XFILLER_132_400 VGND VGND VPWR VPWR sky130_fd_sc_hd__decap_3
X_8276_ _8766_/CLK _8276_/D fanout575/X VGND VGND VPWR VPWR _8276_/Q sky130_fd_sc_hd__dfrtp_2
X_5488_ _5488_/A VGND VGND VPWR VPWR _7791_/D sky130_fd_sc_hd__buf_1
X_4508_ _4526_/S _4508_/B VGND VGND VPWR VPWR _4508_/X sky130_fd_sc_hd__or2_2
XFILLER_116_12 VGND VGND VPWR VPWR sky130_fd_sc_hd__decap_3
XFILLER_132_433 VGND VGND VPWR VPWR sky130_fd_sc_hd__decap_3
XFILLER_4_9 VGND VGND VPWR VPWR sky130_fd_sc_hd__decap_3
X_7227_ _7215_/X _4765_/X _7217_/X _7218_/X hold863/X VGND VGND VPWR VPWR _8659_/D
+ sky130_fd_sc_hd__a32o_2
X_4439_ _7697_/Q _4652_/A2 _3817_/X _7616_/Q _3819_/X VGND VGND VPWR VPWR _4439_/X
+ sky130_fd_sc_hd__o221a_2
XFILLER_104_179 VGND VGND VPWR VPWR sky130_fd_sc_hd__fill_2
XFILLER_132_466 VGND VGND VPWR VPWR sky130_fd_sc_hd__decap_3
XFILLER_132_477 VGND VGND VPWR VPWR sky130_fd_sc_hd__decap_3
Xfanout500 fanout506/X VGND VGND VPWR VPWR fanout500/X sky130_fd_sc_hd__clkdlybuf4s25_1
Xfanout522 fanout527/X VGND VGND VPWR VPWR fanout522/X sky130_fd_sc_hd__clkdlybuf4s25_1
XFILLER_58_200 VGND VGND VPWR VPWR sky130_fd_sc_hd__decap_3
XFILLER_58_222 VGND VGND VPWR VPWR sky130_fd_sc_hd__decap_3
XFILLER_59_756 VGND VGND VPWR VPWR sky130_fd_sc_hd__decap_3
XFILLER_76_27 VGND VGND VPWR VPWR sky130_fd_sc_hd__fill_1
XFILLER_98_380 VGND VGND VPWR VPWR sky130_fd_sc_hd__fill_1
Xfanout544 fanout548/X VGND VGND VPWR VPWR fanout544/X sky130_fd_sc_hd__clkdlybuf4s25_1
Xfanout566 fanout577/X VGND VGND VPWR VPWR fanout566/X sky130_fd_sc_hd__clkdlybuf4s25_1
X_7158_ _4908_/X _8612_/Q _7172_/S VGND VGND VPWR VPWR _7159_/A sky130_fd_sc_hd__mux2_2
XFILLER_100_352 VGND VGND VPWR VPWR sky130_fd_sc_hd__decap_3
XFILLER_58_244 VGND VGND VPWR VPWR sky130_fd_sc_hd__decap_3
XFILLER_59_778 VGND VGND VPWR VPWR sky130_fd_sc_hd__decap_3
XFILLER_74_704 VGND VGND VPWR VPWR sky130_fd_sc_hd__fill_2
XFILLER_86_564 VGND VGND VPWR VPWR sky130_fd_sc_hd__decap_3
XTAP_TAPCELL_ROW_109_1819 VGND VPWR sky130_fd_sc_hd__tapvpwrvgnd_1
Xfanout577 fanout613/X VGND VGND VPWR VPWR fanout577/X sky130_fd_sc_hd__clkdlybuf4s25_1
Xfanout588 fanout594/X VGND VGND VPWR VPWR fanout588/X sky130_fd_sc_hd__clkdlybuf4s25_1
Xfanout599 fanout609/A VGND VGND VPWR VPWR wire600/A sky130_fd_sc_hd__clkdlybuf4s25_1
X_7089_ _7089_/A VGND VGND VPWR VPWR _8579_/D sky130_fd_sc_hd__buf_2
X_6109_ _6109_/A VGND VGND VPWR VPWR _8119_/D sky130_fd_sc_hd__buf_1
XFILLER_132_44 VGND VGND VPWR VPWR sky130_fd_sc_hd__decap_3
XFILLER_73_225 VGND VGND VPWR VPWR sky130_fd_sc_hd__decap_3
XFILLER_132_77 VGND VGND VPWR VPWR sky130_fd_sc_hd__decap_3
XFILLER_26_130 VGND VGND VPWR VPWR sky130_fd_sc_hd__decap_3
XFILLER_73_258 VGND VGND VPWR VPWR sky130_fd_sc_hd__fill_1
XTAP_TAPCELL_ROW_68_1240 VGND VPWR sky130_fd_sc_hd__tapvpwrvgnd_1
XFILLER_132_88 VGND VGND VPWR VPWR sky130_fd_sc_hd__decap_3
XFILLER_26_141 VGND VGND VPWR VPWR sky130_fd_sc_hd__decap_3
XFILLER_42_601 VGND VGND VPWR VPWR sky130_fd_sc_hd__decap_3
XFILLER_54_450 VGND VGND VPWR VPWR sky130_fd_sc_hd__fill_2
XTAP_TAPCELL_ROW_68_1251 VGND VPWR sky130_fd_sc_hd__tapvpwrvgnd_1
XFILLER_25_42 VGND VGND VPWR VPWR sky130_fd_sc_hd__decap_3
XFILLER_41_122 VGND VGND VPWR VPWR sky130_fd_sc_hd__fill_2
XFILLER_42_634 VGND VGND VPWR VPWR sky130_fd_sc_hd__decap_3
XFILLER_42_645 VGND VGND VPWR VPWR sky130_fd_sc_hd__decap_3
XFILLER_54_494 VGND VGND VPWR VPWR sky130_fd_sc_hd__decap_3
XFILLER_25_75 VGND VGND VPWR VPWR sky130_fd_sc_hd__decap_3
XFILLER_41_166 VGND VGND VPWR VPWR sky130_fd_sc_hd__fill_2
XFILLER_128_728 VGND VGND VPWR VPWR sky130_fd_sc_hd__decap_3
XTAP_TAPCELL_ROW_40_846 VGND VPWR sky130_fd_sc_hd__tapvpwrvgnd_1
XTAP_TAPCELL_ROW_40_857 VGND VPWR sky130_fd_sc_hd__tapvpwrvgnd_1
XFILLER_127_249 VGND VGND VPWR VPWR sky130_fd_sc_hd__fill_1
Xclkbuf_leaf_27_CLK clkbuf_5_8__f_CLK/X VGND VGND VPWR VPWR _8770_/CLK sky130_fd_sc_hd__clkbuf_8
XFILLER_108_430 VGND VGND VPWR VPWR sky130_fd_sc_hd__decap_3
XFILLER_6_568 VGND VGND VPWR VPWR sky130_fd_sc_hd__decap_3
XTAP_TAPCELL_ROW_20_570 VGND VPWR sky130_fd_sc_hd__tapvpwrvgnd_1
XFILLER_135_271 VGND VGND VPWR VPWR sky130_fd_sc_hd__fill_1
XFILLER_123_488 VGND VGND VPWR VPWR sky130_fd_sc_hd__decap_3
XFILLER_2_752 VGND VGND VPWR VPWR sky130_fd_sc_hd__decap_3
XFILLER_2_763 VGND VGND VPWR VPWR sky130_fd_sc_hd__decap_3
XTAP_TAPCELL_ROW_92_1580 VGND VPWR sky130_fd_sc_hd__tapvpwrvgnd_1
XFILLER_104_680 VGND VGND VPWR VPWR sky130_fd_sc_hd__decap_3
XFILLER_110_138 VGND VGND VPWR VPWR sky130_fd_sc_hd__fill_2
XFILLER_2_24 VGND VGND VPWR VPWR sky130_fd_sc_hd__decap_3
XFILLER_2_35 VGND VGND VPWR VPWR sky130_fd_sc_hd__decap_3
XFILLER_2_796 VGND VGND VPWR VPWR sky130_fd_sc_hd__decap_3
XFILLER_77_531 VGND VGND VPWR VPWR sky130_fd_sc_hd__decap_3
XFILLER_2_68 VGND VGND VPWR VPWR sky130_fd_sc_hd__decap_3
XFILLER_77_564 VGND VGND VPWR VPWR sky130_fd_sc_hd__fill_2
XFILLER_77_575 VGND VGND VPWR VPWR sky130_fd_sc_hd__decap_3
XFILLER_37_417 VGND VGND VPWR VPWR sky130_fd_sc_hd__decap_3
XFILLER_64_203 VGND VGND VPWR VPWR sky130_fd_sc_hd__decap_3
XFILLER_92_545 VGND VGND VPWR VPWR sky130_fd_sc_hd__fill_2
XTAP_TAPCELL_ROW_48_968 VGND VPWR sky130_fd_sc_hd__tapvpwrvgnd_1
XFILLER_45_461 VGND VGND VPWR VPWR sky130_fd_sc_hd__decap_3
XFILLER_18_697 VGND VGND VPWR VPWR sky130_fd_sc_hd__decap_3
XFILLER_32_111 VGND VGND VPWR VPWR sky130_fd_sc_hd__fill_2
XFILLER_33_656 VGND VGND VPWR VPWR sky130_fd_sc_hd__decap_3
XFILLER_45_494 VGND VGND VPWR VPWR sky130_fd_sc_hd__decap_3
XTAP_TAPCELL_ROW_28_681 VGND VPWR sky130_fd_sc_hd__tapvpwrvgnd_1
XFILLER_32_144 VGND VGND VPWR VPWR sky130_fd_sc_hd__decap_3
X_3810_ _7723_/Q _7804_/Q _3814_/S VGND VGND VPWR VPWR _3810_/X sky130_fd_sc_hd__mux2_2
X_4790_ _4790_/A _4810_/B VGND VGND VPWR VPWR _4791_/A sky130_fd_sc_hd__and2_2
XFILLER_20_317 VGND VGND VPWR VPWR sky130_fd_sc_hd__decap_3
X_3741_ _3939_/A VGND VGND VPWR VPWR _3995_/B sky130_fd_sc_hd__clkbuf_2
XFILLER_9_340 VGND VGND VPWR VPWR sky130_fd_sc_hd__decap_3
XFILLER_9_362 VGND VGND VPWR VPWR sky130_fd_sc_hd__decap_3
Xclkbuf_leaf_18_CLK clkbuf_leaf_52_CLK/A VGND VGND VPWR VPWR _8161_/CLK sky130_fd_sc_hd__clkbuf_8
X_6460_ _6460_/A VGND VGND VPWR VPWR _8284_/D sky130_fd_sc_hd__buf_2
XFILLER_127_750 VGND VGND VPWR VPWR sky130_fd_sc_hd__decap_3
X_6391_ _6391_/A VGND VGND VPWR VPWR _8251_/D sky130_fd_sc_hd__buf_2
X_5411_ _7755_/Q _4752_/A _5419_/S VGND VGND VPWR VPWR _5412_/A sky130_fd_sc_hd__mux2_2
XFILLER_127_783 VGND VGND VPWR VPWR sky130_fd_sc_hd__fill_1
XFILLER_127_794 VGND VGND VPWR VPWR sky130_fd_sc_hd__decap_3
XFILLER_133_208 VGND VGND VPWR VPWR sky130_fd_sc_hd__decap_3
Xoutput125 _4277_/X VGND VGND VPWR VPWR rdata[44] sky130_fd_sc_hd__clkdlybuf4s25_1
Xoutput114 _4168_/X VGND VGND VPWR VPWR rdata[34] sky130_fd_sc_hd__clkdlybuf4s25_1
Xoutput103 _4060_/X VGND VGND VPWR VPWR rdata[24] sky130_fd_sc_hd__clkdlybuf4s25_1
X_8130_ _8776_/CLK _8130_/D load_slew731/X VGND VGND VPWR VPWR _8130_/Q sky130_fd_sc_hd__dfrtp_2
X_5342_ _7722_/Q _4956_/A _5356_/S VGND VGND VPWR VPWR _5343_/A sky130_fd_sc_hd__mux2_2
XFILLER_114_433 VGND VGND VPWR VPWR sky130_fd_sc_hd__decap_3
Xoutput136 _4396_/X VGND VGND VPWR VPWR rdata[54] sky130_fd_sc_hd__clkdlybuf4s25_1
Xoutput147 _4511_/X VGND VGND VPWR VPWR rdata[64] sky130_fd_sc_hd__clkdlybuf4s25_1
Xoutput158 _4618_/X VGND VGND VPWR VPWR rdata[74] sky130_fd_sc_hd__clkdlybuf4s25_1
X_8061_ _8790_/CLK _8061_/D load_slew673/X VGND VGND VPWR VPWR _8061_/Q sky130_fd_sc_hd__dfrtp_2
XFILLER_114_477 VGND VGND VPWR VPWR sky130_fd_sc_hd__decap_3
XFILLER_99_166 VGND VGND VPWR VPWR sky130_fd_sc_hd__fill_2
X_7012_ _7012_/A VGND VGND VPWR VPWR _8542_/D sky130_fd_sc_hd__buf_2
X_5273_ _7690_/Q _4819_/X _5289_/S VGND VGND VPWR VPWR _5274_/A sky130_fd_sc_hd__mux2_2
XFILLER_101_116 VGND VGND VPWR VPWR sky130_fd_sc_hd__fill_2
X_4224_ _4241_/S _4219_/X _4221_/X _4223_/X VGND VGND VPWR VPWR _4224_/X sky130_fd_sc_hd__a22o_2
XFILLER_101_149 VGND VGND VPWR VPWR sky130_fd_sc_hd__fill_2
XFILLER_68_553 VGND VGND VPWR VPWR sky130_fd_sc_hd__decap_3
X_4155_ _4149_/X _4154_/X _4165_/A VGND VGND VPWR VPWR _4156_/A sky130_fd_sc_hd__mux2_2
XFILLER_110_672 VGND VGND VPWR VPWR sky130_fd_sc_hd__decap_3
XFILLER_55_225 VGND VGND VPWR VPWR sky130_fd_sc_hd__decap_3
XFILLER_68_586 VGND VGND VPWR VPWR sky130_fd_sc_hd__fill_2
XFILLER_83_523 VGND VGND VPWR VPWR sky130_fd_sc_hd__fill_2
XFILLER_83_567 VGND VGND VPWR VPWR sky130_fd_sc_hd__decap_3
X_4086_ _3732_/X _4080_/X _4085_/X VGND VGND VPWR VPWR _4086_/X sky130_fd_sc_hd__o21a_2
XFILLER_102_14 VGND VGND VPWR VPWR sky130_fd_sc_hd__decap_3
XFILLER_24_601 VGND VGND VPWR VPWR sky130_fd_sc_hd__decap_3
XFILLER_71_729 VGND VGND VPWR VPWR sky130_fd_sc_hd__fill_2
X_7914_ _8660_/CLK _7914_/D load_slew524/X VGND VGND VPWR VPWR _7914_/Q sky130_fd_sc_hd__dfrtp_2
XFILLER_24_645 VGND VGND VPWR VPWR sky130_fd_sc_hd__decap_3
XFILLER_36_483 VGND VGND VPWR VPWR sky130_fd_sc_hd__decap_3
XFILLER_51_420 VGND VGND VPWR VPWR sky130_fd_sc_hd__decap_3
XTAP_TAPCELL_ROW_104_1749 VGND VPWR sky130_fd_sc_hd__tapvpwrvgnd_1
X_7845_ _8662_/CLK _7845_/D load_slew621/X VGND VGND VPWR VPWR _7845_/Q sky130_fd_sc_hd__dfrtp_2
XFILLER_23_133 VGND VGND VPWR VPWR sky130_fd_sc_hd__fill_2
XFILLER_24_689 VGND VGND VPWR VPWR sky130_fd_sc_hd__decap_3
XFILLER_11_306 VGND VGND VPWR VPWR sky130_fd_sc_hd__decap_3
XTAP_TAPCELL_ROW_63_1170 VGND VPWR sky130_fd_sc_hd__tapvpwrvgnd_1
X_7776_ _8019_/CLK _7776_/D load_slew714/X VGND VGND VPWR VPWR _7776_/Q sky130_fd_sc_hd__dfrtp_2
X_4988_ input4/X _4988_/B VGND VGND VPWR VPWR _4989_/A sky130_fd_sc_hd__and2_2
XTAP_TAPCELL_ROW_63_1181 VGND VPWR sky130_fd_sc_hd__tapvpwrvgnd_1
X_3939_ _3939_/A VGND VGND VPWR VPWR _3939_/X sky130_fd_sc_hd__clkbuf_2
Xwire219 _4988_/B VGND VGND VPWR VPWR _4984_/B sky130_fd_sc_hd__clkbuf_4
X_6727_ _6727_/A VGND VGND VPWR VPWR _8408_/D sky130_fd_sc_hd__buf_2
X_6658_ _6141_/C _6658_/B _6658_/C VGND VGND VPWR VPWR _6659_/A sky130_fd_sc_hd__and3b_2
XFILLER_11_33 VGND VGND VPWR VPWR sky130_fd_sc_hd__decap_3
X_5609_ _5609_/A VGND VGND VPWR VPWR _7848_/D sky130_fd_sc_hd__buf_1
XFILLER_117_260 VGND VGND VPWR VPWR sky130_fd_sc_hd__decap_3
XFILLER_118_772 VGND VGND VPWR VPWR sky130_fd_sc_hd__fill_1
XFILLER_118_794 VGND VGND VPWR VPWR sky130_fd_sc_hd__fill_2
XFILLER_11_66 VGND VGND VPWR VPWR sky130_fd_sc_hd__decap_3
XFILLER_127_33 VGND VGND VPWR VPWR sky130_fd_sc_hd__decap_3
X_8328_ _8328_/CLK _8328_/D fanout475/A VGND VGND VPWR VPWR _8328_/Q sky130_fd_sc_hd__dfrtp_2
X_6589_ _4807_/X _8345_/Q _6591_/S VGND VGND VPWR VPWR _6590_/A sky130_fd_sc_hd__mux2_2
XFILLER_127_66 VGND VGND VPWR VPWR sky130_fd_sc_hd__decap_3
XFILLER_132_230 VGND VGND VPWR VPWR sky130_fd_sc_hd__decap_3
XFILLER_133_753 VGND VGND VPWR VPWR sky130_fd_sc_hd__decap_3
XFILLER_2_6 VGND VGND VPWR VPWR sky130_fd_sc_hd__decap_3
XFILLER_127_99 VGND VGND VPWR VPWR sky130_fd_sc_hd__decap_3
XFILLER_133_797 VGND VGND VPWR VPWR sky130_fd_sc_hd__decap_3
XFILLER_78_317 VGND VGND VPWR VPWR sky130_fd_sc_hd__decap_3
X_8259_ _8583_/CLK _8259_/D wire618/X VGND VGND VPWR VPWR _8259_/Q sky130_fd_sc_hd__dfrtp_2
XFILLER_132_274 VGND VGND VPWR VPWR sky130_fd_sc_hd__decap_3
XFILLER_120_469 VGND VGND VPWR VPWR sky130_fd_sc_hd__fill_2
XFILLER_59_564 VGND VGND VPWR VPWR sky130_fd_sc_hd__decap_3
XFILLER_86_350 VGND VGND VPWR VPWR sky130_fd_sc_hd__decap_3
XFILLER_93_309 VGND VGND VPWR VPWR sky130_fd_sc_hd__fill_1
XTAP_TAPCELL_ROW_6_376 VGND VPWR sky130_fd_sc_hd__tapvpwrvgnd_1
Xfanout352 _4524_/S1 VGND VGND VPWR VPWR wire353/A sky130_fd_sc_hd__clkdlybuf4s25_1
Xfanout363 fanout364/X VGND VGND VPWR VPWR _4013_/A1 sky130_fd_sc_hd__clkdlybuf4s25_1
XFILLER_46_214 VGND VGND VPWR VPWR sky130_fd_sc_hd__decap_3
XFILLER_74_512 VGND VGND VPWR VPWR sky130_fd_sc_hd__fill_2
XFILLER_74_523 VGND VGND VPWR VPWR sky130_fd_sc_hd__decap_3
XFILLER_86_383 VGND VGND VPWR VPWR sky130_fd_sc_hd__decap_3
Xfanout385 _4569_/A VGND VGND VPWR VPWR _4633_/A sky130_fd_sc_hd__clkdlybuf4s25_1
XFILLER_46_236 VGND VGND VPWR VPWR sky130_fd_sc_hd__decap_3
XFILLER_62_707 VGND VGND VPWR VPWR sky130_fd_sc_hd__decap_3
XFILLER_34_409 VGND VGND VPWR VPWR sky130_fd_sc_hd__fill_2
XFILLER_36_41 VGND VGND VPWR VPWR sky130_fd_sc_hd__decap_3
XFILLER_36_63 VGND VGND VPWR VPWR sky130_fd_sc_hd__fill_1
XTAP_TAPCELL_ROW_45_916 VGND VPWR sky130_fd_sc_hd__tapvpwrvgnd_1
XTAP_TAPCELL_ROW_45_927 VGND VPWR sky130_fd_sc_hd__tapvpwrvgnd_1
XFILLER_14_100 VGND VGND VPWR VPWR sky130_fd_sc_hd__decap_3
XFILLER_15_634 VGND VGND VPWR VPWR sky130_fd_sc_hd__fill_1
XFILLER_36_85 VGND VGND VPWR VPWR sky130_fd_sc_hd__decap_3
XFILLER_54_280 VGND VGND VPWR VPWR sky130_fd_sc_hd__decap_3
XFILLER_61_228 VGND VGND VPWR VPWR sky130_fd_sc_hd__fill_2
XFILLER_14_133 VGND VGND VPWR VPWR sky130_fd_sc_hd__decap_3
XFILLER_14_144 VGND VGND VPWR VPWR sky130_fd_sc_hd__decap_3
XFILLER_15_656 VGND VGND VPWR VPWR sky130_fd_sc_hd__decap_3
XFILLER_30_604 VGND VGND VPWR VPWR sky130_fd_sc_hd__decap_3
XTAP_TAPCELL_ROW_25_640 VGND VPWR sky130_fd_sc_hd__tapvpwrvgnd_1
XFILLER_30_648 VGND VGND VPWR VPWR sky130_fd_sc_hd__fill_2
XFILLER_7_800 VGND VGND VPWR VPWR sky130_fd_sc_hd__decap_3
XFILLER_128_525 VGND VGND VPWR VPWR sky130_fd_sc_hd__decap_3
XFILLER_128_536 VGND VGND VPWR VPWR sky130_fd_sc_hd__decap_3
Xinput16 wdata[21] VGND VGND VPWR VPWR _5035_/A sky130_fd_sc_hd__clkdlybuf4s25_1
Xinput27 wdata[31] VGND VGND VPWR VPWR _4734_/A sky130_fd_sc_hd__clkdlybuf4s25_1
XFILLER_109_750 VGND VGND VPWR VPWR sky130_fd_sc_hd__decap_3
XFILLER_10_383 VGND VGND VPWR VPWR sky130_fd_sc_hd__fill_2
XFILLER_128_569 VGND VGND VPWR VPWR sky130_fd_sc_hd__decap_3
Xinput38 wdata[41] VGND VGND VPWR VPWR _4776_/A sky130_fd_sc_hd__clkdlybuf4s25_1
Xinput49 wdata[51] VGND VGND VPWR VPWR _4818_/A sky130_fd_sc_hd__clkdlybuf4s25_1
XFILLER_6_365 VGND VGND VPWR VPWR sky130_fd_sc_hd__fill_2
XFILLER_108_282 VGND VGND VPWR VPWR sky130_fd_sc_hd__fill_1
Xload_slew714 fanout713/X VGND VGND VPWR VPWR load_slew714/X sky130_fd_sc_hd__clkbuf_4
XFILLER_111_425 VGND VGND VPWR VPWR sky130_fd_sc_hd__decap_3
XFILLER_124_797 VGND VGND VPWR VPWR sky130_fd_sc_hd__decap_3
XFILLER_35_6 VGND VGND VPWR VPWR sky130_fd_sc_hd__decap_3
XFILLER_84_309 VGND VGND VPWR VPWR sky130_fd_sc_hd__fill_1
XFILLER_96_147 VGND VGND VPWR VPWR sky130_fd_sc_hd__fill_2
XFILLER_37_225 VGND VGND VPWR VPWR sky130_fd_sc_hd__decap_3
Xclkbuf_leaf_7_CLK clkbuf_leaf_8_CLK/A VGND VGND VPWR VPWR _8731_/CLK sky130_fd_sc_hd__clkbuf_8
XFILLER_53_729 VGND VGND VPWR VPWR sky130_fd_sc_hd__fill_2
XFILLER_65_567 VGND VGND VPWR VPWR sky130_fd_sc_hd__decap_3
X_5960_ _5959_/X _5947_/A _4941_/X _5948_/A hold914/X VGND VGND VPWR VPWR _8043_/D
+ sky130_fd_sc_hd__a32o_2
XFILLER_46_781 VGND VGND VPWR VPWR sky130_fd_sc_hd__decap_3
X_5891_ _5893_/A1 _5893_/A2 _4719_/X _5893_/B1 hold764/X VGND VGND VPWR VPWR _7990_/D
+ sky130_fd_sc_hd__a32o_2
X_4911_ _4911_/A VGND VGND VPWR VPWR _7549_/D sky130_fd_sc_hd__buf_1
XFILLER_61_740 VGND VGND VPWR VPWR sky130_fd_sc_hd__fill_1
X_7630_ _8450_/CLK _7630_/D load_slew742/X VGND VGND VPWR VPWR _7630_/Q sky130_fd_sc_hd__dfrtp_2
XFILLER_33_475 VGND VGND VPWR VPWR sky130_fd_sc_hd__decap_3
X_4842_ _4841_/X _4842_/A1 _4862_/S VGND VGND VPWR VPWR _4843_/A sky130_fd_sc_hd__mux2_2
XFILLER_119_503 VGND VGND VPWR VPWR sky130_fd_sc_hd__fill_1
X_7561_ _8462_/CLK _7561_/D wire669/X VGND VGND VPWR VPWR _7561_/Q sky130_fd_sc_hd__dfrtp_2
X_4773_ _4773_/A VGND VGND VPWR VPWR _4773_/X sky130_fd_sc_hd__buf_1
X_3724_ _8049_/Q _3722_/X _3728_/B VGND VGND VPWR VPWR _3725_/A sky130_fd_sc_hd__o21ba_2
X_7492_ _7492_/A VGND VGND VPWR VPWR _8801_/D sky130_fd_sc_hd__buf_1
X_6512_ _4995_/X _8308_/Q _6528_/S VGND VGND VPWR VPWR _6513_/A sky130_fd_sc_hd__mux2_2
XFILLER_9_181 VGND VGND VPWR VPWR sky130_fd_sc_hd__decap_3
X_6443_ _4857_/X _8276_/Q _6461_/S VGND VGND VPWR VPWR _6444_/A sky130_fd_sc_hd__mux2_2
XFILLER_134_528 VGND VGND VPWR VPWR sky130_fd_sc_hd__decap_3
XFILLER_134_539 VGND VGND VPWR VPWR sky130_fd_sc_hd__decap_3
XTAP_TAPCELL_ROW_132_2134 VGND VPWR sky130_fd_sc_hd__tapvpwrvgnd_1
XTAP_TAPCELL_ROW_132_2145 VGND VPWR sky130_fd_sc_hd__tapvpwrvgnd_1
XFILLER_127_591 VGND VGND VPWR VPWR sky130_fd_sc_hd__decap_3
X_6374_ _6374_/A VGND VGND VPWR VPWR _8243_/D sky130_fd_sc_hd__buf_2
XFILLER_130_701 VGND VGND VPWR VPWR sky130_fd_sc_hd__decap_3
X_8113_ _8759_/CLK _8113_/D fanout705/X VGND VGND VPWR VPWR _8113_/Q sky130_fd_sc_hd__dfrtp_2
X_5325_ _7715_/Q _4925_/X _5331_/S VGND VGND VPWR VPWR _5326_/A sky130_fd_sc_hd__mux2_2
XFILLER_130_734 VGND VGND VPWR VPWR sky130_fd_sc_hd__decap_3
XFILLER_88_648 VGND VGND VPWR VPWR sky130_fd_sc_hd__decap_3
X_8044_ _8608_/CLK _8044_/D wire547/X VGND VGND VPWR VPWR _8044_/Q sky130_fd_sc_hd__dfrtp_2
X_5256_ _7682_/Q _4787_/X _5268_/S VGND VGND VPWR VPWR _5257_/A sky130_fd_sc_hd__mux2_2
XFILLER_130_778 VGND VGND VPWR VPWR sky130_fd_sc_hd__decap_3
XFILLER_87_169 VGND VGND VPWR VPWR sky130_fd_sc_hd__decap_3
X_4207_ _7677_/Q _3774_/X _4436_/B1 _7596_/Q _3733_/A VGND VGND VPWR VPWR _4207_/X
+ sky130_fd_sc_hd__o221a_2
XTAP_TAPCELL_ROW_3_335 VGND VPWR sky130_fd_sc_hd__tapvpwrvgnd_1
X_5187_ _7649_/Q _4989_/X _5205_/S VGND VGND VPWR VPWR _5188_/A sky130_fd_sc_hd__mux2_2
XFILLER_110_480 VGND VGND VPWR VPWR sky130_fd_sc_hd__decap_3
XFILLER_113_35 VGND VGND VPWR VPWR sky130_fd_sc_hd__fill_1
XFILLER_28_247 VGND VGND VPWR VPWR sky130_fd_sc_hd__decap_3
XFILLER_56_556 VGND VGND VPWR VPWR sky130_fd_sc_hd__decap_3
X_4138_ _8653_/Q _4295_/A2 _4137_/X VGND VGND VPWR VPWR _4138_/X sky130_fd_sc_hd__o21a_2
X_4069_ _8727_/Q _7502_/Q _7583_/Q _7664_/Q _4035_/S _4146_/A VGND VGND VPWR VPWR
+ _4069_/X sky130_fd_sc_hd__mux4_2
XFILLER_71_559 VGND VGND VPWR VPWR sky130_fd_sc_hd__fill_1
XFILLER_73_39 VGND VGND VPWR VPWR sky130_fd_sc_hd__decap_3
XFILLER_12_604 VGND VGND VPWR VPWR sky130_fd_sc_hd__decap_3
XFILLER_12_637 VGND VGND VPWR VPWR sky130_fd_sc_hd__decap_3
XFILLER_24_486 VGND VGND VPWR VPWR sky130_fd_sc_hd__decap_3
X_7828_ _8729_/CLK _7828_/D fanout490/X VGND VGND VPWR VPWR _7828_/Q sky130_fd_sc_hd__dfrtp_2
XFILLER_8_619 VGND VGND VPWR VPWR sky130_fd_sc_hd__decap_3
X_7759_ _8734_/CLK _7759_/D wire519/X VGND VGND VPWR VPWR _7759_/Q sky130_fd_sc_hd__dfrtp_2
XFILLER_22_32 VGND VGND VPWR VPWR sky130_fd_sc_hd__decap_3
XFILLER_22_65 VGND VGND VPWR VPWR sky130_fd_sc_hd__decap_3
XPHY_EDGE_ROW_129_Right_129 VGND VGND VPWR VPWR sky130_fd_sc_hd__decap_3
XTAP_TAPCELL_ROW_117_1929 VGND VPWR sky130_fd_sc_hd__tapvpwrvgnd_1
XTAP_TAPCELL_ROW_50_996 VGND VPWR sky130_fd_sc_hd__tapvpwrvgnd_1
XFILLER_118_3 VGND VGND VPWR VPWR sky130_fd_sc_hd__decap_3
XFILLER_3_302 VGND VGND VPWR VPWR sky130_fd_sc_hd__fill_1
XFILLER_106_731 VGND VGND VPWR VPWR sky130_fd_sc_hd__decap_3
XTAP_TAPCELL_ROW_76_1350 VGND VPWR sky130_fd_sc_hd__tapvpwrvgnd_1
XTAP_TAPCELL_ROW_76_1361 VGND VPWR sky130_fd_sc_hd__tapvpwrvgnd_1
XFILLER_0_3 VGND VGND VPWR VPWR sky130_fd_sc_hd__decap_3
XFILLER_106_753 VGND VGND VPWR VPWR sky130_fd_sc_hd__decap_3
XFILLER_133_550 VGND VGND VPWR VPWR sky130_fd_sc_hd__decap_3
XFILLER_133_561 VGND VGND VPWR VPWR sky130_fd_sc_hd__decap_3
XFILLER_3_346 VGND VGND VPWR VPWR sky130_fd_sc_hd__fill_1
XFILLER_79_615 VGND VGND VPWR VPWR sky130_fd_sc_hd__fill_1
XFILLER_106_797 VGND VGND VPWR VPWR sky130_fd_sc_hd__decap_3
XFILLER_121_734 VGND VGND VPWR VPWR sky130_fd_sc_hd__fill_1
XFILLER_133_594 VGND VGND VPWR VPWR sky130_fd_sc_hd__decap_3
XFILLER_79_626 VGND VGND VPWR VPWR sky130_fd_sc_hd__decap_3
XFILLER_120_233 VGND VGND VPWR VPWR sky130_fd_sc_hd__decap_3
XFILLER_78_147 VGND VGND VPWR VPWR sky130_fd_sc_hd__fill_1
XFILLER_78_158 VGND VGND VPWR VPWR sky130_fd_sc_hd__decap_3
XFILLER_120_288 VGND VGND VPWR VPWR sky130_fd_sc_hd__decap_3
XFILLER_47_512 VGND VGND VPWR VPWR sky130_fd_sc_hd__fill_1
XFILLER_74_331 VGND VGND VPWR VPWR sky130_fd_sc_hd__decap_3
XFILLER_86_180 VGND VGND VPWR VPWR sky130_fd_sc_hd__decap_3
XFILLER_34_206 VGND VGND VPWR VPWR sky130_fd_sc_hd__decap_3
XFILLER_47_567 VGND VGND VPWR VPWR sky130_fd_sc_hd__fill_2
XFILLER_62_526 VGND VGND VPWR VPWR sky130_fd_sc_hd__decap_3
XFILLER_74_386 VGND VGND VPWR VPWR sky130_fd_sc_hd__decap_3
XFILLER_15_464 VGND VGND VPWR VPWR sky130_fd_sc_hd__decap_3
XFILLER_30_401 VGND VGND VPWR VPWR sky130_fd_sc_hd__fill_2
XFILLER_42_261 VGND VGND VPWR VPWR sky130_fd_sc_hd__decap_3
XFILLER_70_592 VGND VGND VPWR VPWR sky130_fd_sc_hd__decap_3
XFILLER_8_12 VGND VGND VPWR VPWR sky130_fd_sc_hd__decap_3
XFILLER_8_56 VGND VGND VPWR VPWR sky130_fd_sc_hd__decap_3
XFILLER_7_641 VGND VGND VPWR VPWR sky130_fd_sc_hd__decap_3
XFILLER_116_506 VGND VGND VPWR VPWR sky130_fd_sc_hd__fill_1
XFILLER_116_528 VGND VGND VPWR VPWR sky130_fd_sc_hd__fill_1
XFILLER_6_162 VGND VGND VPWR VPWR sky130_fd_sc_hd__decap_3
XFILLER_7_685 VGND VGND VPWR VPWR sky130_fd_sc_hd__decap_3
XFILLER_112_701 VGND VGND VPWR VPWR sky130_fd_sc_hd__decap_3
XFILLER_111_211 VGND VGND VPWR VPWR sky130_fd_sc_hd__decap_3
XFILLER_88_91 VGND VGND VPWR VPWR sky130_fd_sc_hd__decap_3
Xload_slew511 fanout510/X VGND VGND VPWR VPWR load_slew511/X sky130_fd_sc_hd__clkbuf_4
X_6090_ _6090_/A VGND VGND VPWR VPWR _8110_/D sky130_fd_sc_hd__buf_1
X_5110_ _4841_/X _5110_/A1 _5116_/S VGND VGND VPWR VPWR _5111_/A sky130_fd_sc_hd__mux2_2
XFILLER_111_255 VGND VGND VPWR VPWR sky130_fd_sc_hd__decap_3
XFILLER_112_778 VGND VGND VPWR VPWR sky130_fd_sc_hd__fill_2
Xload_slew533 fanout532/X VGND VGND VPWR VPWR load_slew533/X sky130_fd_sc_hd__clkbuf_4
X_5041_ _4703_/X hold952/X _5053_/S VGND VGND VPWR VPWR _5042_/A sky130_fd_sc_hd__mux2_2
XFILLER_38_512 VGND VGND VPWR VPWR sky130_fd_sc_hd__decap_3
XFILLER_78_681 VGND VGND VPWR VPWR sky130_fd_sc_hd__decap_3
XFILLER_65_331 VGND VGND VPWR VPWR sky130_fd_sc_hd__decap_3
XFILLER_38_578 VGND VGND VPWR VPWR sky130_fd_sc_hd__decap_3
XFILLER_38_589 VGND VGND VPWR VPWR sky130_fd_sc_hd__decap_3
XFILLER_93_673 VGND VGND VPWR VPWR sky130_fd_sc_hd__fill_2
X_8800_ _8800_/CLK _8800_/D load_slew593/X VGND VGND VPWR VPWR _8800_/Q sky130_fd_sc_hd__dfrtp_2
XFILLER_19_781 VGND VGND VPWR VPWR sky130_fd_sc_hd__decap_3
X_8731_ _8731_/CLK _8731_/D fanout497/X VGND VGND VPWR VPWR _8731_/Q sky130_fd_sc_hd__dfrtp_2
X_6992_ _4921_/X _8534_/Q _7000_/S VGND VGND VPWR VPWR _6993_/A sky130_fd_sc_hd__mux2_4
XFILLER_53_559 VGND VGND VPWR VPWR sky130_fd_sc_hd__fill_1
X_5943_ _5944_/A1 _5944_/A2 _4887_/X _5944_/B1 hold817/X VGND VGND VPWR VPWR _8030_/D
+ sky130_fd_sc_hd__a32o_2
XFILLER_33_261 VGND VGND VPWR VPWR sky130_fd_sc_hd__fill_2
XTAP_TAPCELL_ROW_101_1708 VGND VPWR sky130_fd_sc_hd__tapvpwrvgnd_1
X_8662_ _8662_/CLK _8662_/D fanout620/X VGND VGND VPWR VPWR _8662_/Q sky130_fd_sc_hd__dfrtp_2
X_5874_ _5868_/X _5879_/A2 _5003_/X _5879_/B1 hold917/X VGND VGND VPWR VPWR _7976_/D
+ sky130_fd_sc_hd__a32o_2
X_8593_ _8593_/CLK _8593_/D fanout709/X VGND VGND VPWR VPWR _8593_/Q sky130_fd_sc_hd__dfrtp_2
X_7613_ _8758_/CLK _7613_/D load_slew710/X VGND VGND VPWR VPWR _7613_/Q sky130_fd_sc_hd__dfrtp_2
X_4825_ _7497_/S VGND VGND VPWR VPWR _4862_/S sky130_fd_sc_hd__buf_2
XFILLER_21_489 VGND VGND VPWR VPWR sky130_fd_sc_hd__fill_2
X_7544_ _8769_/CLK _7544_/D wire552/X VGND VGND VPWR VPWR _7544_/Q sky130_fd_sc_hd__dfrtp_2
X_4756_ _4756_/A _4776_/B VGND VGND VPWR VPWR _4757_/A sky130_fd_sc_hd__and2_2
XFILLER_107_517 VGND VGND VPWR VPWR sky130_fd_sc_hd__decap_3
XFILLER_119_366 VGND VGND VPWR VPWR sky130_fd_sc_hd__decap_3
X_3707_ _4543_/A _3707_/B _3727_/B VGND VGND VPWR VPWR _5962_/B sky130_fd_sc_hd__and3_2
X_7475_ _7475_/A VGND VGND VPWR VPWR _8793_/D sky130_fd_sc_hd__buf_1
X_4687_ _8051_/Q _7282_/B VGND VGND VPWR VPWR _6658_/C sky130_fd_sc_hd__or2_2
XFILLER_107_539 VGND VGND VPWR VPWR sky130_fd_sc_hd__decap_3
XFILLER_108_35 VGND VGND VPWR VPWR sky130_fd_sc_hd__fill_2
XFILLER_134_347 VGND VGND VPWR VPWR sky130_fd_sc_hd__decap_3
X_6426_ _4824_/X _8268_/Q _6440_/S VGND VGND VPWR VPWR _6427_/A sky130_fd_sc_hd__mux2_2
XTAP_TAPCELL_ROW_8_405 VGND VPWR sky130_fd_sc_hd__tapvpwrvgnd_1
X_6357_ _6357_/A VGND VGND VPWR VPWR _8235_/D sky130_fd_sc_hd__buf_2
XFILLER_0_305 VGND VGND VPWR VPWR sky130_fd_sc_hd__decap_3
XFILLER_102_200 VGND VGND VPWR VPWR sky130_fd_sc_hd__decap_3
XFILLER_103_723 VGND VGND VPWR VPWR sky130_fd_sc_hd__decap_3
XFILLER_115_594 VGND VGND VPWR VPWR sky130_fd_sc_hd__decap_3
XTAP_TAPCELL_ROW_112_1859 VGND VPWR sky130_fd_sc_hd__tapvpwrvgnd_1
X_5308_ _7707_/Q _4891_/X _5310_/S VGND VGND VPWR VPWR _5309_/A sky130_fd_sc_hd__mux2_2
XFILLER_124_12 VGND VGND VPWR VPWR sky130_fd_sc_hd__decap_3
XFILLER_130_531 VGND VGND VPWR VPWR sky130_fd_sc_hd__fill_1
XFILLER_130_542 VGND VGND VPWR VPWR sky130_fd_sc_hd__decap_3
XFILLER_88_467 VGND VGND VPWR VPWR sky130_fd_sc_hd__decap_3
X_6288_ _6288_/A VGND VGND VPWR VPWR _8203_/D sky130_fd_sc_hd__buf_6
XFILLER_130_575 VGND VGND VPWR VPWR sky130_fd_sc_hd__decap_3
XFILLER_48_309 VGND VGND VPWR VPWR sky130_fd_sc_hd__decap_3
XTAP_TAPCELL_ROW_71_1280 VGND VPWR sky130_fd_sc_hd__tapvpwrvgnd_1
XTAP_TAPCELL_ROW_71_1291 VGND VPWR sky130_fd_sc_hd__tapvpwrvgnd_1
X_8027_ _8029_/CLK _8027_/D load_slew572/X VGND VGND VPWR VPWR _8027_/Q sky130_fd_sc_hd__dfrtp_2
X_5239_ _7674_/Q _4753_/X _5247_/S VGND VGND VPWR VPWR _5240_/A sky130_fd_sc_hd__mux2_2
XFILLER_124_78 VGND VGND VPWR VPWR sky130_fd_sc_hd__decap_3
XFILLER_75_139 VGND VGND VPWR VPWR sky130_fd_sc_hd__decap_3
XFILLER_17_21 VGND VGND VPWR VPWR sky130_fd_sc_hd__decap_3
XFILLER_17_729 VGND VGND VPWR VPWR sky130_fd_sc_hd__decap_3
XFILLER_72_802 VGND VGND VPWR VPWR sky130_fd_sc_hd__fill_2
XFILLER_84_662 VGND VGND VPWR VPWR sky130_fd_sc_hd__decap_3
XFILLER_17_54 VGND VGND VPWR VPWR sky130_fd_sc_hd__fill_2
XFILLER_83_161 VGND VGND VPWR VPWR sky130_fd_sc_hd__decap_3
XFILLER_83_183 VGND VGND VPWR VPWR sky130_fd_sc_hd__decap_3
XFILLER_12_401 VGND VGND VPWR VPWR sky130_fd_sc_hd__decap_3
XFILLER_71_389 VGND VGND VPWR VPWR sky130_fd_sc_hd__decap_3
XFILLER_40_732 VGND VGND VPWR VPWR sky130_fd_sc_hd__decap_3
XFILLER_129_108 VGND VGND VPWR VPWR sky130_fd_sc_hd__decap_3
XFILLER_129_119 VGND VGND VPWR VPWR sky130_fd_sc_hd__decap_3
XFILLER_33_75 VGND VGND VPWR VPWR sky130_fd_sc_hd__decap_3
XFILLER_8_416 VGND VGND VPWR VPWR sky130_fd_sc_hd__decap_3
XPHY_EDGE_ROW_49_Left_185 VGND VGND VPWR VPWR sky130_fd_sc_hd__decap_3
XFILLER_4_622 VGND VGND VPWR VPWR sky130_fd_sc_hd__decap_3
XFILLER_4_666 VGND VGND VPWR VPWR sky130_fd_sc_hd__decap_3
XFILLER_106_572 VGND VGND VPWR VPWR sky130_fd_sc_hd__decap_3
XFILLER_4_699 VGND VGND VPWR VPWR sky130_fd_sc_hd__fill_1
XFILLER_79_423 VGND VGND VPWR VPWR sky130_fd_sc_hd__decap_3
XFILLER_121_531 VGND VGND VPWR VPWR sky130_fd_sc_hd__decap_3
XFILLER_133_391 VGND VGND VPWR VPWR sky130_fd_sc_hd__fill_1
XFILLER_121_564 VGND VGND VPWR VPWR sky130_fd_sc_hd__decap_3
XFILLER_58_83 VGND VGND VPWR VPWR sky130_fd_sc_hd__fill_1
XFILLER_66_117 VGND VGND VPWR VPWR sky130_fd_sc_hd__decap_3
XPHY_EDGE_ROW_58_Left_194 VGND VGND VPWR VPWR sky130_fd_sc_hd__decap_3
XTAP_TAPCELL_ROW_89_1541 VGND VPWR sky130_fd_sc_hd__tapvpwrvgnd_1
XFILLER_47_364 VGND VGND VPWR VPWR sky130_fd_sc_hd__fill_1
XFILLER_90_610 VGND VGND VPWR VPWR sky130_fd_sc_hd__fill_1
XFILLER_90_632 VGND VGND VPWR VPWR sky130_fd_sc_hd__decap_3
XFILLER_90_643 VGND VGND VPWR VPWR sky130_fd_sc_hd__fill_1
XFILLER_90_654 VGND VGND VPWR VPWR sky130_fd_sc_hd__decap_3
XFILLER_90_676 VGND VGND VPWR VPWR sky130_fd_sc_hd__decap_3
XFILLER_22_209 VGND VGND VPWR VPWR sky130_fd_sc_hd__fill_1
XFILLER_50_529 VGND VGND VPWR VPWR sky130_fd_sc_hd__decap_3
XFILLER_30_231 VGND VGND VPWR VPWR sky130_fd_sc_hd__decap_3
XTAP_TAPCELL_ROW_33_749 VGND VPWR sky130_fd_sc_hd__tapvpwrvgnd_1
XFILLER_129_620 VGND VGND VPWR VPWR sky130_fd_sc_hd__decap_3
X_4610_ _8452_/Q _8533_/Q _4630_/S VGND VGND VPWR VPWR _4610_/X sky130_fd_sc_hd__mux2_2
XFILLER_128_130 VGND VGND VPWR VPWR sky130_fd_sc_hd__decap_3
XFILLER_129_653 VGND VGND VPWR VPWR sky130_fd_sc_hd__decap_3
XTAP_TAPCELL_ROW_13_473 VGND VPWR sky130_fd_sc_hd__tapvpwrvgnd_1
X_5590_ _5590_/A VGND VGND VPWR VPWR _7839_/D sky130_fd_sc_hd__buf_1
XFILLER_128_141 VGND VGND VPWR VPWR sky130_fd_sc_hd__decap_3
XFILLER_7_460 VGND VGND VPWR VPWR sky130_fd_sc_hd__decap_3
X_4541_ _3820_/X _4540_/X _3707_/B VGND VGND VPWR VPWR _4541_/X sky130_fd_sc_hd__o21a_2
XFILLER_128_174 VGND VGND VPWR VPWR sky130_fd_sc_hd__decap_3
XFILLER_129_697 VGND VGND VPWR VPWR sky130_fd_sc_hd__decap_3
XFILLER_7_493 VGND VGND VPWR VPWR sky130_fd_sc_hd__fill_2
X_7260_ _7254_/X _4866_/X _7266_/A3 _7266_/B1 hold786/X VGND VGND VPWR VPWR _8683_/D
+ sky130_fd_sc_hd__a32o_2
X_4472_ _8601_/Q _3744_/X _4471_/X _4496_/A1 _4460_/A VGND VGND VPWR VPWR _4472_/X
+ sky130_fd_sc_hd__o221a_2
Xmax_cap168 _4904_/S VGND VGND VPWR VPWR _4896_/S sky130_fd_sc_hd__buf_6
X_7191_ _7269_/A VGND VGND VPWR VPWR _7191_/X sky130_fd_sc_hd__clkbuf_1
X_6211_ _6211_/A VGND VGND VPWR VPWR _8166_/D sky130_fd_sc_hd__buf_6
Xmax_cap179 _5948_/X VGND VGND VPWR VPWR _5958_/B1 sky130_fd_sc_hd__clkbuf_2
X_6142_ _8049_/Q _6314_/C _7004_/D _6314_/A VGND VGND VPWR VPWR _6143_/A sky130_fd_sc_hd__or4b_4
XFILLER_97_220 VGND VGND VPWR VPWR sky130_fd_sc_hd__decap_3
XFILLER_100_704 VGND VGND VPWR VPWR sky130_fd_sc_hd__decap_3
XFILLER_97_253 VGND VGND VPWR VPWR sky130_fd_sc_hd__decap_3
Xload_slew374 _3888_/A VGND VGND VPWR VPWR _3835_/S1 sky130_fd_sc_hd__buf_2
Xload_slew341 _4141_/A VGND VGND VPWR VPWR _4227_/A sky130_fd_sc_hd__clkbuf_4
X_6073_ _6073_/A VGND VGND VPWR VPWR _8102_/D sky130_fd_sc_hd__buf_1
Xload_slew396 _4088_/S0 VGND VGND VPWR VPWR _4124_/S sky130_fd_sc_hd__clkbuf_4
X_5024_ _5023_/X hold977/X _5028_/S VGND VGND VPWR VPWR _5025_/A sky130_fd_sc_hd__mux2_2
XFILLER_38_353 VGND VGND VPWR VPWR sky130_fd_sc_hd__fill_1
XFILLER_66_651 VGND VGND VPWR VPWR sky130_fd_sc_hd__decap_3
XTAP_TAPCELL_ROW_127_2066 VGND VPWR sky130_fd_sc_hd__tapvpwrvgnd_1
XTAP_TAPCELL_ROW_127_2077 VGND VPWR sky130_fd_sc_hd__tapvpwrvgnd_1
XFILLER_66_684 VGND VGND VPWR VPWR sky130_fd_sc_hd__decap_3
X_6975_ _4887_/X _8526_/Q _6979_/S VGND VGND VPWR VPWR _6976_/A sky130_fd_sc_hd__mux2_4
XFILLER_53_367 VGND VGND VPWR VPWR sky130_fd_sc_hd__decap_3
XFILLER_53_389 VGND VGND VPWR VPWR sky130_fd_sc_hd__decap_3
X_8714_ _8801_/CLK _8714_/D fanout607/A VGND VGND VPWR VPWR _8714_/Q sky130_fd_sc_hd__dfrtp_2
X_5926_ _5931_/A1 _5932_/A2 _7248_/A2 _5932_/B1 hold829/X VGND VGND VPWR VPWR _8016_/D
+ sky130_fd_sc_hd__a32o_2
XFILLER_110_47 VGND VGND VPWR VPWR sky130_fd_sc_hd__decap_3
XFILLER_34_592 VGND VGND VPWR VPWR sky130_fd_sc_hd__fill_1
X_8645_ _8645_/CLK _8645_/D fanout502/X VGND VGND VPWR VPWR _8645_/Q sky130_fd_sc_hd__dfrtp_2
XFILLER_21_231 VGND VGND VPWR VPWR sky130_fd_sc_hd__decap_3
XFILLER_70_29 VGND VGND VPWR VPWR sky130_fd_sc_hd__decap_3
X_5857_ _5948_/A VGND VGND VPWR VPWR _5857_/X sky130_fd_sc_hd__clkbuf_1
X_8576_ _8657_/CLK _8576_/D fanout512/X VGND VGND VPWR VPWR _8576_/Q sky130_fd_sc_hd__dfrtp_2
X_5788_ _5788_/A VGND VGND VPWR VPWR _7932_/D sky130_fd_sc_hd__buf_1
X_4808_ _4807_/X _4808_/A1 _4820_/S VGND VGND VPWR VPWR _4809_/A sky130_fd_sc_hd__mux2_2
XFILLER_119_12 VGND VGND VPWR VPWR sky130_fd_sc_hd__decap_3
XFILLER_119_45 VGND VGND VPWR VPWR sky130_fd_sc_hd__decap_3
X_7527_ _8753_/CLK _7527_/D load_slew642/X VGND VGND VPWR VPWR _7527_/Q sky130_fd_sc_hd__dfrtp_2
X_4739_ _4739_/A _4776_/B VGND VGND VPWR VPWR _4740_/A sky130_fd_sc_hd__and2_2
XFILLER_134_100 VGND VGND VPWR VPWR sky130_fd_sc_hd__decap_3
XFILLER_135_634 VGND VGND VPWR VPWR sky130_fd_sc_hd__decap_3
XFILLER_135_645 VGND VGND VPWR VPWR sky130_fd_sc_hd__decap_3
X_7458_ _4957_/X hold963/X _7474_/S VGND VGND VPWR VPWR _7459_/A sky130_fd_sc_hd__mux2_2
XFILLER_134_133 VGND VGND VPWR VPWR sky130_fd_sc_hd__decap_3
XFILLER_134_144 VGND VGND VPWR VPWR sky130_fd_sc_hd__decap_3
X_6409_ _4791_/X hold941/X _6419_/S VGND VGND VPWR VPWR _6410_/A sky130_fd_sc_hd__mux2_1
XFILLER_134_177 VGND VGND VPWR VPWR sky130_fd_sc_hd__decap_3
XFILLER_89_732 VGND VGND VPWR VPWR sky130_fd_sc_hd__decap_3
XTAP_TAPCELL_ROW_73_1320 VGND VPWR sky130_fd_sc_hd__tapvpwrvgnd_1
Xhold950 _8255_/Q VGND VGND VPWR VPWR hold950/X sky130_fd_sc_hd__dlygate4sd3_1
Xhold961 _7573_/Q VGND VGND VPWR VPWR hold961/X sky130_fd_sc_hd__dlygate4sd3_1
Xhold972 _7505_/Q VGND VGND VPWR VPWR hold972/X sky130_fd_sc_hd__dlygate4sd3_1
X_7389_ _8752_/Q _4814_/A _7407_/S VGND VGND VPWR VPWR _7390_/A sky130_fd_sc_hd__mux2_2
XFILLER_0_113 VGND VGND VPWR VPWR sky130_fd_sc_hd__decap_3
XFILLER_103_520 VGND VGND VPWR VPWR sky130_fd_sc_hd__decap_3
XFILLER_103_553 VGND VGND VPWR VPWR sky130_fd_sc_hd__decap_3
XFILLER_135_44 VGND VGND VPWR VPWR sky130_fd_sc_hd__decap_3
XFILLER_1_647 VGND VGND VPWR VPWR sky130_fd_sc_hd__decap_3
XFILLER_88_242 VGND VGND VPWR VPWR sky130_fd_sc_hd__decap_3
Xhold983 _7669_/Q VGND VGND VPWR VPWR hold983/X sky130_fd_sc_hd__dlygate4sd3_1
Xhold994 _7947_/Q VGND VGND VPWR VPWR hold994/X sky130_fd_sc_hd__dlygate4sd3_1
XFILLER_135_66 VGND VGND VPWR VPWR sky130_fd_sc_hd__decap_3
XFILLER_135_88 VGND VGND VPWR VPWR sky130_fd_sc_hd__decap_3
XFILLER_48_106 VGND VGND VPWR VPWR sky130_fd_sc_hd__decap_3
XFILLER_48_117 VGND VGND VPWR VPWR sky130_fd_sc_hd__decap_3
XFILLER_88_253 VGND VGND VPWR VPWR sky130_fd_sc_hd__decap_3
XFILLER_130_394 VGND VGND VPWR VPWR sky130_fd_sc_hd__decap_3
XFILLER_28_53 VGND VGND VPWR VPWR sky130_fd_sc_hd__fill_1
XFILLER_28_75 VGND VGND VPWR VPWR sky130_fd_sc_hd__decap_3
XFILLER_29_331 VGND VGND VPWR VPWR sky130_fd_sc_hd__decap_3
XFILLER_29_342 VGND VGND VPWR VPWR sky130_fd_sc_hd__decap_3
XFILLER_57_662 VGND VGND VPWR VPWR sky130_fd_sc_hd__decap_3
XFILLER_57_673 VGND VGND VPWR VPWR sky130_fd_sc_hd__decap_3
XFILLER_63_109 VGND VGND VPWR VPWR sky130_fd_sc_hd__decap_3
XFILLER_28_97 VGND VGND VPWR VPWR sky130_fd_sc_hd__fill_1
XFILLER_17_548 VGND VGND VPWR VPWR sky130_fd_sc_hd__decap_3
XFILLER_44_356 VGND VGND VPWR VPWR sky130_fd_sc_hd__decap_3
XFILLER_71_131 VGND VGND VPWR VPWR sky130_fd_sc_hd__decap_3
XFILLER_72_643 VGND VGND VPWR VPWR sky130_fd_sc_hd__fill_1
XFILLER_25_570 VGND VGND VPWR VPWR sky130_fd_sc_hd__decap_3
XFILLER_72_698 VGND VGND VPWR VPWR sky130_fd_sc_hd__fill_2
XTAP_TAPCELL_ROW_84_1471 VGND VPWR sky130_fd_sc_hd__tapvpwrvgnd_1
XFILLER_13_732 VGND VGND VPWR VPWR sky130_fd_sc_hd__decap_3
XFILLER_44_85 VGND VGND VPWR VPWR sky130_fd_sc_hd__decap_3
XFILLER_71_197 VGND VGND VPWR VPWR sky130_fd_sc_hd__decap_3
XFILLER_12_253 VGND VGND VPWR VPWR sky130_fd_sc_hd__fill_1
XFILLER_13_765 VGND VGND VPWR VPWR sky130_fd_sc_hd__decap_3
XFILLER_40_562 VGND VGND VPWR VPWR sky130_fd_sc_hd__fill_2
XFILLER_9_703 VGND VGND VPWR VPWR sky130_fd_sc_hd__decap_3
XTAP_TAPCELL_ROW_30_708 VGND VPWR sky130_fd_sc_hd__tapvpwrvgnd_1
XTAP_TAPCELL_ROW_30_719 VGND VPWR sky130_fd_sc_hd__tapvpwrvgnd_1
XFILLER_100_91 VGND VGND VPWR VPWR sky130_fd_sc_hd__decap_3
XFILLER_60_40 VGND VGND VPWR VPWR sky130_fd_sc_hd__decap_3
XFILLER_9_747 VGND VGND VPWR VPWR sky130_fd_sc_hd__decap_3
XFILLER_126_601 VGND VGND VPWR VPWR sky130_fd_sc_hd__decap_3
XFILLER_8_268 VGND VGND VPWR VPWR sky130_fd_sc_hd__decap_3
XTAP_TAPCELL_ROW_10_432 VGND VPWR sky130_fd_sc_hd__tapvpwrvgnd_1
XFILLER_126_645 VGND VGND VPWR VPWR sky130_fd_sc_hd__decap_3
XFILLER_5_24 VGND VGND VPWR VPWR sky130_fd_sc_hd__decap_3
XFILLER_125_166 VGND VGND VPWR VPWR sky130_fd_sc_hd__fill_2
XFILLER_126_689 VGND VGND VPWR VPWR sky130_fd_sc_hd__decap_3
XFILLER_4_463 VGND VGND VPWR VPWR sky130_fd_sc_hd__decap_3
XFILLER_5_57 VGND VGND VPWR VPWR sky130_fd_sc_hd__decap_3
XFILLER_106_391 VGND VGND VPWR VPWR sky130_fd_sc_hd__decap_3
XFILLER_79_231 VGND VGND VPWR VPWR sky130_fd_sc_hd__decap_3
XFILLER_95_713 VGND VGND VPWR VPWR sky130_fd_sc_hd__fill_2
XPHY_EDGE_ROW_66_Left_202 VGND VGND VPWR VPWR sky130_fd_sc_hd__decap_3
XFILLER_0_691 VGND VGND VPWR VPWR sky130_fd_sc_hd__decap_3
XFILLER_121_383 VGND VGND VPWR VPWR sky130_fd_sc_hd__decap_3
XFILLER_39_139 VGND VGND VPWR VPWR sky130_fd_sc_hd__decap_3
XFILLER_94_212 VGND VGND VPWR VPWR sky130_fd_sc_hd__decap_3
XFILLER_95_735 VGND VGND VPWR VPWR sky130_fd_sc_hd__decap_3
XFILLER_36_802 VGND VGND VPWR VPWR sky130_fd_sc_hd__fill_2
XFILLER_95_779 VGND VGND VPWR VPWR sky130_fd_sc_hd__decap_3
XTAP_TAPCELL_ROW_38_819 VGND VPWR sky130_fd_sc_hd__tapvpwrvgnd_1
XFILLER_75_481 VGND VGND VPWR VPWR sky130_fd_sc_hd__decap_3
XFILLER_85_81 VGND VGND VPWR VPWR sky130_fd_sc_hd__fill_2
XFILLER_35_334 VGND VGND VPWR VPWR sky130_fd_sc_hd__fill_2
XTAP_TAPCELL_ROW_18_543 VGND VPWR sky130_fd_sc_hd__tapvpwrvgnd_1
XFILLER_50_315 VGND VGND VPWR VPWR sky130_fd_sc_hd__decap_3
XFILLER_90_462 VGND VGND VPWR VPWR sky130_fd_sc_hd__fill_1
X_6760_ _6760_/A VGND VGND VPWR VPWR _8424_/D sky130_fd_sc_hd__buf_2
XFILLER_16_592 VGND VGND VPWR VPWR sky130_fd_sc_hd__decap_3
XFILLER_62_186 VGND VGND VPWR VPWR sky130_fd_sc_hd__fill_1
XFILLER_62_197 VGND VGND VPWR VPWR sky130_fd_sc_hd__decap_3
XFILLER_90_495 VGND VGND VPWR VPWR sky130_fd_sc_hd__decap_3
XPHY_EDGE_ROW_75_Left_211 VGND VGND VPWR VPWR sky130_fd_sc_hd__decap_3
X_3972_ _7655_/Q _3969_/X _3971_/X VGND VGND VPWR VPWR _3972_/X sky130_fd_sc_hd__o21a_2
X_5711_ _7896_/Q _5007_/A _5721_/S VGND VGND VPWR VPWR _5712_/A sky130_fd_sc_hd__mux2_2
X_6691_ _6691_/A VGND VGND VPWR VPWR _8391_/D sky130_fd_sc_hd__buf_2
XFILLER_31_573 VGND VGND VPWR VPWR sky130_fd_sc_hd__decap_3
X_8430_ _8678_/CLK _8430_/D fanout690/X VGND VGND VPWR VPWR _8430_/Q sky130_fd_sc_hd__dfrtp_2
X_5642_ _7864_/Q _4871_/A _5654_/S VGND VGND VPWR VPWR _5643_/A sky130_fd_sc_hd__mux2_2
XFILLER_117_601 VGND VGND VPWR VPWR sky130_fd_sc_hd__decap_3
XFILLER_129_461 VGND VGND VPWR VPWR sky130_fd_sc_hd__decap_3
X_8361_ _8685_/CLK _8361_/D wire574/X VGND VGND VPWR VPWR _8361_/Q sky130_fd_sc_hd__dfrtp_2
X_5573_ _7831_/Q _4731_/A _5591_/S VGND VGND VPWR VPWR _5574_/A sky130_fd_sc_hd__mux2_2
XFILLER_116_111 VGND VGND VPWR VPWR sky130_fd_sc_hd__decap_3
XFILLER_117_623 VGND VGND VPWR VPWR sky130_fd_sc_hd__decap_3
XFILLER_129_494 VGND VGND VPWR VPWR sky130_fd_sc_hd__decap_3
X_7312_ _7312_/A VGND VGND VPWR VPWR _8715_/D sky130_fd_sc_hd__buf_1
X_4524_ _8768_/Q _7543_/Q _7624_/Q _7705_/Q _4524_/S0 _4524_/S1 VGND VGND VPWR VPWR
+ _4524_/X sky130_fd_sc_hd__mux4_2
XFILLER_116_144 VGND VGND VPWR VPWR sky130_fd_sc_hd__fill_2
XFILLER_116_155 VGND VGND VPWR VPWR sky130_fd_sc_hd__decap_3
XFILLER_132_604 VGND VGND VPWR VPWR sky130_fd_sc_hd__decap_3
X_8292_ _8695_/CLK _8292_/D load_slew733/X VGND VGND VPWR VPWR _8292_/Q sky130_fd_sc_hd__dfrtp_2
XFILLER_104_306 VGND VGND VPWR VPWR sky130_fd_sc_hd__fill_2
XFILLER_104_317 VGND VGND VPWR VPWR sky130_fd_sc_hd__decap_3
XFILLER_132_637 VGND VGND VPWR VPWR sky130_fd_sc_hd__decap_3
X_7243_ _7269_/A VGND VGND VPWR VPWR _7243_/X sky130_fd_sc_hd__clkbuf_1
X_4455_ _4455_/A _4455_/B VGND VGND VPWR VPWR _4455_/X sky130_fd_sc_hd__or2_2
XFILLER_131_125 VGND VGND VPWR VPWR sky130_fd_sc_hd__decap_3
XFILLER_132_648 VGND VGND VPWR VPWR sky130_fd_sc_hd__decap_3
XPHY_EDGE_ROW_84_Left_220 VGND VGND VPWR VPWR sky130_fd_sc_hd__decap_3
XTAP_TAPCELL_ROW_55_1061 VGND VPWR sky130_fd_sc_hd__tapvpwrvgnd_1
Xfanout715 fanout716/X VGND VGND VPWR VPWR fanout715/X sky130_fd_sc_hd__clkdlybuf4s25_1
X_7174_ _4941_/X _8620_/Q _7174_/S VGND VGND VPWR VPWR _7175_/A sky130_fd_sc_hd__mux2_2
X_4386_ _4442_/A _4386_/B VGND VGND VPWR VPWR _4386_/X sky130_fd_sc_hd__or2_2
XFILLER_112_350 VGND VGND VPWR VPWR sky130_fd_sc_hd__decap_3
XFILLER_131_158 VGND VGND VPWR VPWR sky130_fd_sc_hd__decap_3
XFILLER_131_169 VGND VGND VPWR VPWR sky130_fd_sc_hd__decap_3
Xfanout726 fanout734/X VGND VGND VPWR VPWR fanout726/X sky130_fd_sc_hd__clkdlybuf4s25_1
Xfanout737 fanout739/X VGND VGND VPWR VPWR fanout737/X sky130_fd_sc_hd__clkdlybuf4s25_1
X_6125_ _8127_/Q _4912_/A _6137_/S VGND VGND VPWR VPWR _6126_/A sky130_fd_sc_hd__mux2_2
XFILLER_112_383 VGND VGND VPWR VPWR sky130_fd_sc_hd__decap_3
XFILLER_58_448 VGND VGND VPWR VPWR sky130_fd_sc_hd__decap_3
XFILLER_86_757 VGND VGND VPWR VPWR sky130_fd_sc_hd__decap_3
XFILLER_65_29 VGND VGND VPWR VPWR sky130_fd_sc_hd__decap_3
X_6056_ _6056_/A0 _4772_/A _6074_/S VGND VGND VPWR VPWR _6057_/A sky130_fd_sc_hd__mux2_2
XFILLER_26_301 VGND VGND VPWR VPWR sky130_fd_sc_hd__decap_3
XFILLER_26_312 VGND VGND VPWR VPWR sky130_fd_sc_hd__decap_3
XFILLER_66_470 VGND VGND VPWR VPWR sky130_fd_sc_hd__decap_3
XFILLER_73_418 VGND VGND VPWR VPWR sky130_fd_sc_hd__decap_3
XFILLER_85_278 VGND VGND VPWR VPWR sky130_fd_sc_hd__fill_2
X_5007_ _5007_/A VGND VGND VPWR VPWR _5007_/X sky130_fd_sc_hd__buf_1
XFILLER_54_654 VGND VGND VPWR VPWR sky130_fd_sc_hd__decap_3
XFILLER_121_57 VGND VGND VPWR VPWR sky130_fd_sc_hd__decap_3
XFILLER_14_529 VGND VGND VPWR VPWR sky130_fd_sc_hd__decap_3
XFILLER_53_164 VGND VGND VPWR VPWR sky130_fd_sc_hd__decap_3
XFILLER_53_175 VGND VGND VPWR VPWR sky130_fd_sc_hd__decap_3
X_6958_ _4853_/X _8518_/Q _6958_/S VGND VGND VPWR VPWR _6959_/A sky130_fd_sc_hd__mux2_4
XFILLER_14_44 VGND VGND VPWR VPWR sky130_fd_sc_hd__decap_3
XTAP_TAPCELL_ROW_120_1969 VGND VPWR sky130_fd_sc_hd__tapvpwrvgnd_1
X_6889_ _4715_/X _8485_/Q _6895_/S VGND VGND VPWR VPWR _6890_/A sky130_fd_sc_hd__mux2_4
X_5909_ _5948_/A VGND VGND VPWR VPWR _5909_/X sky130_fd_sc_hd__clkbuf_1
XFILLER_10_713 VGND VGND VPWR VPWR sky130_fd_sc_hd__decap_3
XFILLER_14_77 VGND VGND VPWR VPWR sky130_fd_sc_hd__decap_3
XFILLER_22_595 VGND VGND VPWR VPWR sky130_fd_sc_hd__fill_2
X_8628_ _8701_/CLK _8628_/D load_slew673/X VGND VGND VPWR VPWR _8628_/Q sky130_fd_sc_hd__dfrtp_2
XFILLER_10_746 VGND VGND VPWR VPWR sky130_fd_sc_hd__decap_3
XFILLER_10_757 VGND VGND VPWR VPWR sky130_fd_sc_hd__decap_3
XFILLER_14_88 VGND VGND VPWR VPWR sky130_fd_sc_hd__decap_3
X_8559_ _8802_/CLK _8559_/D fanout578/X VGND VGND VPWR VPWR _8559_/Q sky130_fd_sc_hd__dfrtp_2
XFILLER_30_32 VGND VGND VPWR VPWR sky130_fd_sc_hd__decap_3
XFILLER_6_728 VGND VGND VPWR VPWR sky130_fd_sc_hd__decap_3
XFILLER_107_144 VGND VGND VPWR VPWR sky130_fd_sc_hd__decap_3
XFILLER_100_3 VGND VGND VPWR VPWR sky130_fd_sc_hd__decap_3
XFILLER_107_166 VGND VGND VPWR VPWR sky130_fd_sc_hd__fill_2
XFILLER_123_626 VGND VGND VPWR VPWR sky130_fd_sc_hd__decap_3
XFILLER_135_475 VGND VGND VPWR VPWR sky130_fd_sc_hd__fill_1
XFILLER_135_486 VGND VGND VPWR VPWR sky130_fd_sc_hd__decap_3
XFILLER_122_147 VGND VGND VPWR VPWR sky130_fd_sc_hd__decap_3
Xhold780 _8692_/Q VGND VGND VPWR VPWR hold780/X sky130_fd_sc_hd__dlygate4sd3_1
Xhold791 _8675_/Q VGND VGND VPWR VPWR hold791/X sky130_fd_sc_hd__dlygate4sd3_1
XFILLER_110_309 VGND VGND VPWR VPWR sky130_fd_sc_hd__decap_3
XFILLER_39_41 VGND VGND VPWR VPWR sky130_fd_sc_hd__fill_2
XFILLER_77_713 VGND VGND VPWR VPWR sky130_fd_sc_hd__decap_3
XFILLER_89_573 VGND VGND VPWR VPWR sky130_fd_sc_hd__decap_3
XFILLER_103_383 VGND VGND VPWR VPWR sky130_fd_sc_hd__fill_1
XFILLER_130_180 VGND VGND VPWR VPWR sky130_fd_sc_hd__decap_3
XFILLER_76_212 VGND VGND VPWR VPWR sky130_fd_sc_hd__decap_3
XFILLER_77_735 VGND VGND VPWR VPWR sky130_fd_sc_hd__decap_3
XFILLER_77_757 VGND VGND VPWR VPWR sky130_fd_sc_hd__decap_3
XFILLER_49_459 VGND VGND VPWR VPWR sky130_fd_sc_hd__fill_2
XFILLER_76_256 VGND VGND VPWR VPWR sky130_fd_sc_hd__decap_3
XFILLER_77_779 VGND VGND VPWR VPWR sky130_fd_sc_hd__decap_3
XFILLER_29_172 VGND VGND VPWR VPWR sky130_fd_sc_hd__decap_3
XFILLER_76_289 VGND VGND VPWR VPWR sky130_fd_sc_hd__decap_3
XFILLER_92_749 VGND VGND VPWR VPWR sky130_fd_sc_hd__decap_3
XTAP_TAPCELL_ROW_86_1500 VGND VPWR sky130_fd_sc_hd__tapvpwrvgnd_1
XFILLER_45_632 VGND VGND VPWR VPWR sky130_fd_sc_hd__decap_3
XFILLER_55_51 VGND VGND VPWR VPWR sky130_fd_sc_hd__decap_3
XFILLER_91_259 VGND VGND VPWR VPWR sky130_fd_sc_hd__decap_3
XFILLER_17_378 VGND VGND VPWR VPWR sky130_fd_sc_hd__fill_1
XFILLER_45_676 VGND VGND VPWR VPWR sky130_fd_sc_hd__fill_1
XTAP_TAPCELL_ROW_15_502 VGND VPWR sky130_fd_sc_hd__tapvpwrvgnd_1
XFILLER_44_186 VGND VGND VPWR VPWR sky130_fd_sc_hd__decap_3
XFILLER_44_197 VGND VGND VPWR VPWR sky130_fd_sc_hd__decap_3
XFILLER_9_500 VGND VGND VPWR VPWR sky130_fd_sc_hd__decap_3
XFILLER_71_61 VGND VGND VPWR VPWR sky130_fd_sc_hd__fill_2
XFILLER_9_533 VGND VGND VPWR VPWR sky130_fd_sc_hd__decap_3
XTAP_TAPCELL_ROW_43_888 VGND VPWR sky130_fd_sc_hd__tapvpwrvgnd_1
XTAP_TAPCELL_ROW_43_899 VGND VPWR sky130_fd_sc_hd__tapvpwrvgnd_1
XFILLER_40_392 VGND VGND VPWR VPWR sky130_fd_sc_hd__decap_3
XTAP_TAPCELL_ROW_97_1651 VGND VPWR sky130_fd_sc_hd__tapvpwrvgnd_1
XFILLER_126_442 VGND VGND VPWR VPWR sky130_fd_sc_hd__decap_3
XFILLER_5_750 VGND VGND VPWR VPWR sky130_fd_sc_hd__decap_3
XFILLER_114_604 VGND VGND VPWR VPWR sky130_fd_sc_hd__fill_2
XFILLER_114_637 VGND VGND VPWR VPWR sky130_fd_sc_hd__decap_3
XFILLER_126_486 VGND VGND VPWR VPWR sky130_fd_sc_hd__decap_3
XFILLER_5_783 VGND VGND VPWR VPWR sky130_fd_sc_hd__fill_1
XFILLER_5_794 VGND VGND VPWR VPWR sky130_fd_sc_hd__decap_3
XFILLER_99_337 VGND VGND VPWR VPWR sky130_fd_sc_hd__decap_3
X_4240_ _4238_/X _4239_/X _4252_/A VGND VGND VPWR VPWR _4240_/X sky130_fd_sc_hd__mux2_2
XFILLER_113_169 VGND VGND VPWR VPWR sky130_fd_sc_hd__decap_3
X_4171_ _7998_/Q _4399_/A2 _3775_/X _7917_/Q _3733_/A VGND VGND VPWR VPWR _4171_/X
+ sky130_fd_sc_hd__o221a_2
XFILLER_67_223 VGND VGND VPWR VPWR sky130_fd_sc_hd__fill_1
XFILLER_68_757 VGND VGND VPWR VPWR sky130_fd_sc_hd__fill_1
XFILLER_83_716 VGND VGND VPWR VPWR sky130_fd_sc_hd__decap_3
XFILLER_95_576 VGND VGND VPWR VPWR sky130_fd_sc_hd__decap_3
XTAP_TAPCELL_ROW_124_2025 VGND VPWR sky130_fd_sc_hd__tapvpwrvgnd_1
X_7930_ _8750_/CLK _7930_/D fanout641/X VGND VGND VPWR VPWR _7930_/Q sky130_fd_sc_hd__dfrtp_2
X_7861_ _8029_/CLK _7861_/D fanout595/X VGND VGND VPWR VPWR _7861_/Q sky130_fd_sc_hd__dfrtp_2
XFILLER_35_142 VGND VGND VPWR VPWR sky130_fd_sc_hd__decap_3
XFILLER_36_687 VGND VGND VPWR VPWR sky130_fd_sc_hd__fill_1
X_6812_ _8449_/Q _4902_/A _6828_/S VGND VGND VPWR VPWR _6813_/A sky130_fd_sc_hd__mux2_2
XFILLER_50_112 VGND VGND VPWR VPWR sky130_fd_sc_hd__fill_1
XTAP_TAPCELL_ROW_106_1780 VGND VPWR sky130_fd_sc_hd__tapvpwrvgnd_1
X_7792_ _8693_/CLK _7792_/D fanout743/X VGND VGND VPWR VPWR _7792_/Q sky130_fd_sc_hd__dfrtp_2
XFILLER_50_134 VGND VGND VPWR VPWR sky130_fd_sc_hd__decap_3
X_3955_ _3955_/A VGND VGND VPWR VPWR _4165_/A sky130_fd_sc_hd__clkbuf_2
X_6743_ _6743_/A VGND VGND VPWR VPWR _8416_/D sky130_fd_sc_hd__buf_2
X_6674_ _6674_/A VGND VGND VPWR VPWR _8383_/D sky130_fd_sc_hd__buf_2
X_3886_ _3888_/A _3884_/X _3885_/X VGND VGND VPWR VPWR _3886_/X sky130_fd_sc_hd__o21a_2
X_8413_ _8737_/CLK _8413_/D load_slew511/X VGND VGND VPWR VPWR _8413_/Q sky130_fd_sc_hd__dfrtp_2
X_5625_ _7856_/Q _4837_/A _5633_/S VGND VGND VPWR VPWR _5626_/A sky130_fd_sc_hd__mux2_2
XFILLER_117_442 VGND VGND VPWR VPWR sky130_fd_sc_hd__decap_3
XFILLER_3_709 VGND VGND VPWR VPWR sky130_fd_sc_hd__decap_3
XTAP_TAPCELL_ROW_135_2176 VGND VPWR sky130_fd_sc_hd__tapvpwrvgnd_1
XTAP_TAPCELL_ROW_135_2187 VGND VPWR sky130_fd_sc_hd__tapvpwrvgnd_1
XTAP_TAPCELL_ROW_135_2198 VGND VPWR sky130_fd_sc_hd__tapvpwrvgnd_1
X_8344_ _8749_/CLK _8344_/D load_slew633/X VGND VGND VPWR VPWR _8344_/Q sky130_fd_sc_hd__dfrtp_2
X_5556_ _7823_/Q _4691_/A _5570_/S VGND VGND VPWR VPWR _5557_/A sky130_fd_sc_hd__mux2_2
XFILLER_105_626 VGND VGND VPWR VPWR sky130_fd_sc_hd__fill_2
XFILLER_132_412 VGND VGND VPWR VPWR sky130_fd_sc_hd__decap_3
X_8275_ _8518_/CLK _8275_/D load_slew704/X VGND VGND VPWR VPWR _8275_/Q sky130_fd_sc_hd__dfrtp_2
X_5487_ _7791_/Q _4902_/A _5503_/S VGND VGND VPWR VPWR _5488_/A sky130_fd_sc_hd__mux2_2
X_4507_ _8118_/Q _8199_/Q _8280_/Q _8361_/Q _4502_/S _4503_/A VGND VGND VPWR VPWR
+ _4508_/B sky130_fd_sc_hd__mux4_2
XFILLER_104_114 VGND VGND VPWR VPWR sky130_fd_sc_hd__fill_2
XFILLER_105_659 VGND VGND VPWR VPWR sky130_fd_sc_hd__decap_3
XFILLER_116_24 VGND VGND VPWR VPWR sky130_fd_sc_hd__decap_3
XFILLER_117_497 VGND VGND VPWR VPWR sky130_fd_sc_hd__decap_3
XFILLER_132_445 VGND VGND VPWR VPWR sky130_fd_sc_hd__decap_3
X_7226_ wire234/X _4761_/X wire175/X wire205/X hold853/X VGND VGND VPWR VPWR _8658_/D
+ sky130_fd_sc_hd__a32o_2
X_4438_ _8760_/Q _7535_/Q _4568_/S VGND VGND VPWR VPWR _4438_/X sky130_fd_sc_hd__mux2_2
XFILLER_120_618 VGND VGND VPWR VPWR sky130_fd_sc_hd__decap_3
XFILLER_132_489 VGND VGND VPWR VPWR sky130_fd_sc_hd__decap_3
Xfanout512 fanout516/X VGND VGND VPWR VPWR fanout512/X sky130_fd_sc_hd__clkdlybuf4s25_1
Xfanout523 fanout525/X VGND VGND VPWR VPWR fanout523/X sky130_fd_sc_hd__clkdlybuf4s25_1
Xfanout534 fanout543/X VGND VGND VPWR VPWR fanout534/X sky130_fd_sc_hd__clkdlybuf4s25_1
Xfanout556 fanout561/X VGND VGND VPWR VPWR fanout556/X sky130_fd_sc_hd__clkdlybuf4s25_1
X_7157_ _7157_/A VGND VGND VPWR VPWR _8611_/D sky130_fd_sc_hd__buf_2
X_4369_ _7691_/Q _3762_/A _3763_/A _7610_/Q _3925_/A VGND VGND VPWR VPWR _4369_/X
+ sky130_fd_sc_hd__o221a_2
XFILLER_46_407 VGND VGND VPWR VPWR sky130_fd_sc_hd__decap_3
Xfanout567 fanout577/X VGND VGND VPWR VPWR fanout567/X sky130_fd_sc_hd__clkdlybuf4s25_1
Xfanout578 fanout580/X VGND VGND VPWR VPWR fanout578/X sky130_fd_sc_hd__clkdlybuf4s25_1
X_7088_ _4769_/X hold949/X _7088_/S VGND VGND VPWR VPWR _7089_/A sky130_fd_sc_hd__mux2_1
X_6108_ _8119_/Q _4878_/A _6116_/S VGND VGND VPWR VPWR _6109_/A sky130_fd_sc_hd__mux2_2
XFILLER_132_12 VGND VGND VPWR VPWR sky130_fd_sc_hd__decap_3
XFILLER_39_470 VGND VGND VPWR VPWR sky130_fd_sc_hd__decap_3
XFILLER_46_418 VGND VGND VPWR VPWR sky130_fd_sc_hd__fill_2
XFILLER_74_727 VGND VGND VPWR VPWR sky130_fd_sc_hd__fill_1
XFILLER_74_738 VGND VGND VPWR VPWR sky130_fd_sc_hd__decap_3
XFILLER_86_598 VGND VGND VPWR VPWR sky130_fd_sc_hd__decap_3
X_6039_ _8086_/Q _4739_/A _6053_/S VGND VGND VPWR VPWR _6040_/A sky130_fd_sc_hd__mux2_2
XFILLER_132_56 VGND VGND VPWR VPWR sky130_fd_sc_hd__decap_3
XTAP_TAPCELL_ROW_68_1241 VGND VPWR sky130_fd_sc_hd__tapvpwrvgnd_1
XFILLER_25_21 VGND VGND VPWR VPWR sky130_fd_sc_hd__decap_3
XFILLER_27_676 VGND VGND VPWR VPWR sky130_fd_sc_hd__fill_1
XFILLER_42_613 VGND VGND VPWR VPWR sky130_fd_sc_hd__decap_3
XFILLER_14_315 VGND VGND VPWR VPWR sky130_fd_sc_hd__decap_3
XFILLER_25_54 VGND VGND VPWR VPWR sky130_fd_sc_hd__fill_2
XFILLER_26_175 VGND VGND VPWR VPWR sky130_fd_sc_hd__decap_3
XFILLER_26_197 VGND VGND VPWR VPWR sky130_fd_sc_hd__decap_3
XFILLER_14_348 VGND VGND VPWR VPWR sky130_fd_sc_hd__decap_3
XFILLER_25_87 VGND VGND VPWR VPWR sky130_fd_sc_hd__decap_3
XFILLER_41_145 VGND VGND VPWR VPWR sky130_fd_sc_hd__decap_3
XFILLER_42_657 VGND VGND VPWR VPWR sky130_fd_sc_hd__decap_3
XTAP_TAPCELL_ROW_81_1430 VGND VPWR sky130_fd_sc_hd__tapvpwrvgnd_1
XFILLER_128_707 VGND VGND VPWR VPWR sky130_fd_sc_hd__decap_3
XTAP_TAPCELL_ROW_40_847 VGND VPWR sky130_fd_sc_hd__tapvpwrvgnd_1
XTAP_TAPCELL_ROW_40_858 VGND VPWR sky130_fd_sc_hd__tapvpwrvgnd_1
XFILLER_10_576 VGND VGND VPWR VPWR sky130_fd_sc_hd__decap_3
XFILLER_127_228 VGND VGND VPWR VPWR sky130_fd_sc_hd__decap_3
XTAP_TAPCELL_ROW_20_571 VGND VPWR sky130_fd_sc_hd__tapvpwrvgnd_1
XFILLER_108_464 VGND VGND VPWR VPWR sky130_fd_sc_hd__decap_3
XTAP_TAPCELL_ROW_79_1392 VGND VPWR sky130_fd_sc_hd__tapvpwrvgnd_1
XFILLER_123_434 VGND VGND VPWR VPWR sky130_fd_sc_hd__fill_1
XFILLER_135_294 VGND VGND VPWR VPWR sky130_fd_sc_hd__decap_3
XFILLER_2_731 VGND VGND VPWR VPWR sky130_fd_sc_hd__decap_3
XFILLER_111_629 VGND VGND VPWR VPWR sky130_fd_sc_hd__decap_3
XFILLER_2_775 VGND VGND VPWR VPWR sky130_fd_sc_hd__decap_3
XFILLER_96_318 VGND VGND VPWR VPWR sky130_fd_sc_hd__decap_3
XTAP_TAPCELL_ROW_92_1581 VGND VPWR sky130_fd_sc_hd__tapvpwrvgnd_1
XFILLER_110_128 VGND VGND VPWR VPWR sky130_fd_sc_hd__fill_1
XFILLER_2_47 VGND VGND VPWR VPWR sky130_fd_sc_hd__decap_3
XFILLER_77_587 VGND VGND VPWR VPWR sky130_fd_sc_hd__decap_3
XFILLER_92_524 VGND VGND VPWR VPWR sky130_fd_sc_hd__decap_3
XFILLER_18_643 VGND VGND VPWR VPWR sky130_fd_sc_hd__fill_1
XFILLER_64_248 VGND VGND VPWR VPWR sky130_fd_sc_hd__decap_3
XFILLER_66_83 VGND VGND VPWR VPWR sky130_fd_sc_hd__fill_1
XFILLER_66_94 VGND VGND VPWR VPWR sky130_fd_sc_hd__decap_3
XTAP_TAPCELL_ROW_48_958 VGND VPWR sky130_fd_sc_hd__tapvpwrvgnd_1
XTAP_TAPCELL_ROW_48_969 VGND VPWR sky130_fd_sc_hd__tapvpwrvgnd_1
XFILLER_18_687 VGND VGND VPWR VPWR sky130_fd_sc_hd__decap_3
XFILLER_33_613 VGND VGND VPWR VPWR sky130_fd_sc_hd__decap_3
XFILLER_17_175 VGND VGND VPWR VPWR sky130_fd_sc_hd__decap_3
XFILLER_17_186 VGND VGND VPWR VPWR sky130_fd_sc_hd__decap_3
XFILLER_33_635 VGND VGND VPWR VPWR sky130_fd_sc_hd__decap_3
XFILLER_60_421 VGND VGND VPWR VPWR sky130_fd_sc_hd__fill_1
XFILLER_72_281 VGND VGND VPWR VPWR sky130_fd_sc_hd__decap_3
XTAP_TAPCELL_ROW_28_682 VGND VPWR sky130_fd_sc_hd__tapvpwrvgnd_1
XFILLER_32_134 VGND VGND VPWR VPWR sky130_fd_sc_hd__decap_3
XFILLER_33_668 VGND VGND VPWR VPWR sky130_fd_sc_hd__decap_3
XFILLER_60_498 VGND VGND VPWR VPWR sky130_fd_sc_hd__decap_3
X_3740_ _3749_/A VGND VGND VPWR VPWR _3811_/A sky130_fd_sc_hd__clkbuf_1
XFILLER_119_729 VGND VGND VPWR VPWR sky130_fd_sc_hd__decap_3
XFILLER_127_762 VGND VGND VPWR VPWR sky130_fd_sc_hd__decap_3
XFILLER_9_396 VGND VGND VPWR VPWR sky130_fd_sc_hd__decap_3
X_6390_ _4753_/X _8251_/Q _6398_/S VGND VGND VPWR VPWR _6391_/A sky130_fd_sc_hd__mux2_2
X_5410_ _5410_/A VGND VGND VPWR VPWR _7754_/D sky130_fd_sc_hd__buf_1
XFILLER_114_401 VGND VGND VPWR VPWR sky130_fd_sc_hd__fill_2
XFILLER_126_250 VGND VGND VPWR VPWR sky130_fd_sc_hd__fill_2
Xoutput115 _4181_/X VGND VGND VPWR VPWR rdata[35] sky130_fd_sc_hd__clkdlybuf4s25_1
Xoutput104 _4073_/X VGND VGND VPWR VPWR rdata[25] sky130_fd_sc_hd__clkdlybuf4s25_1
X_5341_ _5341_/A VGND VGND VPWR VPWR _7721_/D sky130_fd_sc_hd__buf_1
Xoutput126 _4289_/X VGND VGND VPWR VPWR rdata[45] sky130_fd_sc_hd__clkdlybuf4s25_1
Xoutput137 _4407_/X VGND VGND VPWR VPWR rdata[55] sky130_fd_sc_hd__clkdlybuf4s25_1
Xoutput148 _4519_/X VGND VGND VPWR VPWR rdata[65] sky130_fd_sc_hd__clkdlybuf4s25_1
Xoutput159 _4628_/X VGND VGND VPWR VPWR rdata[75] sky130_fd_sc_hd__clkdlybuf4s25_1
X_8060_ _8789_/CLK _8060_/D wire680/X VGND VGND VPWR VPWR _8060_/Q sky130_fd_sc_hd__dfrtp_2
XFILLER_99_178 VGND VGND VPWR VPWR sky130_fd_sc_hd__decap_3
X_7011_ _4957_/X _8542_/Q _7025_/S VGND VGND VPWR VPWR _7012_/A sky130_fd_sc_hd__mux2_2
X_5272_ _5272_/A VGND VGND VPWR VPWR _7689_/D sky130_fd_sc_hd__buf_1
XTAP_TAPCELL_ROW_52_1020 VGND VPWR sky130_fd_sc_hd__tapvpwrvgnd_1
X_4223_ _4231_/A _4222_/X _4545_/B1 VGND VGND VPWR VPWR _4223_/X sky130_fd_sc_hd__o21a_2
XFILLER_110_651 VGND VGND VPWR VPWR sky130_fd_sc_hd__decap_3
XFILLER_68_543 VGND VGND VPWR VPWR sky130_fd_sc_hd__decap_3
XFILLER_68_565 VGND VGND VPWR VPWR sky130_fd_sc_hd__decap_3
XFILLER_95_340 VGND VGND VPWR VPWR sky130_fd_sc_hd__fill_1
X_4154_ _4151_/X _4152_/X _4153_/X _3726_/A VGND VGND VPWR VPWR _4154_/X sky130_fd_sc_hd__a22o_2
XFILLER_110_695 VGND VGND VPWR VPWR sky130_fd_sc_hd__decap_3
XFILLER_28_418 VGND VGND VPWR VPWR sky130_fd_sc_hd__fill_2
X_4085_ _4082_/X _4083_/X _4084_/X _4165_/A _3988_/A VGND VGND VPWR VPWR _4085_/X
+ sky130_fd_sc_hd__a221o_2
XFILLER_71_708 VGND VGND VPWR VPWR sky130_fd_sc_hd__decap_3
XFILLER_83_546 VGND VGND VPWR VPWR sky130_fd_sc_hd__decap_3
X_7913_ _8730_/CLK _7913_/D fanout487/X VGND VGND VPWR VPWR _7913_/Q sky130_fd_sc_hd__dfrtp_2
XFILLER_55_259 VGND VGND VPWR VPWR sky130_fd_sc_hd__fill_1
XFILLER_64_760 VGND VGND VPWR VPWR sky130_fd_sc_hd__decap_3
XFILLER_36_473 VGND VGND VPWR VPWR sky130_fd_sc_hd__decap_3
XFILLER_63_281 VGND VGND VPWR VPWR sky130_fd_sc_hd__decap_3
X_7844_ _8745_/CLK _7844_/D wire618/X VGND VGND VPWR VPWR _7844_/Q sky130_fd_sc_hd__dfrtp_2
XFILLER_24_668 VGND VGND VPWR VPWR sky130_fd_sc_hd__decap_3
X_7775_ _8019_/CLK _7775_/D fanout715/X VGND VGND VPWR VPWR _7775_/Q sky130_fd_sc_hd__dfrtp_2
XTAP_TAPCELL_ROW_63_1171 VGND VPWR sky130_fd_sc_hd__tapvpwrvgnd_1
X_6726_ _8408_/Q _4730_/A _6744_/S VGND VGND VPWR VPWR _6727_/A sky130_fd_sc_hd__mux2_2
X_4987_ _4987_/A VGND VGND VPWR VPWR _7567_/D sky130_fd_sc_hd__buf_1
XFILLER_134_9 VGND VGND VPWR VPWR sky130_fd_sc_hd__decap_3
XFILLER_32_690 VGND VGND VPWR VPWR sky130_fd_sc_hd__fill_1
X_3938_ _4455_/A _3938_/B VGND VGND VPWR VPWR _3938_/X sky130_fd_sc_hd__or2_2
Xwire209 _6097_/A VGND VGND VPWR VPWR _6139_/S sky130_fd_sc_hd__clkbuf_4
XPHY_EDGE_ROW_12_Left_148 VGND VGND VPWR VPWR sky130_fd_sc_hd__decap_3
X_3869_ _3869_/A _3869_/B VGND VGND VPWR VPWR _3869_/X sky130_fd_sc_hd__or2_2
X_6657_ _6657_/A VGND VGND VPWR VPWR _8377_/D sky130_fd_sc_hd__buf_1
XFILLER_11_12 VGND VGND VPWR VPWR sky130_fd_sc_hd__decap_3
XTAP_TAPCELL_ROW_119_1960 VGND VPWR sky130_fd_sc_hd__tapvpwrvgnd_1
X_6588_ _6588_/A VGND VGND VPWR VPWR _8344_/D sky130_fd_sc_hd__buf_2
X_5608_ _5608_/A0 _4803_/A _5612_/S VGND VGND VPWR VPWR _5609_/A sky130_fd_sc_hd__mux2_2
XFILLER_11_45 VGND VGND VPWR VPWR sky130_fd_sc_hd__decap_3
XFILLER_124_209 VGND VGND VPWR VPWR sky130_fd_sc_hd__fill_2
XFILLER_127_12 VGND VGND VPWR VPWR sky130_fd_sc_hd__decap_3
X_8327_ _8493_/CLK _8327_/D fanout475/A VGND VGND VPWR VPWR _8327_/Q sky130_fd_sc_hd__dfrtp_2
X_5539_ _5539_/A0 _5007_/A _5549_/S VGND VGND VPWR VPWR _5540_/A sky130_fd_sc_hd__mux2_2
XFILLER_11_78 VGND VGND VPWR VPWR sky130_fd_sc_hd__decap_3
XFILLER_127_45 VGND VGND VPWR VPWR sky130_fd_sc_hd__decap_3
XFILLER_133_721 VGND VGND VPWR VPWR sky130_fd_sc_hd__decap_3
XFILLER_133_732 VGND VGND VPWR VPWR sky130_fd_sc_hd__decap_3
XFILLER_105_467 VGND VGND VPWR VPWR sky130_fd_sc_hd__fill_1
XFILLER_127_78 VGND VGND VPWR VPWR sky130_fd_sc_hd__decap_3
XFILLER_132_242 VGND VGND VPWR VPWR sky130_fd_sc_hd__decap_3
XFILLER_132_253 VGND VGND VPWR VPWR sky130_fd_sc_hd__decap_3
XFILLER_133_765 VGND VGND VPWR VPWR sky130_fd_sc_hd__decap_3
X_8258_ _8670_/CLK _8258_/D load_slew633/X VGND VGND VPWR VPWR _8258_/Q sky130_fd_sc_hd__dfrtp_2
XFILLER_105_489 VGND VGND VPWR VPWR sky130_fd_sc_hd__decap_3
XFILLER_132_286 VGND VGND VPWR VPWR sky130_fd_sc_hd__decap_3
XFILLER_78_329 VGND VGND VPWR VPWR sky130_fd_sc_hd__decap_3
Xfanout331 _4158_/A VGND VGND VPWR VPWR _4125_/A sky130_fd_sc_hd__clkdlybuf4s25_1
X_8189_ _8780_/CLK _8189_/D load_slew722/X VGND VGND VPWR VPWR _8189_/Q sky130_fd_sc_hd__dfrtp_2
X_7209_ _7213_/A1 _4703_/X _7216_/A3 _7216_/B1 hold858/X VGND VGND VPWR VPWR _8644_/D
+ sky130_fd_sc_hd__a32o_2
XTAP_TAPCELL_ROW_6_377 VGND VPWR sky130_fd_sc_hd__tapvpwrvgnd_1
Xfanout342 fanout364/X VGND VGND VPWR VPWR _4096_/A sky130_fd_sc_hd__clkdlybuf4s25_1
Xfanout364 _8045_/Q VGND VGND VPWR VPWR fanout364/X sky130_fd_sc_hd__clkdlybuf4s25_1
Xfanout375 _3849_/S1 VGND VGND VPWR VPWR _3869_/A sky130_fd_sc_hd__clkdlybuf4s25_1
XFILLER_100_150 VGND VGND VPWR VPWR sky130_fd_sc_hd__decap_3
XFILLER_47_727 VGND VGND VPWR VPWR sky130_fd_sc_hd__fill_1
XFILLER_59_576 VGND VGND VPWR VPWR sky130_fd_sc_hd__decap_3
XFILLER_86_362 VGND VGND VPWR VPWR sky130_fd_sc_hd__fill_2
XPHY_EDGE_ROW_21_Left_157 VGND VGND VPWR VPWR sky130_fd_sc_hd__decap_3
Xfanout386 _4636_/S1 VGND VGND VPWR VPWR _4564_/A1 sky130_fd_sc_hd__clkdlybuf4s25_1
Xfanout397 fanout414/X VGND VGND VPWR VPWR _4193_/S sky130_fd_sc_hd__clkdlybuf4s25_1
XFILLER_100_194 VGND VGND VPWR VPWR sky130_fd_sc_hd__fill_2
XFILLER_74_557 VGND VGND VPWR VPWR sky130_fd_sc_hd__fill_2
XFILLER_86_395 VGND VGND VPWR VPWR sky130_fd_sc_hd__fill_1
XFILLER_46_259 VGND VGND VPWR VPWR sky130_fd_sc_hd__decap_3
XFILLER_74_568 VGND VGND VPWR VPWR sky130_fd_sc_hd__decap_3
XTAP_TAPCELL_ROW_45_917 VGND VPWR sky130_fd_sc_hd__tapvpwrvgnd_1
XTAP_TAPCELL_ROW_45_928 VGND VPWR sky130_fd_sc_hd__tapvpwrvgnd_1
XFILLER_14_112 VGND VGND VPWR VPWR sky130_fd_sc_hd__decap_3
XFILLER_42_421 VGND VGND VPWR VPWR sky130_fd_sc_hd__decap_3
XFILLER_15_679 VGND VGND VPWR VPWR sky130_fd_sc_hd__decap_3
XTAP_TAPCELL_ROW_25_641 VGND VPWR sky130_fd_sc_hd__tapvpwrvgnd_1
XFILLER_30_638 VGND VGND VPWR VPWR sky130_fd_sc_hd__decap_3
XFILLER_128_504 VGND VGND VPWR VPWR sky130_fd_sc_hd__decap_3
XFILLER_52_74 VGND VGND VPWR VPWR sky130_fd_sc_hd__fill_1
XFILLER_52_85 VGND VGND VPWR VPWR sky130_fd_sc_hd__decap_3
XPHY_EDGE_ROW_30_Left_166 VGND VGND VPWR VPWR sky130_fd_sc_hd__decap_3
Xinput17 wdata[22] VGND VGND VPWR VPWR _4690_/A sky130_fd_sc_hd__clkdlybuf4s25_1
Xinput28 wdata[32] VGND VGND VPWR VPWR _4739_/A sky130_fd_sc_hd__clkdlybuf4s25_1
XFILLER_128_548 VGND VGND VPWR VPWR sky130_fd_sc_hd__decap_3
Xinput39 wdata[42] VGND VGND VPWR VPWR _4781_/A sky130_fd_sc_hd__clkdlybuf4s25_1
XFILLER_124_710 VGND VGND VPWR VPWR sky130_fd_sc_hd__fill_1
XTAP_TAPCELL_ROW_94_1610 VGND VPWR sky130_fd_sc_hd__tapvpwrvgnd_1
XFILLER_123_220 VGND VGND VPWR VPWR sky130_fd_sc_hd__decap_3
Xload_slew704 fanout703/X VGND VGND VPWR VPWR load_slew704/X sky130_fd_sc_hd__clkbuf_4
XFILLER_111_437 VGND VGND VPWR VPWR sky130_fd_sc_hd__fill_2
XFILLER_69_329 VGND VGND VPWR VPWR sky130_fd_sc_hd__decap_3
Xload_slew748 fanout747/X VGND VGND VPWR VPWR load_slew748/X sky130_fd_sc_hd__clkbuf_2
XFILLER_28_6 VGND VGND VPWR VPWR sky130_fd_sc_hd__decap_3
XFILLER_77_340 VGND VGND VPWR VPWR sky130_fd_sc_hd__decap_3
XFILLER_77_60 VGND VGND VPWR VPWR sky130_fd_sc_hd__fill_1
XFILLER_65_535 VGND VGND VPWR VPWR sky130_fd_sc_hd__decap_3
XFILLER_92_332 VGND VGND VPWR VPWR sky130_fd_sc_hd__decap_3
XFILLER_65_579 VGND VGND VPWR VPWR sky130_fd_sc_hd__decap_3
XFILLER_92_365 VGND VGND VPWR VPWR sky130_fd_sc_hd__fill_1
XFILLER_33_421 VGND VGND VPWR VPWR sky130_fd_sc_hd__decap_3
XFILLER_46_793 VGND VGND VPWR VPWR sky130_fd_sc_hd__decap_3
X_5890_ _5881_/X _5882_/X _4715_/X _5883_/X hold902/X VGND VGND VPWR VPWR _7989_/D
+ sky130_fd_sc_hd__a32o_2
X_4910_ _4908_/X _4910_/A1 _7453_/S VGND VGND VPWR VPWR _4911_/A sky130_fd_sc_hd__mux2_2
X_4841_ _4841_/A VGND VGND VPWR VPWR _4841_/X sky130_fd_sc_hd__buf_1
XFILLER_61_785 VGND VGND VPWR VPWR sky130_fd_sc_hd__decap_3
X_7560_ _8627_/CLK _7560_/D load_slew667/X VGND VGND VPWR VPWR _7560_/Q sky130_fd_sc_hd__dfrtp_2
X_4772_ _4772_/A _4776_/B VGND VGND VPWR VPWR _4773_/A sky130_fd_sc_hd__and2_2
X_3723_ _8052_/Q _3723_/B _7004_/A _8049_/Q VGND VGND VPWR VPWR _3728_/B sky130_fd_sc_hd__and4b_2
X_7491_ _5023_/X _8801_/Q _7495_/S VGND VGND VPWR VPWR _7492_/A sky130_fd_sc_hd__mux2_2
X_6511_ _6511_/A VGND VGND VPWR VPWR _8307_/D sky130_fd_sc_hd__buf_2
X_6442_ _6484_/S VGND VGND VPWR VPWR _6461_/S sky130_fd_sc_hd__buf_6
XFILLER_127_570 VGND VGND VPWR VPWR sky130_fd_sc_hd__decap_3
XFILLER_134_507 VGND VGND VPWR VPWR sky130_fd_sc_hd__decap_3
XTAP_TAPCELL_ROW_132_2135 VGND VPWR sky130_fd_sc_hd__tapvpwrvgnd_1
XTAP_TAPCELL_ROW_132_2146 VGND VPWR sky130_fd_sc_hd__tapvpwrvgnd_1
XFILLER_114_220 VGND VGND VPWR VPWR sky130_fd_sc_hd__decap_3
XFILLER_115_732 VGND VGND VPWR VPWR sky130_fd_sc_hd__decap_3
X_8112_ _8760_/CLK _8112_/D load_slew718/X VGND VGND VPWR VPWR _8112_/Q sky130_fd_sc_hd__dfrtp_2
X_6373_ _7063_/A0 hold923/X _6377_/S VGND VGND VPWR VPWR _6374_/A sky130_fd_sc_hd__mux2_1
XFILLER_115_776 VGND VGND VPWR VPWR sky130_fd_sc_hd__decap_3
XFILLER_88_605 VGND VGND VPWR VPWR sky130_fd_sc_hd__decap_3
X_5324_ _5324_/A VGND VGND VPWR VPWR _7714_/D sky130_fd_sc_hd__buf_1
XFILLER_130_713 VGND VGND VPWR VPWR sky130_fd_sc_hd__decap_3
XFILLER_130_746 VGND VGND VPWR VPWR sky130_fd_sc_hd__decap_3
XFILLER_88_638 VGND VGND VPWR VPWR sky130_fd_sc_hd__decap_3
XTAP_TAPCELL_ROW_114_1890 VGND VPWR sky130_fd_sc_hd__tapvpwrvgnd_1
X_8043_ _8701_/CLK _8043_/D load_slew649/X VGND VGND VPWR VPWR _8043_/Q sky130_fd_sc_hd__dfrtp_2
X_5255_ _5255_/A VGND VGND VPWR VPWR _7681_/D sky130_fd_sc_hd__buf_1
XFILLER_130_757 VGND VGND VPWR VPWR sky130_fd_sc_hd__decap_3
XFILLER_87_148 VGND VGND VPWR VPWR sky130_fd_sc_hd__decap_3
X_4206_ _8740_/Q _7515_/Q _4209_/S VGND VGND VPWR VPWR _4206_/X sky130_fd_sc_hd__mux2_2
XFILLER_29_738 VGND VGND VPWR VPWR sky130_fd_sc_hd__decap_3
XFILLER_3_90 VGND VGND VPWR VPWR sky130_fd_sc_hd__decap_3
XFILLER_96_660 VGND VGND VPWR VPWR sky130_fd_sc_hd__decap_3
XTAP_TAPCELL_ROW_3_336 VGND VPWR sky130_fd_sc_hd__tapvpwrvgnd_1
X_5186_ _5291_/A VGND VGND VPWR VPWR _5205_/S sky130_fd_sc_hd__buf_2
XFILLER_95_181 VGND VGND VPWR VPWR sky130_fd_sc_hd__decap_3
X_4137_ _8572_/Q _3769_/X _4136_/X _4096_/A _4231_/A VGND VGND VPWR VPWR _4137_/X
+ sky130_fd_sc_hd__o221a_2
XFILLER_71_505 VGND VGND VPWR VPWR sky130_fd_sc_hd__fill_2
XFILLER_83_365 VGND VGND VPWR VPWR sky130_fd_sc_hd__decap_3
Xclkbuf_5_13__f_CLK clkbuf_4_6_0_CLK/X VGND VGND VPWR VPWR clkload4/A sky130_fd_sc_hd__clkbuf_16
X_4068_ _4062_/X _4063_/X _4064_/X _4067_/X VGND VGND VPWR VPWR _4068_/X sky130_fd_sc_hd__a22o_2
XFILLER_24_410 VGND VGND VPWR VPWR sky130_fd_sc_hd__fill_2
XFILLER_24_421 VGND VGND VPWR VPWR sky130_fd_sc_hd__decap_3
XFILLER_37_782 VGND VGND VPWR VPWR sky130_fd_sc_hd__fill_2
XFILLER_83_387 VGND VGND VPWR VPWR sky130_fd_sc_hd__decap_3
XTAP_TAPCELL_ROW_65_1200 VGND VPWR sky130_fd_sc_hd__tapvpwrvgnd_1
X_7827_ _8483_/CLK _7827_/D fanout504/X VGND VGND VPWR VPWR _7827_/Q sky130_fd_sc_hd__dfrtp_2
XFILLER_12_616 VGND VGND VPWR VPWR sky130_fd_sc_hd__decap_3
XFILLER_24_465 VGND VGND VPWR VPWR sky130_fd_sc_hd__decap_3
XTAP_TAPCELL_ROW_22_600 VGND VPWR sky130_fd_sc_hd__tapvpwrvgnd_1
XFILLER_51_284 VGND VGND VPWR VPWR sky130_fd_sc_hd__decap_3
X_7758_ _8748_/CLK _7758_/D fanout542/X VGND VGND VPWR VPWR _7758_/Q sky130_fd_sc_hd__dfrtp_2
XFILLER_11_159 VGND VGND VPWR VPWR sky130_fd_sc_hd__decap_3
XFILLER_132_6 VGND VGND VPWR VPWR sky130_fd_sc_hd__decap_3
XFILLER_22_11 VGND VGND VPWR VPWR sky130_fd_sc_hd__decap_3
XTAP_TAPCELL_ROW_50_986 VGND VPWR sky130_fd_sc_hd__tapvpwrvgnd_1
X_7689_ _8753_/CLK _7689_/D load_slew640/X VGND VGND VPWR VPWR _7689_/Q sky130_fd_sc_hd__dfrtp_2
X_6709_ _8400_/Q _4690_/A _6723_/S VGND VGND VPWR VPWR _6710_/A sky130_fd_sc_hd__mux2_2
XFILLER_20_671 VGND VGND VPWR VPWR sky130_fd_sc_hd__fill_1
XFILLER_22_44 VGND VGND VPWR VPWR sky130_fd_sc_hd__decap_3
XTAP_TAPCELL_ROW_50_997 VGND VPWR sky130_fd_sc_hd__tapvpwrvgnd_1
XFILLER_22_77 VGND VGND VPWR VPWR sky130_fd_sc_hd__decap_3
XFILLER_22_88 VGND VGND VPWR VPWR sky130_fd_sc_hd__decap_3
XTAP_TAPCELL_ROW_76_1351 VGND VPWR sky130_fd_sc_hd__tapvpwrvgnd_1
XFILLER_79_605 VGND VGND VPWR VPWR sky130_fd_sc_hd__fill_2
XTAP_TAPCELL_ROW_76_1362 VGND VPWR sky130_fd_sc_hd__tapvpwrvgnd_1
XFILLER_133_573 VGND VGND VPWR VPWR sky130_fd_sc_hd__decap_3
XFILLER_78_115 VGND VGND VPWR VPWR sky130_fd_sc_hd__decap_3
XFILLER_79_638 VGND VGND VPWR VPWR sky130_fd_sc_hd__decap_3
XFILLER_121_779 VGND VGND VPWR VPWR sky130_fd_sc_hd__decap_3
XFILLER_78_137 VGND VGND VPWR VPWR sky130_fd_sc_hd__decap_3
XFILLER_120_256 VGND VGND VPWR VPWR sky130_fd_sc_hd__decap_3
XFILLER_47_502 VGND VGND VPWR VPWR sky130_fd_sc_hd__fill_2
XFILLER_87_682 VGND VGND VPWR VPWR sky130_fd_sc_hd__fill_2
XFILLER_101_481 VGND VGND VPWR VPWR sky130_fd_sc_hd__decap_3
XFILLER_47_52 VGND VGND VPWR VPWR sky130_fd_sc_hd__decap_3
XFILLER_47_524 VGND VGND VPWR VPWR sky130_fd_sc_hd__fill_1
XFILLER_47_546 VGND VGND VPWR VPWR sky130_fd_sc_hd__decap_3
XFILLER_62_505 VGND VGND VPWR VPWR sky130_fd_sc_hd__fill_2
XFILLER_62_516 VGND VGND VPWR VPWR sky130_fd_sc_hd__decap_3
XFILLER_74_343 VGND VGND VPWR VPWR sky130_fd_sc_hd__fill_1
XFILLER_74_365 VGND VGND VPWR VPWR sky130_fd_sc_hd__decap_3
XFILLER_74_398 VGND VGND VPWR VPWR sky130_fd_sc_hd__decap_3
XFILLER_15_421 VGND VGND VPWR VPWR sky130_fd_sc_hd__fill_1
XFILLER_15_443 VGND VGND VPWR VPWR sky130_fd_sc_hd__fill_1
XFILLER_27_281 VGND VGND VPWR VPWR sky130_fd_sc_hd__decap_3
XFILLER_63_40 VGND VGND VPWR VPWR sky130_fd_sc_hd__decap_3
XFILLER_42_251 VGND VGND VPWR VPWR sky130_fd_sc_hd__fill_1
XFILLER_42_273 VGND VGND VPWR VPWR sky130_fd_sc_hd__fill_2
XFILLER_30_446 VGND VGND VPWR VPWR sky130_fd_sc_hd__decap_3
XFILLER_8_24 VGND VGND VPWR VPWR sky130_fd_sc_hd__decap_3
XFILLER_8_35 VGND VGND VPWR VPWR sky130_fd_sc_hd__decap_3
XFILLER_11_682 VGND VGND VPWR VPWR sky130_fd_sc_hd__decap_3
XFILLER_7_620 VGND VGND VPWR VPWR sky130_fd_sc_hd__decap_3
XFILLER_8_68 VGND VGND VPWR VPWR sky130_fd_sc_hd__decap_3
XFILLER_6_141 VGND VGND VPWR VPWR sky130_fd_sc_hd__decap_3
XFILLER_7_653 VGND VGND VPWR VPWR sky130_fd_sc_hd__decap_3
XFILLER_109_592 VGND VGND VPWR VPWR sky130_fd_sc_hd__decap_3
XFILLER_7_697 VGND VGND VPWR VPWR sky130_fd_sc_hd__decap_3
XFILLER_124_584 VGND VGND VPWR VPWR sky130_fd_sc_hd__decap_3
XFILLER_124_595 VGND VGND VPWR VPWR sky130_fd_sc_hd__decap_3
Xload_slew501 fanout500/X VGND VGND VPWR VPWR load_slew501/X sky130_fd_sc_hd__buf_2
XFILLER_2_391 VGND VGND VPWR VPWR sky130_fd_sc_hd__fill_2
XFILLER_97_457 VGND VGND VPWR VPWR sky130_fd_sc_hd__fill_2
Xload_slew545 fanout544/X VGND VGND VPWR VPWR _8053_/SET_B sky130_fd_sc_hd__clkbuf_4
X_5040_ _5040_/A VGND VGND VPWR VPWR _7580_/D sky130_fd_sc_hd__buf_1
XFILLER_26_3 VGND VGND VPWR VPWR sky130_fd_sc_hd__decap_3
Xload_slew589 fanout588/X VGND VGND VPWR VPWR load_slew589/X sky130_fd_sc_hd__buf_4
XFILLER_111_289 VGND VGND VPWR VPWR sky130_fd_sc_hd__decap_3
XFILLER_77_181 VGND VGND VPWR VPWR sky130_fd_sc_hd__fill_2
XFILLER_53_505 VGND VGND VPWR VPWR sky130_fd_sc_hd__decap_3
XFILLER_65_365 VGND VGND VPWR VPWR sky130_fd_sc_hd__decap_3
XFILLER_81_803 VGND VGND VPWR VPWR sky130_fd_sc_hd__fill_1
XFILLER_93_652 VGND VGND VPWR VPWR sky130_fd_sc_hd__decap_3
X_6991_ _6991_/A VGND VGND VPWR VPWR _8533_/D sky130_fd_sc_hd__buf_6
XFILLER_53_538 VGND VGND VPWR VPWR sky130_fd_sc_hd__decap_3
X_8730_ _8730_/CLK _8730_/D fanout516/X VGND VGND VPWR VPWR _8730_/Q sky130_fd_sc_hd__dfrtp_2
X_5942_ _5944_/A1 _5944_/A2 _4883_/X _5944_/B1 hold892/X VGND VGND VPWR VPWR _8029_/D
+ sky130_fd_sc_hd__a32o_2
XFILLER_18_281 VGND VGND VPWR VPWR sky130_fd_sc_hd__decap_3
XFILLER_34_730 VGND VGND VPWR VPWR sky130_fd_sc_hd__decap_3
XFILLER_34_752 VGND VGND VPWR VPWR sky130_fd_sc_hd__decap_3
XFILLER_21_402 VGND VGND VPWR VPWR sky130_fd_sc_hd__decap_3
XTAP_TAPCELL_ROW_101_1709 VGND VPWR sky130_fd_sc_hd__tapvpwrvgnd_1
X_8661_ _8662_/CLK _8661_/D load_slew621/X VGND VGND VPWR VPWR _8661_/Q sky130_fd_sc_hd__dfrtp_2
X_5873_ _5868_/X _5879_/A2 _4999_/X _5879_/B1 hold901/X VGND VGND VPWR VPWR _7975_/D
+ sky130_fd_sc_hd__a32o_2
XFILLER_21_446 VGND VGND VPWR VPWR sky130_fd_sc_hd__fill_2
XFILLER_61_582 VGND VGND VPWR VPWR sky130_fd_sc_hd__decap_3
X_8592_ _8680_/CLK _8592_/D wire693/X VGND VGND VPWR VPWR _8592_/Q sky130_fd_sc_hd__dfrtp_2
X_7612_ _8679_/CLK _7612_/D fanout697/X VGND VGND VPWR VPWR _7612_/Q sky130_fd_sc_hd__dfrtp_2
X_4824_ _4824_/A VGND VGND VPWR VPWR _4824_/X sky130_fd_sc_hd__buf_1
XTAP_TAPCELL_ROW_60_1130 VGND VPWR sky130_fd_sc_hd__tapvpwrvgnd_1
X_7543_ _8768_/CLK _7543_/D fanout562/X VGND VGND VPWR VPWR _7543_/Q sky130_fd_sc_hd__dfrtp_2
X_4755_ _4755_/A VGND VGND VPWR VPWR _7512_/D sky130_fd_sc_hd__buf_1
XFILLER_119_323 VGND VGND VPWR VPWR sky130_fd_sc_hd__decap_3
X_3706_ _4543_/A _3727_/B _3707_/B VGND VGND VPWR VPWR _5962_/A sky130_fd_sc_hd__a21oi_2
XFILLER_134_304 VGND VGND VPWR VPWR sky130_fd_sc_hd__decap_3
X_7474_ _4989_/X _8793_/Q _7474_/S VGND VGND VPWR VPWR _7475_/A sky130_fd_sc_hd__mux2_2
X_4686_ _6314_/A _8049_/Q _6314_/C VGND VGND VPWR VPWR _7282_/B sky130_fd_sc_hd__or3_4
XFILLER_108_25 VGND VGND VPWR VPWR sky130_fd_sc_hd__decap_3
XFILLER_134_315 VGND VGND VPWR VPWR sky130_fd_sc_hd__decap_3
X_6425_ _6425_/A VGND VGND VPWR VPWR _8267_/D sky130_fd_sc_hd__buf_2
XFILLER_108_58 VGND VGND VPWR VPWR sky130_fd_sc_hd__decap_3
XFILLER_134_359 VGND VGND VPWR VPWR sky130_fd_sc_hd__decap_3
XTAP_TAPCELL_ROW_8_406 VGND VPWR sky130_fd_sc_hd__tapvpwrvgnd_1
X_6356_ _5027_/X _8235_/Q _6356_/S VGND VGND VPWR VPWR _6357_/A sky130_fd_sc_hd__mux2_2
XFILLER_130_510 VGND VGND VPWR VPWR sky130_fd_sc_hd__decap_3
XFILLER_68_18 VGND VGND VPWR VPWR sky130_fd_sc_hd__fill_1
XFILLER_68_29 VGND VGND VPWR VPWR sky130_fd_sc_hd__decap_3
XFILLER_88_424 VGND VGND VPWR VPWR sky130_fd_sc_hd__decap_3
X_5307_ _5307_/A VGND VGND VPWR VPWR _7706_/D sky130_fd_sc_hd__buf_1
XFILLER_102_245 VGND VGND VPWR VPWR sky130_fd_sc_hd__decap_3
XFILLER_103_746 VGND VGND VPWR VPWR sky130_fd_sc_hd__decap_3
XFILLER_103_757 VGND VGND VPWR VPWR sky130_fd_sc_hd__decap_3
XFILLER_130_554 VGND VGND VPWR VPWR sky130_fd_sc_hd__decap_3
X_8026_ _8765_/CLK _8026_/D load_slew582/X VGND VGND VPWR VPWR _8026_/Q sky130_fd_sc_hd__dfrtp_2
X_6287_ _4891_/X _8203_/Q _6289_/S VGND VGND VPWR VPWR _6288_/A sky130_fd_sc_hd__mux2_4
XFILLER_124_24 VGND VGND VPWR VPWR sky130_fd_sc_hd__decap_3
XFILLER_124_35 VGND VGND VPWR VPWR sky130_fd_sc_hd__decap_3
XFILLER_130_587 VGND VGND VPWR VPWR sky130_fd_sc_hd__fill_1
XTAP_TAPCELL_ROW_71_1281 VGND VPWR sky130_fd_sc_hd__tapvpwrvgnd_1
X_5238_ _5238_/A VGND VGND VPWR VPWR _7673_/D sky130_fd_sc_hd__buf_1
XFILLER_130_598 VGND VGND VPWR VPWR sky130_fd_sc_hd__decap_3
XFILLER_56_321 VGND VGND VPWR VPWR sky130_fd_sc_hd__fill_1
XTAP_TAPCELL_ROW_71_1292 VGND VPWR sky130_fd_sc_hd__tapvpwrvgnd_1
X_5169_ _5169_/A VGND VGND VPWR VPWR _7640_/D sky130_fd_sc_hd__buf_1
XFILLER_29_579 VGND VGND VPWR VPWR sky130_fd_sc_hd__decap_3
XFILLER_56_365 VGND VGND VPWR VPWR sky130_fd_sc_hd__decap_3
XFILLER_84_674 VGND VGND VPWR VPWR sky130_fd_sc_hd__fill_1
XFILLER_17_33 VGND VGND VPWR VPWR sky130_fd_sc_hd__decap_3
XFILLER_71_313 VGND VGND VPWR VPWR sky130_fd_sc_hd__decap_3
XFILLER_17_66 VGND VGND VPWR VPWR sky130_fd_sc_hd__decap_3
XFILLER_25_741 VGND VGND VPWR VPWR sky130_fd_sc_hd__decap_3
XFILLER_37_590 VGND VGND VPWR VPWR sky130_fd_sc_hd__decap_3
XFILLER_83_195 VGND VGND VPWR VPWR sky130_fd_sc_hd__decap_3
XFILLER_25_785 VGND VGND VPWR VPWR sky130_fd_sc_hd__fill_2
XFILLER_52_560 VGND VGND VPWR VPWR sky130_fd_sc_hd__decap_3
XFILLER_71_379 VGND VGND VPWR VPWR sky130_fd_sc_hd__decap_3
XFILLER_12_413 VGND VGND VPWR VPWR sky130_fd_sc_hd__decap_3
XFILLER_12_424 VGND VGND VPWR VPWR sky130_fd_sc_hd__decap_3
XFILLER_33_32 VGND VGND VPWR VPWR sky130_fd_sc_hd__decap_3
XTAP_TAPCELL_ROW_35_780 VGND VPWR sky130_fd_sc_hd__tapvpwrvgnd_1
XFILLER_12_457 VGND VGND VPWR VPWR sky130_fd_sc_hd__decap_3
XFILLER_130_3 VGND VGND VPWR VPWR sky130_fd_sc_hd__decap_3
XFILLER_4_601 VGND VGND VPWR VPWR sky130_fd_sc_hd__decap_3
XPHY_EDGE_ROW_104_Left_240 VGND VGND VPWR VPWR sky130_fd_sc_hd__decap_3
XFILLER_125_326 VGND VGND VPWR VPWR sky130_fd_sc_hd__fill_1
XFILLER_3_111 VGND VGND VPWR VPWR sky130_fd_sc_hd__fill_1
XFILLER_4_634 VGND VGND VPWR VPWR sky130_fd_sc_hd__decap_3
XFILLER_106_551 VGND VGND VPWR VPWR sky130_fd_sc_hd__decap_3
XFILLER_125_348 VGND VGND VPWR VPWR sky130_fd_sc_hd__decap_3
XFILLER_4_645 VGND VGND VPWR VPWR sky130_fd_sc_hd__decap_3
XFILLER_106_584 VGND VGND VPWR VPWR sky130_fd_sc_hd__decap_3
XFILLER_133_370 VGND VGND VPWR VPWR sky130_fd_sc_hd__decap_3
XFILLER_4_678 VGND VGND VPWR VPWR sky130_fd_sc_hd__decap_3
XFILLER_79_402 VGND VGND VPWR VPWR sky130_fd_sc_hd__decap_3
XFILLER_106_595 VGND VGND VPWR VPWR sky130_fd_sc_hd__decap_3
XFILLER_79_435 VGND VGND VPWR VPWR sky130_fd_sc_hd__fill_1
XFILLER_79_468 VGND VGND VPWR VPWR sky130_fd_sc_hd__fill_1
XFILLER_94_427 VGND VGND VPWR VPWR sky130_fd_sc_hd__decap_3
XFILLER_12_9 VGND VGND VPWR VPWR sky130_fd_sc_hd__decap_3
XFILLER_66_129 VGND VGND VPWR VPWR sky130_fd_sc_hd__decap_3
XFILLER_63_803 VGND VGND VPWR VPWR sky130_fd_sc_hd__fill_1
XTAP_TAPCELL_ROW_89_1542 VGND VPWR sky130_fd_sc_hd__tapvpwrvgnd_1
XFILLER_62_313 VGND VGND VPWR VPWR sky130_fd_sc_hd__decap_3
XFILLER_75_685 VGND VGND VPWR VPWR sky130_fd_sc_hd__decap_3
XFILLER_74_94 VGND VGND VPWR VPWR sky130_fd_sc_hd__decap_3
XFILLER_90_688 VGND VGND VPWR VPWR sky130_fd_sc_hd__decap_3
XFILLER_15_273 VGND VGND VPWR VPWR sky130_fd_sc_hd__decap_3
XFILLER_31_744 VGND VGND VPWR VPWR sky130_fd_sc_hd__decap_3
XFILLER_31_788 VGND VGND VPWR VPWR sky130_fd_sc_hd__decap_3
XFILLER_129_632 VGND VGND VPWR VPWR sky130_fd_sc_hd__decap_3
XFILLER_30_265 VGND VGND VPWR VPWR sky130_fd_sc_hd__decap_3
XFILLER_30_287 VGND VGND VPWR VPWR sky130_fd_sc_hd__decap_3
XTAP_TAPCELL_ROW_13_474 VGND VPWR sky130_fd_sc_hd__tapvpwrvgnd_1
XFILLER_116_304 VGND VGND VPWR VPWR sky130_fd_sc_hd__decap_3
XFILLER_128_153 VGND VGND VPWR VPWR sky130_fd_sc_hd__decap_3
XFILLER_129_665 VGND VGND VPWR VPWR sky130_fd_sc_hd__decap_3
XFILLER_129_676 VGND VGND VPWR VPWR sky130_fd_sc_hd__decap_3
X_4540_ _7788_/Q _7869_/Q _7950_/Q _8031_/Q _4544_/S0 _4498_/A VGND VGND VPWR VPWR
+ _4540_/X sky130_fd_sc_hd__mux4_2
XFILLER_116_315 VGND VGND VPWR VPWR sky130_fd_sc_hd__decap_3
XFILLER_128_186 VGND VGND VPWR VPWR sky130_fd_sc_hd__decap_3
XFILLER_128_197 VGND VGND VPWR VPWR sky130_fd_sc_hd__decap_3
X_4471_ _8439_/Q _8520_/Q _4471_/S VGND VGND VPWR VPWR _4471_/X sky130_fd_sc_hd__mux2_2
X_7190_ _7189_/X _4985_/X _7176_/X _7179_/X hold855/X VGND VGND VPWR VPWR _8630_/D
+ sky130_fd_sc_hd__a32o_2
X_6210_ _4735_/X _8166_/Q _6226_/S VGND VGND VPWR VPWR _6211_/A sky130_fd_sc_hd__mux2_4
Xmax_cap169 _4829_/X VGND VGND VPWR VPWR _7248_/A2 sky130_fd_sc_hd__buf_2
X_6141_ _7177_/A _6141_/B _6141_/C VGND VGND VPWR VPWR _7004_/D sky130_fd_sc_hd__or3_4
Xload_slew320 _3827_/A1 VGND VGND VPWR VPWR _3875_/A sky130_fd_sc_hd__buf_2
XFILLER_100_716 VGND VGND VPWR VPWR sky130_fd_sc_hd__decap_3
XFILLER_58_608 VGND VGND VPWR VPWR sky130_fd_sc_hd__decap_3
XFILLER_98_777 VGND VGND VPWR VPWR sky130_fd_sc_hd__decap_3
X_6072_ _8102_/Q _4806_/A _6074_/S VGND VGND VPWR VPWR _6073_/A sky130_fd_sc_hd__mux2_2
XFILLER_100_738 VGND VGND VPWR VPWR sky130_fd_sc_hd__fill_2
XFILLER_38_321 VGND VGND VPWR VPWR sky130_fd_sc_hd__decap_3
XFILLER_85_438 VGND VGND VPWR VPWR sky130_fd_sc_hd__decap_3
XFILLER_85_449 VGND VGND VPWR VPWR sky130_fd_sc_hd__fill_1
X_5023_ _5023_/A VGND VGND VPWR VPWR _5023_/X sky130_fd_sc_hd__buf_1
XFILLER_66_641 VGND VGND VPWR VPWR sky130_fd_sc_hd__decap_3
XFILLER_66_663 VGND VGND VPWR VPWR sky130_fd_sc_hd__decap_3
XTAP_TAPCELL_ROW_127_2067 VGND VPWR sky130_fd_sc_hd__tapvpwrvgnd_1
XFILLER_38_365 VGND VGND VPWR VPWR sky130_fd_sc_hd__fill_2
XFILLER_38_376 VGND VGND VPWR VPWR sky130_fd_sc_hd__fill_1
XFILLER_38_398 VGND VGND VPWR VPWR sky130_fd_sc_hd__decap_3
XFILLER_53_302 VGND VGND VPWR VPWR sky130_fd_sc_hd__fill_1
XFILLER_65_184 VGND VGND VPWR VPWR sky130_fd_sc_hd__decap_3
X_6974_ _6974_/A VGND VGND VPWR VPWR _8525_/D sky130_fd_sc_hd__buf_6
XFILLER_0_91 VGND VGND VPWR VPWR sky130_fd_sc_hd__decap_3
XFILLER_41_508 VGND VGND VPWR VPWR sky130_fd_sc_hd__decap_3
X_8713_ _8794_/CLK _8713_/D load_slew584/X VGND VGND VPWR VPWR _8713_/Q sky130_fd_sc_hd__dfrtp_2
X_5925_ _5931_/A1 _5921_/X _4824_/X _5922_/X hold881/X VGND VGND VPWR VPWR _8015_/D
+ sky130_fd_sc_hd__a32o_2
XFILLER_110_59 VGND VGND VPWR VPWR sky130_fd_sc_hd__decap_3
X_8644_ _8725_/CLK _8644_/D fanout495/X VGND VGND VPWR VPWR _8644_/Q sky130_fd_sc_hd__dfrtp_2
X_5856_ _5856_/A VGND VGND VPWR VPWR _5948_/A sky130_fd_sc_hd__clkbuf_2
XPHY_EDGE_ROW_3_Right_3 VGND VGND VPWR VPWR sky130_fd_sc_hd__decap_3
X_4807_ _4807_/A VGND VGND VPWR VPWR _4807_/X sky130_fd_sc_hd__buf_1
XFILLER_119_120 VGND VGND VPWR VPWR sky130_fd_sc_hd__decap_3
XFILLER_21_287 VGND VGND VPWR VPWR sky130_fd_sc_hd__decap_3
X_8575_ _8658_/CLK _8575_/D load_slew515/X VGND VGND VPWR VPWR _8575_/Q sky130_fd_sc_hd__dfrtp_2
X_5787_ _7932_/Q _4815_/A _5805_/S VGND VGND VPWR VPWR _5788_/A sky130_fd_sc_hd__mux2_2
XFILLER_119_142 VGND VGND VPWR VPWR sky130_fd_sc_hd__fill_1
XFILLER_119_24 VGND VGND VPWR VPWR sky130_fd_sc_hd__decap_3
XFILLER_135_613 VGND VGND VPWR VPWR sky130_fd_sc_hd__decap_3
X_7526_ _8792_/CLK _7526_/D load_slew628/X VGND VGND VPWR VPWR _7526_/Q sky130_fd_sc_hd__dfrtp_2
X_4738_ _4951_/A VGND VGND VPWR VPWR _4764_/B sky130_fd_sc_hd__clkbuf_1
XFILLER_107_337 VGND VGND VPWR VPWR sky130_fd_sc_hd__decap_3
XFILLER_119_57 VGND VGND VPWR VPWR sky130_fd_sc_hd__decap_3
XFILLER_134_112 VGND VGND VPWR VPWR sky130_fd_sc_hd__decap_3
X_7457_ _7457_/A VGND VGND VPWR VPWR _8784_/D sky130_fd_sc_hd__buf_1
X_4669_ _4667_/X _4668_/X _4669_/S VGND VGND VPWR VPWR _4669_/X sky130_fd_sc_hd__mux2_2
XFILLER_134_156 VGND VGND VPWR VPWR sky130_fd_sc_hd__decap_3
XFILLER_135_657 VGND VGND VPWR VPWR sky130_fd_sc_hd__decap_3
Xhold940 _8540_/Q VGND VGND VPWR VPWR hold940/X sky130_fd_sc_hd__dlygate4sd3_1
X_6408_ _6408_/A VGND VGND VPWR VPWR _8259_/D sky130_fd_sc_hd__buf_2
XFILLER_0_103 VGND VGND VPWR VPWR sky130_fd_sc_hd__decap_3
XFILLER_134_189 VGND VGND VPWR VPWR sky130_fd_sc_hd__decap_3
XFILLER_135_12 VGND VGND VPWR VPWR sky130_fd_sc_hd__decap_3
XFILLER_1_604 VGND VGND VPWR VPWR sky130_fd_sc_hd__decap_3
XFILLER_1_626 VGND VGND VPWR VPWR sky130_fd_sc_hd__decap_3
XTAP_TAPCELL_ROW_73_1310 VGND VPWR sky130_fd_sc_hd__tapvpwrvgnd_1
XTAP_TAPCELL_ROW_73_1321 VGND VPWR sky130_fd_sc_hd__tapvpwrvgnd_1
Xhold951 _8577_/Q VGND VGND VPWR VPWR hold951/X sky130_fd_sc_hd__dlygate4sd3_1
Xhold962 _8263_/Q VGND VGND VPWR VPWR hold962/X sky130_fd_sc_hd__dlygate4sd3_1
Xhold973 _8586_/Q VGND VGND VPWR VPWR hold973/X sky130_fd_sc_hd__dlygate4sd3_1
X_7388_ _7451_/S VGND VGND VPWR VPWR _7407_/S sky130_fd_sc_hd__clkbuf_2
XFILLER_1_659 VGND VGND VPWR VPWR sky130_fd_sc_hd__decap_3
XFILLER_89_744 VGND VGND VPWR VPWR sky130_fd_sc_hd__decap_3
XFILLER_89_766 VGND VGND VPWR VPWR sky130_fd_sc_hd__decap_3
Xhold984 _7873_/Q VGND VGND VPWR VPWR hold984/X sky130_fd_sc_hd__dlygate4sd3_1
Xhold995 _8574_/Q VGND VGND VPWR VPWR hold995/X sky130_fd_sc_hd__dlygate4sd3_1
X_6339_ _6339_/A VGND VGND VPWR VPWR _8226_/D sky130_fd_sc_hd__buf_2
XFILLER_0_169 VGND VGND VPWR VPWR sky130_fd_sc_hd__fill_1
XFILLER_135_78 VGND VGND VPWR VPWR sky130_fd_sc_hd__decap_3
XFILLER_76_416 VGND VGND VPWR VPWR sky130_fd_sc_hd__decap_3
XFILLER_130_373 VGND VGND VPWR VPWR sky130_fd_sc_hd__decap_3
XFILLER_28_21 VGND VGND VPWR VPWR sky130_fd_sc_hd__decap_3
XFILLER_28_32 VGND VGND VPWR VPWR sky130_fd_sc_hd__decap_3
XFILLER_76_427 VGND VGND VPWR VPWR sky130_fd_sc_hd__decap_3
X_8009_ _8750_/CLK _8009_/D wire638/X VGND VGND VPWR VPWR _8009_/Q sky130_fd_sc_hd__dfrtp_2
XFILLER_45_803 VGND VGND VPWR VPWR sky130_fd_sc_hd__fill_1
XFILLER_57_652 VGND VGND VPWR VPWR sky130_fd_sc_hd__fill_1
XFILLER_17_505 VGND VGND VPWR VPWR sky130_fd_sc_hd__decap_3
XFILLER_71_110 VGND VGND VPWR VPWR sky130_fd_sc_hd__fill_2
XFILLER_44_379 VGND VGND VPWR VPWR sky130_fd_sc_hd__decap_3
XFILLER_12_221 VGND VGND VPWR VPWR sky130_fd_sc_hd__decap_3
XFILLER_13_744 VGND VGND VPWR VPWR sky130_fd_sc_hd__decap_3
XFILLER_40_530 VGND VGND VPWR VPWR sky130_fd_sc_hd__fill_2
XTAP_TAPCELL_ROW_84_1472 VGND VPWR sky130_fd_sc_hd__tapvpwrvgnd_1
XFILLER_13_777 VGND VGND VPWR VPWR sky130_fd_sc_hd__decap_3
XFILLER_9_715 VGND VGND VPWR VPWR sky130_fd_sc_hd__decap_3
XTAP_TAPCELL_ROW_30_709 VGND VPWR sky130_fd_sc_hd__tapvpwrvgnd_1
XFILLER_13_788 VGND VGND VPWR VPWR sky130_fd_sc_hd__decap_3
XFILLER_8_214 VGND VGND VPWR VPWR sky130_fd_sc_hd__decap_3
XFILLER_9_759 VGND VGND VPWR VPWR sky130_fd_sc_hd__decap_3
XFILLER_60_74 VGND VGND VPWR VPWR sky130_fd_sc_hd__fill_1
XTAP_TAPCELL_ROW_10_433 VGND VPWR sky130_fd_sc_hd__tapvpwrvgnd_1
XFILLER_126_613 VGND VGND VPWR VPWR sky130_fd_sc_hd__decap_3
XFILLER_5_36 VGND VGND VPWR VPWR sky130_fd_sc_hd__decap_3
XFILLER_99_508 VGND VGND VPWR VPWR sky130_fd_sc_hd__decap_3
XFILLER_4_475 VGND VGND VPWR VPWR sky130_fd_sc_hd__fill_1
XFILLER_4_486 VGND VGND VPWR VPWR sky130_fd_sc_hd__decap_3
XFILLER_5_69 VGND VGND VPWR VPWR sky130_fd_sc_hd__decap_3
XFILLER_106_381 VGND VGND VPWR VPWR sky130_fd_sc_hd__fill_2
XFILLER_134_690 VGND VGND VPWR VPWR sky130_fd_sc_hd__decap_3
XFILLER_69_72 VGND VGND VPWR VPWR sky130_fd_sc_hd__fill_1
XFILLER_79_210 VGND VGND VPWR VPWR sky130_fd_sc_hd__fill_2
XFILLER_121_340 VGND VGND VPWR VPWR sky130_fd_sc_hd__decap_3
XFILLER_69_94 VGND VGND VPWR VPWR sky130_fd_sc_hd__decap_3
XFILLER_79_243 VGND VGND VPWR VPWR sky130_fd_sc_hd__decap_3
XFILLER_121_373 VGND VGND VPWR VPWR sky130_fd_sc_hd__fill_2
XFILLER_94_224 VGND VGND VPWR VPWR sky130_fd_sc_hd__decap_3
XFILLER_10_6 VGND VGND VPWR VPWR sky130_fd_sc_hd__decap_3
XFILLER_48_652 VGND VGND VPWR VPWR sky130_fd_sc_hd__decap_3
XFILLER_47_184 VGND VGND VPWR VPWR sky130_fd_sc_hd__decap_3
XFILLER_62_110 VGND VGND VPWR VPWR sky130_fd_sc_hd__decap_3
XFILLER_63_644 VGND VGND VPWR VPWR sky130_fd_sc_hd__decap_3
XFILLER_23_508 VGND VGND VPWR VPWR sky130_fd_sc_hd__decap_3
XFILLER_35_379 VGND VGND VPWR VPWR sky130_fd_sc_hd__fill_2
XFILLER_62_165 VGND VGND VPWR VPWR sky130_fd_sc_hd__decap_3
XTAP_TAPCELL_ROW_18_544 VGND VPWR sky130_fd_sc_hd__tapvpwrvgnd_1
X_3971_ _7574_/Q _3800_/X _3970_/X _3958_/A _4000_/A VGND VGND VPWR VPWR _3971_/X
+ sky130_fd_sc_hd__o221a_2
XFILLER_50_327 VGND VGND VPWR VPWR sky130_fd_sc_hd__fill_2
X_5710_ _5710_/A VGND VGND VPWR VPWR _7895_/D sky130_fd_sc_hd__buf_1
XFILLER_93_3 VGND VGND VPWR VPWR sky130_fd_sc_hd__decap_3
X_6690_ _8391_/Q input7/X _6702_/S VGND VGND VPWR VPWR _6691_/A sky130_fd_sc_hd__mux2_2
X_5641_ _5641_/A VGND VGND VPWR VPWR _7863_/D sky130_fd_sc_hd__buf_1
X_8360_ _8765_/CLK _8360_/D load_slew582/X VGND VGND VPWR VPWR _8360_/Q sky130_fd_sc_hd__dfrtp_2
X_5572_ _5677_/S VGND VGND VPWR VPWR _5591_/S sky130_fd_sc_hd__buf_2
XFILLER_117_613 VGND VGND VPWR VPWR sky130_fd_sc_hd__decap_3
XFILLER_129_473 VGND VGND VPWR VPWR sky130_fd_sc_hd__decap_3
XFILLER_8_781 VGND VGND VPWR VPWR sky130_fd_sc_hd__decap_3
X_8291_ _8693_/CLK _8291_/D fanout743/X VGND VGND VPWR VPWR _8291_/Q sky130_fd_sc_hd__dfrtp_2
X_7311_ _8715_/Q input7/X _7323_/S VGND VGND VPWR VPWR _7312_/A sky130_fd_sc_hd__mux2_2
X_4523_ _7786_/Q _7867_/Q _7948_/Q _8029_/Q _4523_/S0 _4531_/S1 VGND VGND VPWR VPWR
+ _4523_/X sky130_fd_sc_hd__mux4_2
XFILLER_117_668 VGND VGND VPWR VPWR sky130_fd_sc_hd__decap_3
X_7242_ _7241_/X _4811_/X _7242_/A3 _7242_/B1 hold844/X VGND VGND VPWR VPWR _8670_/D
+ sky130_fd_sc_hd__a32o_2
XFILLER_132_616 VGND VGND VPWR VPWR sky130_fd_sc_hd__decap_3
X_4454_ _8437_/Q _8518_/Q _4454_/S VGND VGND VPWR VPWR _4455_/B sky130_fd_sc_hd__mux2_2
XFILLER_125_690 VGND VGND VPWR VPWR sky130_fd_sc_hd__decap_3
XFILLER_131_137 VGND VGND VPWR VPWR sky130_fd_sc_hd__decap_3
Xfanout705 fanout716/X VGND VGND VPWR VPWR fanout705/X sky130_fd_sc_hd__clkdlybuf4s25_1
X_7173_ _7173_/A VGND VGND VPWR VPWR _8619_/D sky130_fd_sc_hd__buf_2
X_4385_ _7774_/Q _7855_/Q _4435_/S VGND VGND VPWR VPWR _4386_/B sky130_fd_sc_hd__mux2_2
XTAP_TAPCELL_ROW_55_1062 VGND VPWR sky130_fd_sc_hd__tapvpwrvgnd_1
Xclkbuf_leaf_140_CLK clkbuf_5_4__f_CLK/X VGND VGND VPWR VPWR _8495_/CLK sky130_fd_sc_hd__clkbuf_8
Xfanout716 fanout754/X VGND VGND VPWR VPWR fanout716/X sky130_fd_sc_hd__clkdlybuf4s25_1
Xfanout749 fanout749/A VGND VGND VPWR VPWR fanout749/X sky130_fd_sc_hd__clkdlybuf4s25_1
X_6124_ _6124_/A VGND VGND VPWR VPWR _8126_/D sky130_fd_sc_hd__buf_1
XFILLER_105_26 VGND VGND VPWR VPWR sky130_fd_sc_hd__fill_1
X_6055_ _6139_/S VGND VGND VPWR VPWR _6074_/S sky130_fd_sc_hd__buf_2
XFILLER_86_769 VGND VGND VPWR VPWR sky130_fd_sc_hd__decap_3
X_5006_ input8/X _5026_/B VGND VGND VPWR VPWR _5007_/A sky130_fd_sc_hd__and2_2
XFILLER_100_579 VGND VGND VPWR VPWR sky130_fd_sc_hd__fill_2
XFILLER_121_14 VGND VGND VPWR VPWR sky130_fd_sc_hd__decap_3
XFILLER_26_324 VGND VGND VPWR VPWR sky130_fd_sc_hd__decap_3
XFILLER_38_184 VGND VGND VPWR VPWR sky130_fd_sc_hd__decap_3
XFILLER_38_195 VGND VGND VPWR VPWR sky130_fd_sc_hd__fill_1
XFILLER_54_633 VGND VGND VPWR VPWR sky130_fd_sc_hd__decap_3
XFILLER_121_47 VGND VGND VPWR VPWR sky130_fd_sc_hd__decap_3
XFILLER_53_143 VGND VGND VPWR VPWR sky130_fd_sc_hd__fill_1
XFILLER_54_666 VGND VGND VPWR VPWR sky130_fd_sc_hd__decap_3
XFILLER_81_452 VGND VGND VPWR VPWR sky130_fd_sc_hd__fill_2
XFILLER_81_463 VGND VGND VPWR VPWR sky130_fd_sc_hd__fill_2
X_6957_ _6957_/A VGND VGND VPWR VPWR _8517_/D sky130_fd_sc_hd__buf_6
XFILLER_41_349 VGND VGND VPWR VPWR sky130_fd_sc_hd__decap_3
XFILLER_53_187 VGND VGND VPWR VPWR sky130_fd_sc_hd__decap_3
XFILLER_81_29 VGND VGND VPWR VPWR sky130_fd_sc_hd__decap_3
XFILLER_14_12 VGND VGND VPWR VPWR sky130_fd_sc_hd__decap_3
XFILLER_22_541 VGND VGND VPWR VPWR sky130_fd_sc_hd__fill_1
X_6888_ _6888_/A VGND VGND VPWR VPWR _8484_/D sky130_fd_sc_hd__buf_6
X_5908_ _5947_/A VGND VGND VPWR VPWR _5908_/X sky130_fd_sc_hd__clkbuf_1
XFILLER_10_725 VGND VGND VPWR VPWR sky130_fd_sc_hd__decap_3
XFILLER_14_56 VGND VGND VPWR VPWR sky130_fd_sc_hd__decap_3
X_8627_ _8627_/CLK _8627_/D load_slew671/X VGND VGND VPWR VPWR _8627_/Q sky130_fd_sc_hd__dfrtp_2
X_5839_ _5839_/A0 _4921_/A _5847_/S VGND VGND VPWR VPWR _5840_/A sky130_fd_sc_hd__mux2_2
XFILLER_10_769 VGND VGND VPWR VPWR sky130_fd_sc_hd__decap_3
XFILLER_6_707 VGND VGND VPWR VPWR sky130_fd_sc_hd__decap_3
X_8558_ _8639_/CLK _8558_/D fanout606/X VGND VGND VPWR VPWR _8558_/Q sky130_fd_sc_hd__dfrtp_2
X_7509_ _8746_/CLK _7509_/D load_slew526/X VGND VGND VPWR VPWR _7509_/Q sky130_fd_sc_hd__dfrtp_2
XFILLER_135_432 VGND VGND VPWR VPWR sky130_fd_sc_hd__decap_3
X_8489_ _8732_/CLK _8489_/D fanout479/A VGND VGND VPWR VPWR _8489_/Q sky130_fd_sc_hd__dfrtp_2
XFILLER_107_156 VGND VGND VPWR VPWR sky130_fd_sc_hd__decap_3
XFILLER_107_178 VGND VGND VPWR VPWR sky130_fd_sc_hd__decap_3
XFILLER_107_189 VGND VGND VPWR VPWR sky130_fd_sc_hd__decap_3
XFILLER_122_115 VGND VGND VPWR VPWR sky130_fd_sc_hd__decap_3
Xhold770 _7993_/Q VGND VGND VPWR VPWR hold770/X sky130_fd_sc_hd__dlygate4sd3_1
Xhold781 _7970_/Q VGND VGND VPWR VPWR hold781/X sky130_fd_sc_hd__dlygate4sd3_1
Xclkbuf_leaf_131_CLK clkbuf_5_6__f_CLK/X VGND VGND VPWR VPWR _8658_/CLK sky130_fd_sc_hd__clkbuf_8
Xhold792 _8666_/Q VGND VGND VPWR VPWR hold792/X sky130_fd_sc_hd__dlygate4sd3_1
XFILLER_131_671 VGND VGND VPWR VPWR sky130_fd_sc_hd__fill_1
XFILLER_131_682 VGND VGND VPWR VPWR sky130_fd_sc_hd__decap_3
XFILLER_39_75 VGND VGND VPWR VPWR sky130_fd_sc_hd__decap_3
XFILLER_49_438 VGND VGND VPWR VPWR sky130_fd_sc_hd__decap_3
XFILLER_49_449 VGND VGND VPWR VPWR sky130_fd_sc_hd__decap_3
XFILLER_76_224 VGND VGND VPWR VPWR sky130_fd_sc_hd__decap_3
XFILLER_77_747 VGND VGND VPWR VPWR sky130_fd_sc_hd__fill_2
XFILLER_89_585 VGND VGND VPWR VPWR sky130_fd_sc_hd__decap_3
XFILLER_130_192 VGND VGND VPWR VPWR sky130_fd_sc_hd__decap_3
XFILLER_76_246 VGND VGND VPWR VPWR sky130_fd_sc_hd__decap_3
XFILLER_76_268 VGND VGND VPWR VPWR sky130_fd_sc_hd__decap_3
XFILLER_77_769 VGND VGND VPWR VPWR sky130_fd_sc_hd__fill_1
XFILLER_45_611 VGND VGND VPWR VPWR sky130_fd_sc_hd__decap_3
XFILLER_64_419 VGND VGND VPWR VPWR sky130_fd_sc_hd__fill_1
XFILLER_91_205 VGND VGND VPWR VPWR sky130_fd_sc_hd__fill_1
XTAP_TAPCELL_ROW_86_1501 VGND VPWR sky130_fd_sc_hd__tapvpwrvgnd_1
XFILLER_29_184 VGND VGND VPWR VPWR sky130_fd_sc_hd__fill_1
XFILLER_17_368 VGND VGND VPWR VPWR sky130_fd_sc_hd__decap_3
XFILLER_55_85 VGND VGND VPWR VPWR sky130_fd_sc_hd__decap_3
XFILLER_72_474 VGND VGND VPWR VPWR sky130_fd_sc_hd__fill_2
XFILLER_45_699 VGND VGND VPWR VPWR sky130_fd_sc_hd__decap_3
XTAP_TAPCELL_ROW_15_503 VGND VPWR sky130_fd_sc_hd__tapvpwrvgnd_1
XFILLER_13_541 VGND VGND VPWR VPWR sky130_fd_sc_hd__decap_3
XTAP_TAPCELL_ROW_43_889 VGND VPWR sky130_fd_sc_hd__tapvpwrvgnd_1
XFILLER_71_95 VGND VGND VPWR VPWR sky130_fd_sc_hd__decap_3
XFILLER_9_567 VGND VGND VPWR VPWR sky130_fd_sc_hd__decap_3
XFILLER_126_421 VGND VGND VPWR VPWR sky130_fd_sc_hd__decap_3
XTAP_TAPCELL_ROW_97_1652 VGND VPWR sky130_fd_sc_hd__tapvpwrvgnd_1
XFILLER_126_454 VGND VGND VPWR VPWR sky130_fd_sc_hd__decap_3
XFILLER_114_627 VGND VGND VPWR VPWR sky130_fd_sc_hd__decap_3
XFILLER_5_762 VGND VGND VPWR VPWR sky130_fd_sc_hd__decap_3
XFILLER_4_294 VGND VGND VPWR VPWR sky130_fd_sc_hd__fill_1
XFILLER_95_500 VGND VGND VPWR VPWR sky130_fd_sc_hd__decap_3
Xclkbuf_leaf_122_CLK clkbuf_5_17__f_CLK/X VGND VGND VPWR VPWR _8747_/CLK sky130_fd_sc_hd__clkbuf_8
X_4170_ _4198_/A _4170_/B VGND VGND VPWR VPWR _4170_/X sky130_fd_sc_hd__or2_2
XFILLER_95_533 VGND VGND VPWR VPWR sky130_fd_sc_hd__fill_2
XFILLER_121_192 VGND VGND VPWR VPWR sky130_fd_sc_hd__decap_3
XFILLER_96_81 VGND VGND VPWR VPWR sky130_fd_sc_hd__decap_3
XFILLER_95_588 VGND VGND VPWR VPWR sky130_fd_sc_hd__decap_3
XTAP_TAPCELL_ROW_124_2026 VGND VPWR sky130_fd_sc_hd__tapvpwrvgnd_1
X_7860_ _8761_/CLK _7860_/D fanout708/X VGND VGND VPWR VPWR _7860_/Q sky130_fd_sc_hd__dfrtp_2
XFILLER_36_666 VGND VGND VPWR VPWR sky130_fd_sc_hd__fill_1
XFILLER_63_452 VGND VGND VPWR VPWR sky130_fd_sc_hd__decap_3
XFILLER_91_783 VGND VGND VPWR VPWR sky130_fd_sc_hd__fill_1
X_6811_ _6811_/A VGND VGND VPWR VPWR _8448_/D sky130_fd_sc_hd__buf_2
XTAP_TAPCELL_ROW_106_1770 VGND VPWR sky130_fd_sc_hd__tapvpwrvgnd_1
XTAP_TAPCELL_ROW_106_1781 VGND VPWR sky130_fd_sc_hd__tapvpwrvgnd_1
X_7791_ _8698_/CLK _7791_/D load_slew740/X VGND VGND VPWR VPWR _7791_/Q sky130_fd_sc_hd__dfrtp_2
X_3954_ _3954_/A VGND VGND VPWR VPWR _3954_/X sky130_fd_sc_hd__buf_1
X_6742_ _8416_/Q _4764_/A _6744_/S VGND VGND VPWR VPWR _6743_/A sky130_fd_sc_hd__mux2_2
X_3885_ _8630_/Q _4326_/B _3805_/A _8549_/Q _4328_/C1 VGND VGND VPWR VPWR _3885_/X
+ sky130_fd_sc_hd__o221a_2
X_6673_ _8383_/Q _4968_/A _6681_/S VGND VGND VPWR VPWR _6674_/A sky130_fd_sc_hd__mux2_2
XFILLER_31_393 VGND VGND VPWR VPWR sky130_fd_sc_hd__decap_3
X_8412_ _8493_/CLK _8412_/D fanout479/X VGND VGND VPWR VPWR _8412_/Q sky130_fd_sc_hd__dfrtp_2
X_5624_ _5624_/A VGND VGND VPWR VPWR _7855_/D sky130_fd_sc_hd__buf_1
XFILLER_129_270 VGND VGND VPWR VPWR sky130_fd_sc_hd__decap_3
X_8343_ _8748_/CLK _8343_/D fanout542/X VGND VGND VPWR VPWR _8343_/Q sky130_fd_sc_hd__dfrtp_2
XFILLER_117_421 VGND VGND VPWR VPWR sky130_fd_sc_hd__decap_3
XFILLER_129_281 VGND VGND VPWR VPWR sky130_fd_sc_hd__decap_3
XTAP_TAPCELL_ROW_135_2177 VGND VPWR sky130_fd_sc_hd__tapvpwrvgnd_1
XTAP_TAPCELL_ROW_135_2188 VGND VPWR sky130_fd_sc_hd__tapvpwrvgnd_1
XTAP_TAPCELL_ROW_135_2199 VGND VPWR sky130_fd_sc_hd__tapvpwrvgnd_1
X_5555_ _5555_/A VGND VGND VPWR VPWR _7822_/D sky130_fd_sc_hd__buf_1
X_8274_ _8274_/CLK _8274_/D fanout697/X VGND VGND VPWR VPWR _8274_/Q sky130_fd_sc_hd__dfrtp_2
X_5486_ _5486_/A VGND VGND VPWR VPWR _7790_/D sky130_fd_sc_hd__buf_1
X_4506_ _4503_/X _4504_/X _4505_/X _4591_/S VGND VGND VPWR VPWR _4506_/X sky130_fd_sc_hd__a22o_2
XFILLER_104_137 VGND VGND VPWR VPWR sky130_fd_sc_hd__decap_3
XFILLER_132_424 VGND VGND VPWR VPWR sky130_fd_sc_hd__decap_3
X_7225_ wire234/X _4757_/X wire175/X wire205/X hold802/X VGND VGND VPWR VPWR _8657_/D
+ sky130_fd_sc_hd__a32o_2
X_4437_ _4442_/A _4435_/X _4436_/X VGND VGND VPWR VPWR _4437_/X sky130_fd_sc_hd__o21a_2
XFILLER_132_457 VGND VGND VPWR VPWR sky130_fd_sc_hd__decap_3
Xclkbuf_leaf_113_CLK clkbuf_5_17__f_CLK/X VGND VGND VPWR VPWR _8427_/CLK sky130_fd_sc_hd__clkbuf_8
Xfanout502 fanout502/A VGND VGND VPWR VPWR fanout502/X sky130_fd_sc_hd__clkdlybuf4s25_1
X_7156_ _4903_/X _8611_/Q _7172_/S VGND VGND VPWR VPWR _7157_/A sky130_fd_sc_hd__mux2_2
XFILLER_113_671 VGND VGND VPWR VPWR sky130_fd_sc_hd__fill_1
XFILLER_58_213 VGND VGND VPWR VPWR sky130_fd_sc_hd__decap_3
XFILLER_76_29 VGND VGND VPWR VPWR sky130_fd_sc_hd__decap_3
XFILLER_86_522 VGND VGND VPWR VPWR sky130_fd_sc_hd__fill_1
XFILLER_86_533 VGND VGND VPWR VPWR sky130_fd_sc_hd__decap_3
XFILLER_98_371 VGND VGND VPWR VPWR sky130_fd_sc_hd__decap_3
Xfanout535 fanout539/X VGND VGND VPWR VPWR fanout535/X sky130_fd_sc_hd__clkdlybuf4s25_1
Xfanout546 fanout548/X VGND VGND VPWR VPWR wire547/A sky130_fd_sc_hd__clkdlybuf4s25_1
Xfanout557 fanout559/X VGND VGND VPWR VPWR fanout557/X sky130_fd_sc_hd__clkdlybuf4s25_1
X_6107_ _6107_/A VGND VGND VPWR VPWR _8118_/D sky130_fd_sc_hd__buf_1
X_4368_ _4368_/A _4368_/B VGND VGND VPWR VPWR _4368_/X sky130_fd_sc_hd__or2_2
XFILLER_100_321 VGND VGND VPWR VPWR sky130_fd_sc_hd__fill_1
XFILLER_100_343 VGND VGND VPWR VPWR sky130_fd_sc_hd__decap_3
XFILLER_112_192 VGND VGND VPWR VPWR sky130_fd_sc_hd__decap_3
XFILLER_58_235 VGND VGND VPWR VPWR sky130_fd_sc_hd__decap_3
XFILLER_86_555 VGND VGND VPWR VPWR sky130_fd_sc_hd__decap_3
X_7087_ _7087_/A VGND VGND VPWR VPWR _8578_/D sky130_fd_sc_hd__buf_2
X_4299_ _3739_/B _4297_/X _4298_/X VGND VGND VPWR VPWR _4299_/X sky130_fd_sc_hd__o21a_2
XFILLER_132_24 VGND VGND VPWR VPWR sky130_fd_sc_hd__decap_3
XFILLER_132_35 VGND VGND VPWR VPWR sky130_fd_sc_hd__decap_3
X_6038_ _6038_/A VGND VGND VPWR VPWR _8085_/D sky130_fd_sc_hd__buf_1
XFILLER_132_68 VGND VGND VPWR VPWR sky130_fd_sc_hd__decap_3
XFILLER_39_482 VGND VGND VPWR VPWR sky130_fd_sc_hd__fill_2
XFILLER_54_430 VGND VGND VPWR VPWR sky130_fd_sc_hd__decap_3
XFILLER_54_441 VGND VGND VPWR VPWR sky130_fd_sc_hd__decap_3
XFILLER_82_750 VGND VGND VPWR VPWR sky130_fd_sc_hd__decap_3
XTAP_TAPCELL_ROW_68_1242 VGND VPWR sky130_fd_sc_hd__tapvpwrvgnd_1
XFILLER_14_305 VGND VGND VPWR VPWR sky130_fd_sc_hd__decap_3
XFILLER_25_33 VGND VGND VPWR VPWR sky130_fd_sc_hd__decap_3
XFILLER_41_113 VGND VGND VPWR VPWR sky130_fd_sc_hd__decap_3
XFILLER_42_625 VGND VGND VPWR VPWR sky130_fd_sc_hd__decap_3
XFILLER_54_474 VGND VGND VPWR VPWR sky130_fd_sc_hd__fill_2
X_7989_ _8727_/CLK _7989_/D load_slew533/X VGND VGND VPWR VPWR _7989_/Q sky130_fd_sc_hd__dfrtp_2
XFILLER_25_66 VGND VGND VPWR VPWR sky130_fd_sc_hd__decap_3
XFILLER_41_157 VGND VGND VPWR VPWR sky130_fd_sc_hd__decap_3
XTAP_TAPCELL_ROW_81_1420 VGND VPWR sky130_fd_sc_hd__tapvpwrvgnd_1
XTAP_TAPCELL_ROW_81_1431 VGND VPWR sky130_fd_sc_hd__tapvpwrvgnd_1
XFILLER_22_371 VGND VGND VPWR VPWR sky130_fd_sc_hd__decap_3
XFILLER_128_719 VGND VGND VPWR VPWR sky130_fd_sc_hd__decap_3
XTAP_TAPCELL_ROW_40_848 VGND VPWR sky130_fd_sc_hd__tapvpwrvgnd_1
XTAP_TAPCELL_ROW_40_859 VGND VPWR sky130_fd_sc_hd__tapvpwrvgnd_1
XFILLER_127_218 VGND VGND VPWR VPWR sky130_fd_sc_hd__decap_3
XFILLER_41_54 VGND VGND VPWR VPWR sky130_fd_sc_hd__fill_2
XFILLER_108_421 VGND VGND VPWR VPWR sky130_fd_sc_hd__decap_3
XFILLER_41_87 VGND VGND VPWR VPWR sky130_fd_sc_hd__decap_3
XFILLER_6_559 VGND VGND VPWR VPWR sky130_fd_sc_hd__decap_3
XTAP_TAPCELL_ROW_20_572 VGND VPWR sky130_fd_sc_hd__tapvpwrvgnd_1
XFILLER_135_240 VGND VGND VPWR VPWR sky130_fd_sc_hd__decap_3
XFILLER_135_262 VGND VGND VPWR VPWR sky130_fd_sc_hd__decap_3
XTAP_TAPCELL_ROW_79_1393 VGND VPWR sky130_fd_sc_hd__tapvpwrvgnd_1
XFILLER_123_446 VGND VGND VPWR VPWR sky130_fd_sc_hd__fill_2
XFILLER_2_710 VGND VGND VPWR VPWR sky130_fd_sc_hd__decap_3
XFILLER_123_479 VGND VGND VPWR VPWR sky130_fd_sc_hd__decap_3
XFILLER_2_743 VGND VGND VPWR VPWR sky130_fd_sc_hd__decap_3
XTAP_TAPCELL_ROW_92_1582 VGND VPWR sky130_fd_sc_hd__tapvpwrvgnd_1
Xclkbuf_leaf_104_CLK clkload8/A VGND VGND VPWR VPWR _8623_/CLK sky130_fd_sc_hd__clkbuf_8
XFILLER_2_15 VGND VGND VPWR VPWR sky130_fd_sc_hd__decap_3
XFILLER_2_787 VGND VGND VPWR VPWR sky130_fd_sc_hd__decap_3
XFILLER_89_371 VGND VGND VPWR VPWR sky130_fd_sc_hd__fill_1
XFILLER_103_181 VGND VGND VPWR VPWR sky130_fd_sc_hd__fill_1
XFILLER_2_59 VGND VGND VPWR VPWR sky130_fd_sc_hd__decap_3
XFILLER_89_393 VGND VGND VPWR VPWR sky130_fd_sc_hd__decap_3
XFILLER_37_408 VGND VGND VPWR VPWR sky130_fd_sc_hd__decap_3
XFILLER_49_279 VGND VGND VPWR VPWR sky130_fd_sc_hd__fill_1
XFILLER_66_51 VGND VGND VPWR VPWR sky130_fd_sc_hd__decap_3
XTAP_TAPCELL_ROW_48_959 VGND VPWR sky130_fd_sc_hd__tapvpwrvgnd_1
XFILLER_17_143 VGND VGND VPWR VPWR sky130_fd_sc_hd__decap_3
XFILLER_45_452 VGND VGND VPWR VPWR sky130_fd_sc_hd__decap_3
XFILLER_73_750 VGND VGND VPWR VPWR sky130_fd_sc_hd__decap_3
XFILLER_17_165 VGND VGND VPWR VPWR sky130_fd_sc_hd__decap_3
XTAP_TAPCELL_ROW_28_683 VGND VPWR sky130_fd_sc_hd__tapvpwrvgnd_1
XFILLER_33_647 VGND VGND VPWR VPWR sky130_fd_sc_hd__decap_3
XFILLER_72_293 VGND VGND VPWR VPWR sky130_fd_sc_hd__decap_3
XFILLER_82_83 VGND VGND VPWR VPWR sky130_fd_sc_hd__fill_1
XFILLER_60_477 VGND VGND VPWR VPWR sky130_fd_sc_hd__decap_3
XFILLER_82_94 VGND VGND VPWR VPWR sky130_fd_sc_hd__decap_3
XFILLER_41_691 VGND VGND VPWR VPWR sky130_fd_sc_hd__decap_3
XFILLER_9_320 VGND VGND VPWR VPWR sky130_fd_sc_hd__decap_3
XFILLER_127_741 VGND VGND VPWR VPWR sky130_fd_sc_hd__decap_3
XFILLER_127_774 VGND VGND VPWR VPWR sky130_fd_sc_hd__decap_3
XFILLER_127_785 VGND VGND VPWR VPWR sky130_fd_sc_hd__decap_3
Xoutput116 _4191_/X VGND VGND VPWR VPWR rdata[36] sky130_fd_sc_hd__clkdlybuf4s25_1
Xoutput105 _4086_/X VGND VGND VPWR VPWR rdata[26] sky130_fd_sc_hd__clkdlybuf4s25_1
X_5340_ _7721_/Q _4952_/A _5356_/S VGND VGND VPWR VPWR _5341_/A sky130_fd_sc_hd__mux2_2
XFILLER_114_424 VGND VGND VPWR VPWR sky130_fd_sc_hd__decap_3
XFILLER_126_273 VGND VGND VPWR VPWR sky130_fd_sc_hd__decap_3
XFILLER_5_570 VGND VGND VPWR VPWR sky130_fd_sc_hd__fill_2
Xoutput127 _4301_/X VGND VGND VPWR VPWR rdata[46] sky130_fd_sc_hd__clkdlybuf4s25_1
Xoutput138 _4419_/X VGND VGND VPWR VPWR rdata[56] sky130_fd_sc_hd__clkdlybuf4s25_1
Xoutput149 _4527_/X VGND VGND VPWR VPWR rdata[66] sky130_fd_sc_hd__clkdlybuf4s25_1
X_5271_ _7689_/Q _4815_/X _5289_/S VGND VGND VPWR VPWR _5272_/A sky130_fd_sc_hd__mux2_2
X_7010_ _7010_/A VGND VGND VPWR VPWR _8541_/D sky130_fd_sc_hd__buf_2
X_4222_ _8093_/Q _8174_/Q _8255_/Q _8336_/Q _4226_/S _4227_/A VGND VGND VPWR VPWR
+ _4222_/X sky130_fd_sc_hd__mux4_2
XTAP_TAPCELL_ROW_52_1021 VGND VPWR sky130_fd_sc_hd__tapvpwrvgnd_1
XFILLER_110_641 VGND VGND VPWR VPWR sky130_fd_sc_hd__decap_3
XFILLER_68_533 VGND VGND VPWR VPWR sky130_fd_sc_hd__fill_1
XFILLER_95_330 VGND VGND VPWR VPWR sky130_fd_sc_hd__decap_3
X_4153_ _8411_/Q _8492_/Q _8573_/Q _8654_/Q _4150_/S _4146_/A VGND VGND VPWR VPWR
+ _4153_/X sky130_fd_sc_hd__mux4_2
XFILLER_110_663 VGND VGND VPWR VPWR sky130_fd_sc_hd__decap_3
XFILLER_95_385 VGND VGND VPWR VPWR sky130_fd_sc_hd__fill_1
X_4084_ _8080_/Q _8161_/Q _8242_/Q _8323_/Q _4494_/S _4082_/A VGND VGND VPWR VPWR
+ _4084_/X sky130_fd_sc_hd__mux4_2
XTAP_TAPCELL_ROW_108_1810 VGND VPWR sky130_fd_sc_hd__tapvpwrvgnd_1
X_7912_ _8655_/CLK _7912_/D load_slew484/X VGND VGND VPWR VPWR _7912_/Q sky130_fd_sc_hd__dfrtp_2
XFILLER_70_208 VGND VGND VPWR VPWR sky130_fd_sc_hd__fill_2
XFILLER_102_38 VGND VGND VPWR VPWR sky130_fd_sc_hd__decap_3
XFILLER_23_113 VGND VGND VPWR VPWR sky130_fd_sc_hd__fill_1
X_7843_ _8744_/CLK _7843_/D load_slew626/X VGND VGND VPWR VPWR _7843_/Q sky130_fd_sc_hd__dfrtp_2
X_7774_ _8679_/CLK _7774_/D wire701/X VGND VGND VPWR VPWR _7774_/Q sky130_fd_sc_hd__dfrtp_2
X_4986_ _4985_/X _7567_/Q _4986_/S VGND VGND VPWR VPWR _4987_/A sky130_fd_sc_hd__mux2_2
XFILLER_11_319 VGND VGND VPWR VPWR sky130_fd_sc_hd__fill_2
X_3937_ _8391_/Q _8472_/Q _4454_/S VGND VGND VPWR VPWR _3938_/B sky130_fd_sc_hd__mux2_2
X_6725_ _6830_/S VGND VGND VPWR VPWR _6744_/S sky130_fd_sc_hd__buf_2
XTAP_TAPCELL_ROW_63_1172 VGND VPWR sky130_fd_sc_hd__tapvpwrvgnd_1
XFILLER_127_9 VGND VGND VPWR VPWR sky130_fd_sc_hd__decap_3
X_3868_ _8710_/Q _8791_/Q _3868_/S VGND VGND VPWR VPWR _3869_/B sky130_fd_sc_hd__mux2_2
X_6656_ _4941_/X _8377_/Q _6656_/S VGND VGND VPWR VPWR _6657_/A sky130_fd_sc_hd__mux2_2
XFILLER_118_730 VGND VGND VPWR VPWR sky130_fd_sc_hd__decap_3
XFILLER_11_24 VGND VGND VPWR VPWR sky130_fd_sc_hd__decap_3
XTAP_TAPCELL_ROW_119_1961 VGND VPWR sky130_fd_sc_hd__tapvpwrvgnd_1
X_3799_ _3921_/A VGND VGND VPWR VPWR _3799_/X sky130_fd_sc_hd__clkbuf_2
X_6587_ _4803_/X _8344_/Q _6591_/S VGND VGND VPWR VPWR _6588_/A sky130_fd_sc_hd__mux2_2
X_5607_ _5607_/A VGND VGND VPWR VPWR _7847_/D sky130_fd_sc_hd__buf_1
XFILLER_118_763 VGND VGND VPWR VPWR sky130_fd_sc_hd__decap_3
XFILLER_11_57 VGND VGND VPWR VPWR sky130_fd_sc_hd__decap_3
XFILLER_127_24 VGND VGND VPWR VPWR sky130_fd_sc_hd__decap_3
XFILLER_133_700 VGND VGND VPWR VPWR sky130_fd_sc_hd__decap_3
X_8326_ _8569_/CLK _8326_/D load_slew494/X VGND VGND VPWR VPWR _8326_/Q sky130_fd_sc_hd__dfrtp_2
X_5538_ _5538_/A VGND VGND VPWR VPWR _7814_/D sky130_fd_sc_hd__buf_1
XFILLER_127_57 VGND VGND VPWR VPWR sky130_fd_sc_hd__decap_3
XFILLER_132_221 VGND VGND VPWR VPWR sky130_fd_sc_hd__decap_3
XFILLER_133_744 VGND VGND VPWR VPWR sky130_fd_sc_hd__decap_3
X_8257_ _8734_/CLK _8257_/D load_slew521/X VGND VGND VPWR VPWR _8257_/Q sky130_fd_sc_hd__dfrtp_2
XFILLER_133_777 VGND VGND VPWR VPWR sky130_fd_sc_hd__decap_3
XFILLER_133_788 VGND VGND VPWR VPWR sky130_fd_sc_hd__decap_3
XFILLER_87_17 VGND VGND VPWR VPWR sky130_fd_sc_hd__fill_1
X_7208_ _7213_/A1 _4691_/X _7216_/A3 _7216_/B1 hold816/X VGND VGND VPWR VPWR _8643_/D
+ sky130_fd_sc_hd__a32o_2
X_5469_ _5469_/A VGND VGND VPWR VPWR _7782_/D sky130_fd_sc_hd__buf_1
XFILLER_120_405 VGND VGND VPWR VPWR sky130_fd_sc_hd__decap_3
XFILLER_120_427 VGND VGND VPWR VPWR sky130_fd_sc_hd__decap_3
XFILLER_132_265 VGND VGND VPWR VPWR sky130_fd_sc_hd__decap_3
Xfanout321 _4672_/S VGND VGND VPWR VPWR _3831_/A sky130_fd_sc_hd__clkdlybuf4s25_1
X_8188_ _8530_/CLK _8188_/D load_slew738/X VGND VGND VPWR VPWR _8188_/Q sky130_fd_sc_hd__dfrtp_2
XFILLER_132_298 VGND VGND VPWR VPWR sky130_fd_sc_hd__decap_3
Xfanout343 fanout344/X VGND VGND VPWR VPWR _4146_/A sky130_fd_sc_hd__clkdlybuf4s25_1
Xfanout354 fanout364/X VGND VGND VPWR VPWR _4524_/S1 sky130_fd_sc_hd__clkdlybuf4s25_1
Xfanout365 _4330_/A VGND VGND VPWR VPWR _4273_/A sky130_fd_sc_hd__clkdlybuf4s25_1
X_7139_ _4871_/X _8603_/Q _7151_/S VGND VGND VPWR VPWR _7140_/A sky130_fd_sc_hd__mux2_2
XFILLER_101_652 VGND VGND VPWR VPWR sky130_fd_sc_hd__decap_3
XFILLER_59_588 VGND VGND VPWR VPWR sky130_fd_sc_hd__fill_1
XTAP_TAPCELL_ROW_6_378 VGND VPWR sky130_fd_sc_hd__tapvpwrvgnd_1
Xfanout376 _3862_/A VGND VGND VPWR VPWR _3755_/S1 sky130_fd_sc_hd__clkdlybuf4s25_1
Xfanout398 _4110_/S0 VGND VGND VPWR VPWR _4106_/S0 sky130_fd_sc_hd__clkdlybuf4s25_1
XFILLER_46_227 VGND VGND VPWR VPWR sky130_fd_sc_hd__decap_3
XFILLER_27_441 VGND VGND VPWR VPWR sky130_fd_sc_hd__fill_1
XFILLER_36_32 VGND VGND VPWR VPWR sky130_fd_sc_hd__decap_3
XTAP_TAPCELL_ROW_45_918 VGND VPWR sky130_fd_sc_hd__tapvpwrvgnd_1
XFILLER_15_614 VGND VGND VPWR VPWR sky130_fd_sc_hd__fill_2
XFILLER_27_496 VGND VGND VPWR VPWR sky130_fd_sc_hd__decap_3
XFILLER_42_411 VGND VGND VPWR VPWR sky130_fd_sc_hd__decap_3
XFILLER_54_271 VGND VGND VPWR VPWR sky130_fd_sc_hd__decap_3
XFILLER_55_783 VGND VGND VPWR VPWR sky130_fd_sc_hd__fill_1
XFILLER_70_731 VGND VGND VPWR VPWR sky130_fd_sc_hd__fill_1
XTAP_TAPCELL_ROW_45_929 VGND VPWR sky130_fd_sc_hd__tapvpwrvgnd_1
XFILLER_70_742 VGND VGND VPWR VPWR sky130_fd_sc_hd__decap_3
XTAP_TAPCELL_ROW_25_642 VGND VPWR sky130_fd_sc_hd__tapvpwrvgnd_1
XFILLER_10_352 VGND VGND VPWR VPWR sky130_fd_sc_hd__decap_3
XFILLER_128_516 VGND VGND VPWR VPWR sky130_fd_sc_hd__decap_3
Xinput18 wdata[23] VGND VGND VPWR VPWR _4702_/A sky130_fd_sc_hd__clkdlybuf4s25_1
XFILLER_10_374 VGND VGND VPWR VPWR sky130_fd_sc_hd__decap_3
XFILLER_6_312 VGND VGND VPWR VPWR sky130_fd_sc_hd__decap_3
Xinput29 wdata[33] VGND VGND VPWR VPWR _4744_/A sky130_fd_sc_hd__clkdlybuf4s25_1
XFILLER_109_785 VGND VGND VPWR VPWR sky130_fd_sc_hd__decap_3
XFILLER_6_345 VGND VGND VPWR VPWR sky130_fd_sc_hd__decap_3
XTAP_TAPCELL_ROW_94_1611 VGND VPWR sky130_fd_sc_hd__tapvpwrvgnd_1
XFILLER_108_273 VGND VGND VPWR VPWR sky130_fd_sc_hd__decap_3
XFILLER_124_766 VGND VGND VPWR VPWR sky130_fd_sc_hd__decap_3
XFILLER_97_617 VGND VGND VPWR VPWR sky130_fd_sc_hd__decap_3
XFILLER_111_416 VGND VGND VPWR VPWR sky130_fd_sc_hd__decap_3
XFILLER_123_287 VGND VGND VPWR VPWR sky130_fd_sc_hd__decap_3
XFILLER_96_105 VGND VGND VPWR VPWR sky130_fd_sc_hd__fill_1
Xload_slew738 fanout737/X VGND VGND VPWR VPWR load_slew738/X sky130_fd_sc_hd__buf_4
Xload_slew727 fanout726/X VGND VGND VPWR VPWR load_slew727/X sky130_fd_sc_hd__buf_4
XFILLER_2_595 VGND VGND VPWR VPWR sky130_fd_sc_hd__decap_3
XFILLER_38_728 VGND VGND VPWR VPWR sky130_fd_sc_hd__decap_3
XFILLER_65_514 VGND VGND VPWR VPWR sky130_fd_sc_hd__decap_3
XFILLER_77_363 VGND VGND VPWR VPWR sky130_fd_sc_hd__fill_2
XFILLER_93_801 VGND VGND VPWR VPWR sky130_fd_sc_hd__decap_3
XFILLER_65_547 VGND VGND VPWR VPWR sky130_fd_sc_hd__decap_3
XFILLER_46_750 VGND VGND VPWR VPWR sky130_fd_sc_hd__decap_3
XFILLER_46_761 VGND VGND VPWR VPWR sky130_fd_sc_hd__decap_3
XFILLER_93_60 VGND VGND VPWR VPWR sky130_fd_sc_hd__decap_3
XFILLER_18_474 VGND VGND VPWR VPWR sky130_fd_sc_hd__fill_2
XFILLER_92_399 VGND VGND VPWR VPWR sky130_fd_sc_hd__decap_3
XFILLER_33_433 VGND VGND VPWR VPWR sky130_fd_sc_hd__decap_3
XFILLER_33_455 VGND VGND VPWR VPWR sky130_fd_sc_hd__decap_3
XFILLER_61_753 VGND VGND VPWR VPWR sky130_fd_sc_hd__decap_3
X_4840_ _4840_/A _4852_/B VGND VGND VPWR VPWR _4841_/A sky130_fd_sc_hd__and2_2
XFILLER_21_606 VGND VGND VPWR VPWR sky130_fd_sc_hd__fill_1
XTAP_TAPCELL_ROW_103_1740 VGND VPWR sky130_fd_sc_hd__tapvpwrvgnd_1
XFILLER_20_116 VGND VGND VPWR VPWR sky130_fd_sc_hd__fill_1
XFILLER_20_138 VGND VGND VPWR VPWR sky130_fd_sc_hd__fill_2
XFILLER_33_499 VGND VGND VPWR VPWR sky130_fd_sc_hd__fill_2
X_6510_ _4989_/X _8307_/Q _6528_/S VGND VGND VPWR VPWR _6511_/A sky130_fd_sc_hd__mux2_2
X_4771_ _4771_/A VGND VGND VPWR VPWR _7516_/D sky130_fd_sc_hd__buf_1
XFILLER_13_190 VGND VGND VPWR VPWR sky130_fd_sc_hd__decap_3
X_3722_ _8052_/Q _3723_/B _7004_/A VGND VGND VPWR VPWR _3722_/X sky130_fd_sc_hd__and3b_2
X_7490_ _7490_/A VGND VGND VPWR VPWR _8800_/D sky130_fd_sc_hd__buf_1
XFILLER_9_172 VGND VGND VPWR VPWR sky130_fd_sc_hd__decap_3
X_6441_ _6441_/A VGND VGND VPWR VPWR _8275_/D sky130_fd_sc_hd__buf_2
XFILLER_134_519 VGND VGND VPWR VPWR sky130_fd_sc_hd__decap_3
XTAP_TAPCELL_ROW_132_2136 VGND VPWR sky130_fd_sc_hd__tapvpwrvgnd_1
X_6372_ _6372_/A VGND VGND VPWR VPWR _8242_/D sky130_fd_sc_hd__buf_2
XFILLER_127_582 VGND VGND VPWR VPWR sky130_fd_sc_hd__decap_3
XTAP_TAPCELL_ROW_132_2147 VGND VPWR sky130_fd_sc_hd__tapvpwrvgnd_1
X_8111_ _8759_/CLK _8111_/D fanout705/X VGND VGND VPWR VPWR _8111_/Q sky130_fd_sc_hd__dfrtp_2
X_5323_ _7714_/Q _4921_/X _5331_/S VGND VGND VPWR VPWR _5324_/A sky130_fd_sc_hd__mux2_2
XFILLER_115_788 VGND VGND VPWR VPWR sky130_fd_sc_hd__fill_1
XFILLER_130_725 VGND VGND VPWR VPWR sky130_fd_sc_hd__decap_3
XTAP_TAPCELL_ROW_114_1891 VGND VPWR sky130_fd_sc_hd__tapvpwrvgnd_1
X_8042_ _8700_/CLK _8042_/D wire746/X VGND VGND VPWR VPWR _8042_/Q sky130_fd_sc_hd__dfrtp_2
X_5254_ _7681_/Q _4782_/X _5268_/S VGND VGND VPWR VPWR _5255_/A sky130_fd_sc_hd__mux2_2
XFILLER_130_769 VGND VGND VPWR VPWR sky130_fd_sc_hd__decap_3
X_5185_ _5185_/A VGND VGND VPWR VPWR _7648_/D sky130_fd_sc_hd__buf_1
X_4205_ _8335_/Q _3969_/X _4204_/X VGND VGND VPWR VPWR _4205_/X sky130_fd_sc_hd__o21a_2
XFILLER_68_374 VGND VGND VPWR VPWR sky130_fd_sc_hd__decap_3
X_4136_ _8410_/Q _8491_/Q _4140_/S VGND VGND VPWR VPWR _4136_/X sky130_fd_sc_hd__mux2_2
XFILLER_113_26 VGND VGND VPWR VPWR sky130_fd_sc_hd__decap_3
XFILLER_56_525 VGND VGND VPWR VPWR sky130_fd_sc_hd__decap_3
XFILLER_95_193 VGND VGND VPWR VPWR sky130_fd_sc_hd__decap_3
XTAP_TAPCELL_ROW_3_337 VGND VPWR sky130_fd_sc_hd__tapvpwrvgnd_1
XFILLER_113_48 VGND VGND VPWR VPWR sky130_fd_sc_hd__decap_3
XFILLER_37_750 VGND VGND VPWR VPWR sky130_fd_sc_hd__decap_3
XFILLER_73_19 VGND VGND VPWR VPWR sky130_fd_sc_hd__fill_1
XFILLER_83_344 VGND VGND VPWR VPWR sky130_fd_sc_hd__decap_3
X_4067_ _8565_/Q _4436_/B1 _4066_/X _4146_/A _3726_/A VGND VGND VPWR VPWR _4067_/X
+ sky130_fd_sc_hd__o221a_2
XTAP_TAPCELL_ROW_65_1201 VGND VPWR sky130_fd_sc_hd__tapvpwrvgnd_1
X_7826_ _8483_/CLK _7826_/D fanout504/X VGND VGND VPWR VPWR _7826_/Q sky130_fd_sc_hd__dfrtp_2
XFILLER_12_628 VGND VGND VPWR VPWR sky130_fd_sc_hd__decap_3
XFILLER_24_477 VGND VGND VPWR VPWR sky130_fd_sc_hd__decap_3
XFILLER_52_797 VGND VGND VPWR VPWR sky130_fd_sc_hd__fill_1
XTAP_TAPCELL_ROW_22_601 VGND VPWR sky130_fd_sc_hd__tapvpwrvgnd_1
XFILLER_11_116 VGND VGND VPWR VPWR sky130_fd_sc_hd__decap_3
XFILLER_11_138 VGND VGND VPWR VPWR sky130_fd_sc_hd__decap_3
XFILLER_51_274 VGND VGND VPWR VPWR sky130_fd_sc_hd__decap_3
XFILLER_51_296 VGND VGND VPWR VPWR sky130_fd_sc_hd__decap_3
X_7757_ _8739_/CLK _7757_/D load_slew509/X VGND VGND VPWR VPWR _7757_/Q sky130_fd_sc_hd__dfrtp_2
X_4969_ _4969_/A VGND VGND VPWR VPWR _4969_/X sky130_fd_sc_hd__buf_1
XFILLER_22_23 VGND VGND VPWR VPWR sky130_fd_sc_hd__decap_3
X_7688_ _8751_/CLK _7688_/D load_slew628/X VGND VGND VPWR VPWR _7688_/Q sky130_fd_sc_hd__dfrtp_2
X_6708_ _6708_/A VGND VGND VPWR VPWR _8399_/D sky130_fd_sc_hd__buf_2
XFILLER_125_6 VGND VGND VPWR VPWR sky130_fd_sc_hd__decap_3
XFILLER_22_56 VGND VGND VPWR VPWR sky130_fd_sc_hd__decap_3
XTAP_TAPCELL_ROW_50_987 VGND VPWR sky130_fd_sc_hd__tapvpwrvgnd_1
XTAP_TAPCELL_ROW_50_998 VGND VPWR sky130_fd_sc_hd__tapvpwrvgnd_1
X_6639_ _6639_/A VGND VGND VPWR VPWR _8368_/D sky130_fd_sc_hd__buf_2
XFILLER_118_560 VGND VGND VPWR VPWR sky130_fd_sc_hd__decap_3
XFILLER_125_508 VGND VGND VPWR VPWR sky130_fd_sc_hd__fill_1
XFILLER_98_27 VGND VGND VPWR VPWR sky130_fd_sc_hd__fill_1
XTAP_TAPCELL_ROW_76_1352 VGND VPWR sky130_fd_sc_hd__tapvpwrvgnd_1
XFILLER_106_744 VGND VGND VPWR VPWR sky130_fd_sc_hd__decap_3
XFILLER_106_766 VGND VGND VPWR VPWR sky130_fd_sc_hd__fill_2
XFILLER_133_541 VGND VGND VPWR VPWR sky130_fd_sc_hd__decap_3
XTAP_TAPCELL_ROW_76_1363 VGND VPWR sky130_fd_sc_hd__tapvpwrvgnd_1
X_8309_ _8795_/CLK _8309_/D load_slew608/X VGND VGND VPWR VPWR _8309_/Q sky130_fd_sc_hd__dfrtp_2
XFILLER_105_287 VGND VGND VPWR VPWR sky130_fd_sc_hd__decap_3
XFILLER_121_714 VGND VGND VPWR VPWR sky130_fd_sc_hd__fill_2
XFILLER_121_725 VGND VGND VPWR VPWR sky130_fd_sc_hd__decap_3
XFILLER_133_585 VGND VGND VPWR VPWR sky130_fd_sc_hd__decap_3
XFILLER_120_224 VGND VGND VPWR VPWR sky130_fd_sc_hd__decap_3
XPHY_EDGE_ROW_110_Right_110 VGND VGND VPWR VPWR sky130_fd_sc_hd__decap_3
XFILLER_120_279 VGND VGND VPWR VPWR sky130_fd_sc_hd__decap_3
XFILLER_47_20 VGND VGND VPWR VPWR sky130_fd_sc_hd__decap_3
XFILLER_93_119 VGND VGND VPWR VPWR sky130_fd_sc_hd__fill_1
XFILLER_59_385 VGND VGND VPWR VPWR sky130_fd_sc_hd__decap_3
XFILLER_74_322 VGND VGND VPWR VPWR sky130_fd_sc_hd__fill_1
XFILLER_86_171 VGND VGND VPWR VPWR sky130_fd_sc_hd__decap_3
XFILLER_28_750 VGND VGND VPWR VPWR sky130_fd_sc_hd__decap_3
XFILLER_47_558 VGND VGND VPWR VPWR sky130_fd_sc_hd__fill_2
XFILLER_47_75 VGND VGND VPWR VPWR sky130_fd_sc_hd__fill_2
XFILLER_27_260 VGND VGND VPWR VPWR sky130_fd_sc_hd__fill_2
XFILLER_62_539 VGND VGND VPWR VPWR sky130_fd_sc_hd__decap_3
XFILLER_103_81 VGND VGND VPWR VPWR sky130_fd_sc_hd__decap_3
XFILLER_63_74 VGND VGND VPWR VPWR sky130_fd_sc_hd__decap_3
XFILLER_129_803 VGND VGND VPWR VPWR sky130_fd_sc_hd__fill_1
XFILLER_42_296 VGND VGND VPWR VPWR sky130_fd_sc_hd__fill_1
XFILLER_8_47 VGND VGND VPWR VPWR sky130_fd_sc_hd__decap_3
XFILLER_11_694 VGND VGND VPWR VPWR sky130_fd_sc_hd__decap_3
XFILLER_7_632 VGND VGND VPWR VPWR sky130_fd_sc_hd__decap_3
XFILLER_7_665 VGND VGND VPWR VPWR sky130_fd_sc_hd__decap_3
XFILLER_7_676 VGND VGND VPWR VPWR sky130_fd_sc_hd__decap_3
Xwire552 wire552/A VGND VGND VPWR VPWR wire552/X sky130_fd_sc_hd__clkbuf_4
Xwire574 wire574/A VGND VGND VPWR VPWR wire574/X sky130_fd_sc_hd__clkbuf_4
XFILLER_111_202 VGND VGND VPWR VPWR sky130_fd_sc_hd__decap_3
XFILLER_124_563 VGND VGND VPWR VPWR sky130_fd_sc_hd__decap_3
XFILLER_97_425 VGND VGND VPWR VPWR sky130_fd_sc_hd__fill_1
Xload_slew513 fanout512/X VGND VGND VPWR VPWR load_slew513/X sky130_fd_sc_hd__buf_2
XFILLER_111_235 VGND VGND VPWR VPWR sky130_fd_sc_hd__decap_3
XFILLER_85_609 VGND VGND VPWR VPWR sky130_fd_sc_hd__decap_3
Xload_slew524 fanout523/X VGND VGND VPWR VPWR load_slew524/X sky130_fd_sc_hd__clkbuf_4
XFILLER_78_672 VGND VGND VPWR VPWR sky130_fd_sc_hd__decap_3
Xload_slew579 fanout578/X VGND VGND VPWR VPWR load_slew579/X sky130_fd_sc_hd__buf_2
Xload_slew568 fanout567/X VGND VGND VPWR VPWR load_slew568/X sky130_fd_sc_hd__buf_2
XFILLER_19_3 VGND VGND VPWR VPWR sky130_fd_sc_hd__decap_3
XFILLER_38_536 VGND VGND VPWR VPWR sky130_fd_sc_hd__decap_3
XFILLER_93_620 VGND VGND VPWR VPWR sky130_fd_sc_hd__fill_2
XFILLER_38_569 VGND VGND VPWR VPWR sky130_fd_sc_hd__decap_3
XFILLER_65_355 VGND VGND VPWR VPWR sky130_fd_sc_hd__fill_1
XFILLER_77_193 VGND VGND VPWR VPWR sky130_fd_sc_hd__decap_3
XFILLER_92_141 VGND VGND VPWR VPWR sky130_fd_sc_hd__decap_3
X_6990_ _4917_/X _8533_/Q _7000_/S VGND VGND VPWR VPWR _6991_/A sky130_fd_sc_hd__mux2_4
XFILLER_53_517 VGND VGND VPWR VPWR sky130_fd_sc_hd__fill_1
XFILLER_65_388 VGND VGND VPWR VPWR sky130_fd_sc_hd__fill_1
XFILLER_92_185 VGND VGND VPWR VPWR sky130_fd_sc_hd__fill_2
X_5941_ _5944_/A1 _5944_/A2 _4879_/X _5944_/B1 hold873/X VGND VGND VPWR VPWR _8028_/D
+ sky130_fd_sc_hd__a32o_2
XFILLER_18_293 VGND VGND VPWR VPWR sky130_fd_sc_hd__decap_3
XFILLER_80_358 VGND VGND VPWR VPWR sky130_fd_sc_hd__fill_1
X_8660_ _8660_/CLK _8660_/D load_slew524/X VGND VGND VPWR VPWR _8660_/Q sky130_fd_sc_hd__dfrtp_2
X_5872_ _5880_/A1 _5869_/X _4995_/X _5870_/X hold895/X VGND VGND VPWR VPWR _7974_/D
+ sky130_fd_sc_hd__a32o_2
XFILLER_21_414 VGND VGND VPWR VPWR sky130_fd_sc_hd__decap_3
X_8591_ _8671_/CLK _8591_/D load_slew687/X VGND VGND VPWR VPWR _8591_/Q sky130_fd_sc_hd__dfrtp_2
X_7611_ _8593_/CLK _7611_/D load_slew710/X VGND VGND VPWR VPWR _7611_/Q sky130_fd_sc_hd__dfrtp_2
X_4823_ _4823_/A _4852_/B VGND VGND VPWR VPWR _4824_/A sky130_fd_sc_hd__and2_2
XFILLER_21_458 VGND VGND VPWR VPWR sky130_fd_sc_hd__fill_2
XTAP_TAPCELL_ROW_60_1131 VGND VPWR sky130_fd_sc_hd__tapvpwrvgnd_1
Xclkbuf_leaf_93_CLK clkload6/A VGND VGND VPWR VPWR _8701_/CLK sky130_fd_sc_hd__clkbuf_8
X_7542_ _8770_/CLK _7542_/D load_slew550/X VGND VGND VPWR VPWR _7542_/Q sky130_fd_sc_hd__dfrtp_2
X_4754_ _4753_/X _7512_/Q _4778_/S VGND VGND VPWR VPWR _4755_/A sky130_fd_sc_hd__mux2_2
XFILLER_119_335 VGND VGND VPWR VPWR sky130_fd_sc_hd__fill_1
X_3705_ _8053_/Q input2/X _3705_/C _3719_/C VGND VGND VPWR VPWR _3727_/B sky130_fd_sc_hd__and4b_2
X_7473_ _7473_/A VGND VGND VPWR VPWR _8792_/D sky130_fd_sc_hd__buf_1
X_4685_ _4685_/A1 _4679_/X _4684_/X VGND VGND VPWR VPWR _4685_/X sky130_fd_sc_hd__o21a_2
XFILLER_134_338 VGND VGND VPWR VPWR sky130_fd_sc_hd__decap_3
XTAP_TAPCELL_ROW_116_1920 VGND VPWR sky130_fd_sc_hd__tapvpwrvgnd_1
X_6424_ _4819_/X _8267_/Q _6440_/S VGND VGND VPWR VPWR _6425_/A sky130_fd_sc_hd__mux2_2
XTAP_TAPCELL_ROW_8_407 VGND VPWR sky130_fd_sc_hd__tapvpwrvgnd_1
X_6355_ _6355_/A VGND VGND VPWR VPWR _8234_/D sky130_fd_sc_hd__buf_2
XFILLER_115_585 VGND VGND VPWR VPWR sky130_fd_sc_hd__decap_3
XFILLER_88_414 VGND VGND VPWR VPWR sky130_fd_sc_hd__decap_3
X_6286_ _6286_/A VGND VGND VPWR VPWR _8202_/D sky130_fd_sc_hd__buf_6
X_5306_ _7706_/Q _4887_/X _5310_/S VGND VGND VPWR VPWR _5307_/A sky130_fd_sc_hd__mux2_2
XFILLER_130_522 VGND VGND VPWR VPWR sky130_fd_sc_hd__decap_3
XFILLER_130_533 VGND VGND VPWR VPWR sky130_fd_sc_hd__decap_3
X_8025_ _8688_/CLK _8025_/D load_slew565/X VGND VGND VPWR VPWR _8025_/Q sky130_fd_sc_hd__dfrtp_2
X_5237_ _5237_/A0 _4749_/X _5247_/S VGND VGND VPWR VPWR _5238_/A sky130_fd_sc_hd__mux2_2
XFILLER_124_47 VGND VGND VPWR VPWR sky130_fd_sc_hd__decap_3
XFILLER_130_566 VGND VGND VPWR VPWR sky130_fd_sc_hd__decap_3
XFILLER_29_503 VGND VGND VPWR VPWR sky130_fd_sc_hd__fill_1
XFILLER_75_108 VGND VGND VPWR VPWR sky130_fd_sc_hd__decap_3
XTAP_TAPCELL_ROW_71_1282 VGND VPWR sky130_fd_sc_hd__tapvpwrvgnd_1
XFILLER_111_791 VGND VGND VPWR VPWR sky130_fd_sc_hd__decap_3
XFILLER_29_514 VGND VGND VPWR VPWR sky130_fd_sc_hd__decap_3
XFILLER_84_29 VGND VGND VPWR VPWR sky130_fd_sc_hd__decap_3
XFILLER_84_620 VGND VGND VPWR VPWR sky130_fd_sc_hd__fill_1
XTAP_TAPCELL_ROW_71_1293 VGND VPWR sky130_fd_sc_hd__tapvpwrvgnd_1
X_5168_ _7640_/Q _4953_/X _5184_/S VGND VGND VPWR VPWR _5169_/A sky130_fd_sc_hd__mux2_2
XFILLER_17_12 VGND VGND VPWR VPWR sky130_fd_sc_hd__decap_3
XFILLER_84_642 VGND VGND VPWR VPWR sky130_fd_sc_hd__fill_2
X_5099_ _5099_/A VGND VGND VPWR VPWR _7608_/D sky130_fd_sc_hd__buf_1
X_4119_ _8408_/Q _8489_/Q _8570_/Q _8651_/Q _4166_/S0 _4166_/S1 VGND VGND VPWR VPWR
+ _4120_/B sky130_fd_sc_hd__mux4_2
XFILLER_16_208 VGND VGND VPWR VPWR sky130_fd_sc_hd__decap_3
XFILLER_17_45 VGND VGND VPWR VPWR sky130_fd_sc_hd__decap_3
XFILLER_44_528 VGND VGND VPWR VPWR sky130_fd_sc_hd__decap_3
XFILLER_44_539 VGND VGND VPWR VPWR sky130_fd_sc_hd__decap_3
XFILLER_52_572 VGND VGND VPWR VPWR sky130_fd_sc_hd__decap_3
XFILLER_12_436 VGND VGND VPWR VPWR sky130_fd_sc_hd__decap_3
XTAP_TAPCELL_ROW_35_781 VGND VPWR sky130_fd_sc_hd__tapvpwrvgnd_1
X_8789_ _8789_/CLK _8789_/D fanout683/X VGND VGND VPWR VPWR _8789_/Q sky130_fd_sc_hd__dfrtp_2
X_7809_ _8545_/CLK _7809_/D fanout660/X VGND VGND VPWR VPWR _7809_/Q sky130_fd_sc_hd__dfrtp_2
XFILLER_12_469 VGND VGND VPWR VPWR sky130_fd_sc_hd__decap_3
XFILLER_33_66 VGND VGND VPWR VPWR sky130_fd_sc_hd__decap_3
XFILLER_8_407 VGND VGND VPWR VPWR sky130_fd_sc_hd__decap_3
Xclkbuf_leaf_84_CLK clkbuf_leaf_84_CLK/A VGND VGND VPWR VPWR _8780_/CLK sky130_fd_sc_hd__clkbuf_8
XFILLER_8_429 VGND VGND VPWR VPWR sky130_fd_sc_hd__fill_2
XFILLER_4_613 VGND VGND VPWR VPWR sky130_fd_sc_hd__decap_3
XFILLER_4_657 VGND VGND VPWR VPWR sky130_fd_sc_hd__decap_3
XFILLER_106_563 VGND VGND VPWR VPWR sky130_fd_sc_hd__decap_3
XFILLER_121_500 VGND VGND VPWR VPWR sky130_fd_sc_hd__decap_3
XFILLER_121_522 VGND VGND VPWR VPWR sky130_fd_sc_hd__decap_3
XFILLER_133_382 VGND VGND VPWR VPWR sky130_fd_sc_hd__decap_3
XFILLER_133_393 VGND VGND VPWR VPWR sky130_fd_sc_hd__decap_3
XFILLER_58_74 VGND VGND VPWR VPWR sky130_fd_sc_hd__decap_3
XFILLER_67_609 VGND VGND VPWR VPWR sky130_fd_sc_hd__decap_3
XFILLER_94_406 VGND VGND VPWR VPWR sky130_fd_sc_hd__fill_1
XFILLER_58_85 VGND VGND VPWR VPWR sky130_fd_sc_hd__decap_3
XTAP_TAPCELL_ROW_89_1532 VGND VPWR sky130_fd_sc_hd__tapvpwrvgnd_1
XTAP_TAPCELL_ROW_89_1543 VGND VPWR sky130_fd_sc_hd__tapvpwrvgnd_1
XFILLER_47_377 VGND VGND VPWR VPWR sky130_fd_sc_hd__decap_3
XFILLER_47_388 VGND VGND VPWR VPWR sky130_fd_sc_hd__decap_3
XFILLER_75_697 VGND VGND VPWR VPWR sky130_fd_sc_hd__decap_3
XFILLER_90_601 VGND VGND VPWR VPWR sky130_fd_sc_hd__decap_3
XFILLER_28_580 VGND VGND VPWR VPWR sky130_fd_sc_hd__fill_2
XFILLER_16_753 VGND VGND VPWR VPWR sky130_fd_sc_hd__decap_3
XFILLER_43_561 VGND VGND VPWR VPWR sky130_fd_sc_hd__decap_3
XFILLER_15_263 VGND VGND VPWR VPWR sky130_fd_sc_hd__fill_1
XFILLER_30_200 VGND VGND VPWR VPWR sky130_fd_sc_hd__decap_3
XFILLER_30_222 VGND VGND VPWR VPWR sky130_fd_sc_hd__decap_3
XFILLER_129_600 VGND VGND VPWR VPWR sky130_fd_sc_hd__decap_3
XFILLER_90_50 VGND VGND VPWR VPWR sky130_fd_sc_hd__decap_3
XFILLER_128_121 VGND VGND VPWR VPWR sky130_fd_sc_hd__decap_3
XFILLER_129_644 VGND VGND VPWR VPWR sky130_fd_sc_hd__decap_3
XFILLER_90_94 VGND VGND VPWR VPWR sky130_fd_sc_hd__fill_2
XTAP_TAPCELL_ROW_13_475 VGND VPWR sky130_fd_sc_hd__tapvpwrvgnd_1
Xclkbuf_leaf_75_CLK clkbuf_leaf_75_CLK/A VGND VGND VPWR VPWR _8530_/CLK sky130_fd_sc_hd__clkbuf_8
XFILLER_30_299 VGND VGND VPWR VPWR sky130_fd_sc_hd__decap_3
XFILLER_128_165 VGND VGND VPWR VPWR sky130_fd_sc_hd__decap_3
XFILLER_129_688 VGND VGND VPWR VPWR sky130_fd_sc_hd__decap_3
XFILLER_7_484 VGND VGND VPWR VPWR sky130_fd_sc_hd__decap_3
X_4470_ _3910_/A _4468_/X _4469_/X VGND VGND VPWR VPWR _4470_/X sky130_fd_sc_hd__o21a_2
XFILLER_131_308 VGND VGND VPWR VPWR sky130_fd_sc_hd__decap_3
XFILLER_98_701 VGND VGND VPWR VPWR sky130_fd_sc_hd__fill_2
X_6140_ _6140_/A VGND VGND VPWR VPWR _8134_/D sky130_fd_sc_hd__buf_1
XFILLER_112_533 VGND VGND VPWR VPWR sky130_fd_sc_hd__decap_3
XFILLER_124_371 VGND VGND VPWR VPWR sky130_fd_sc_hd__decap_3
Xload_slew310 _4557_/A1 VGND VGND VPWR VPWR _4543_/A sky130_fd_sc_hd__clkbuf_2
XFILLER_57_108 VGND VGND VPWR VPWR sky130_fd_sc_hd__fill_1
XTAP_TAPCELL_ROW_111_1850 VGND VPWR sky130_fd_sc_hd__tapvpwrvgnd_1
Xload_slew332 _4125_/A VGND VGND VPWR VPWR _4166_/S1 sky130_fd_sc_hd__buf_2
X_6071_ _6071_/A VGND VGND VPWR VPWR _8101_/D sky130_fd_sc_hd__buf_1
XFILLER_112_599 VGND VGND VPWR VPWR sky130_fd_sc_hd__decap_3
XFILLER_66_631 VGND VGND VPWR VPWR sky130_fd_sc_hd__fill_1
XFILLER_78_480 VGND VGND VPWR VPWR sky130_fd_sc_hd__fill_2
Xload_slew387 _4564_/A1 VGND VGND VPWR VPWR _4569_/A sky130_fd_sc_hd__clkbuf_4
X_5022_ _5022_/A _5026_/B VGND VGND VPWR VPWR _5023_/A sky130_fd_sc_hd__and2_2
XTAP_TAPCELL_ROW_127_2068 VGND VPWR sky130_fd_sc_hd__tapvpwrvgnd_1
XFILLER_26_506 VGND VGND VPWR VPWR sky130_fd_sc_hd__fill_1
XFILLER_53_314 VGND VGND VPWR VPWR sky130_fd_sc_hd__fill_2
XFILLER_66_675 VGND VGND VPWR VPWR sky130_fd_sc_hd__decap_3
XFILLER_81_623 VGND VGND VPWR VPWR sky130_fd_sc_hd__decap_3
XFILLER_53_325 VGND VGND VPWR VPWR sky130_fd_sc_hd__decap_3
XFILLER_65_196 VGND VGND VPWR VPWR sky130_fd_sc_hd__decap_3
XFILLER_81_656 VGND VGND VPWR VPWR sky130_fd_sc_hd__decap_3
X_6973_ _4883_/X _8525_/Q _6979_/S VGND VGND VPWR VPWR _6974_/A sky130_fd_sc_hd__mux2_4
XFILLER_0_81 VGND VGND VPWR VPWR sky130_fd_sc_hd__decap_3
XFILLER_22_701 VGND VGND VPWR VPWR sky130_fd_sc_hd__decap_3
XFILLER_53_358 VGND VGND VPWR VPWR sky130_fd_sc_hd__decap_3
XFILLER_80_144 VGND VGND VPWR VPWR sky130_fd_sc_hd__decap_3
X_8712_ _8712_/CLK _8712_/D load_slew689/X VGND VGND VPWR VPWR _8712_/Q sky130_fd_sc_hd__dfrtp_2
X_5924_ _5931_/A1 _5921_/X _4819_/X _5922_/X hold887/X VGND VGND VPWR VPWR _8014_/D
+ sky130_fd_sc_hd__a32o_2
XFILLER_110_27 VGND VGND VPWR VPWR sky130_fd_sc_hd__fill_1
X_8643_ _8724_/CLK _8643_/D fanout502/A VGND VGND VPWR VPWR _8643_/Q sky130_fd_sc_hd__dfrtp_2
X_5855_ _7004_/C _6486_/B _7282_/A VGND VGND VPWR VPWR _5856_/A sky130_fd_sc_hd__or3_2
XTAP_TAPCELL_ROW_32_740 VGND VPWR sky130_fd_sc_hd__tapvpwrvgnd_1
X_4806_ _4806_/A _4810_/B VGND VGND VPWR VPWR _4807_/A sky130_fd_sc_hd__and2_2
XFILLER_9_90 VGND VGND VPWR VPWR sky130_fd_sc_hd__decap_3
Xclkbuf_leaf_66_CLK clkload9/A VGND VGND VPWR VPWR _8758_/CLK sky130_fd_sc_hd__clkbuf_8
X_8574_ _8655_/CLK _8574_/D load_slew484/X VGND VGND VPWR VPWR _8574_/Q sky130_fd_sc_hd__dfrtp_2
X_5786_ _5849_/S VGND VGND VPWR VPWR _5805_/S sky130_fd_sc_hd__buf_2
XFILLER_119_36 VGND VGND VPWR VPWR sky130_fd_sc_hd__decap_3
X_7525_ _8793_/CLK _7525_/D fanout641/X VGND VGND VPWR VPWR _7525_/Q sky130_fd_sc_hd__dfrtp_2
X_4737_ _4737_/A VGND VGND VPWR VPWR _7508_/D sky130_fd_sc_hd__buf_1
XFILLER_107_305 VGND VGND VPWR VPWR sky130_fd_sc_hd__fill_2
XFILLER_119_165 VGND VGND VPWR VPWR sky130_fd_sc_hd__decap_3
XFILLER_135_625 VGND VGND VPWR VPWR sky130_fd_sc_hd__decap_3
X_7456_ _4953_/X _8784_/Q _7474_/S VGND VGND VPWR VPWR _7457_/A sky130_fd_sc_hd__mux2_2
X_4668_ _8457_/Q _8538_/Q _8619_/Q _8700_/Q _4670_/S0 _4651_/A VGND VGND VPWR VPWR
+ _4668_/X sky130_fd_sc_hd__mux4_2
XFILLER_107_349 VGND VGND VPWR VPWR sky130_fd_sc_hd__fill_2
XFILLER_119_198 VGND VGND VPWR VPWR sky130_fd_sc_hd__decap_3
XFILLER_134_124 VGND VGND VPWR VPWR sky130_fd_sc_hd__decap_3
XFILLER_135_669 VGND VGND VPWR VPWR sky130_fd_sc_hd__decap_3
XFILLER_79_29 VGND VGND VPWR VPWR sky130_fd_sc_hd__fill_1
Xhold930 _8247_/Q VGND VGND VPWR VPWR hold930/X sky130_fd_sc_hd__dlygate4sd3_1
X_6407_ _4787_/X hold918/X _6419_/S VGND VGND VPWR VPWR _6408_/A sky130_fd_sc_hd__mux2_1
XFILLER_103_500 VGND VGND VPWR VPWR sky130_fd_sc_hd__decap_3
XFILLER_134_168 VGND VGND VPWR VPWR sky130_fd_sc_hd__decap_3
XFILLER_88_200 VGND VGND VPWR VPWR sky130_fd_sc_hd__decap_3
XTAP_TAPCELL_ROW_73_1311 VGND VPWR sky130_fd_sc_hd__tapvpwrvgnd_1
Xhold941 _8260_/Q VGND VGND VPWR VPWR hold941/X sky130_fd_sc_hd__dlygate4sd3_1
Xhold952 _7581_/Q VGND VGND VPWR VPWR hold952/X sky130_fd_sc_hd__dlygate4sd3_1
Xhold963 _8785_/Q VGND VGND VPWR VPWR hold963/X sky130_fd_sc_hd__dlygate4sd3_1
X_7387_ _7387_/A VGND VGND VPWR VPWR _8751_/D sky130_fd_sc_hd__buf_1
X_4599_ _8451_/Q _8532_/Q _4630_/S VGND VGND VPWR VPWR _4599_/X sky130_fd_sc_hd__mux2_2
XFILLER_135_24 VGND VGND VPWR VPWR sky130_fd_sc_hd__decap_3
XFILLER_135_35 VGND VGND VPWR VPWR sky130_fd_sc_hd__decap_3
XFILLER_1_638 VGND VGND VPWR VPWR sky130_fd_sc_hd__decap_3
Xhold974 _8242_/Q VGND VGND VPWR VPWR hold974/X sky130_fd_sc_hd__dlygate4sd3_1
Xhold985 _7578_/Q VGND VGND VPWR VPWR hold985/X sky130_fd_sc_hd__dlygate4sd3_1
Xhold996 _7539_/Q VGND VGND VPWR VPWR hold996/X sky130_fd_sc_hd__dlygate4sd3_1
X_6338_ _4989_/X _8226_/Q _6356_/S VGND VGND VPWR VPWR _6339_/A sky130_fd_sc_hd__mux2_2
XFILLER_130_341 VGND VGND VPWR VPWR sky130_fd_sc_hd__fill_2
XFILLER_135_57 VGND VGND VPWR VPWR sky130_fd_sc_hd__decap_3
XFILLER_89_778 VGND VGND VPWR VPWR sky130_fd_sc_hd__decap_3
X_6269_ _6269_/A VGND VGND VPWR VPWR _8194_/D sky130_fd_sc_hd__buf_6
XFILLER_130_385 VGND VGND VPWR VPWR sky130_fd_sc_hd__decap_3
XFILLER_29_311 VGND VGND VPWR VPWR sky130_fd_sc_hd__decap_3
X_8008_ _8747_/CLK _8008_/D load_slew645/X VGND VGND VPWR VPWR _8008_/Q sky130_fd_sc_hd__dfrtp_2
XFILLER_28_44 VGND VGND VPWR VPWR sky130_fd_sc_hd__decap_3
XFILLER_28_88 VGND VGND VPWR VPWR sky130_fd_sc_hd__decap_3
XFILLER_44_303 VGND VGND VPWR VPWR sky130_fd_sc_hd__fill_2
XFILLER_56_141 VGND VGND VPWR VPWR sky130_fd_sc_hd__fill_2
XFILLER_72_645 VGND VGND VPWR VPWR sky130_fd_sc_hd__fill_2
XFILLER_72_656 VGND VGND VPWR VPWR sky130_fd_sc_hd__decap_3
XTAP_TAPCELL_ROW_84_1462 VGND VPWR sky130_fd_sc_hd__tapvpwrvgnd_1
XFILLER_12_200 VGND VGND VPWR VPWR sky130_fd_sc_hd__decap_3
XTAP_TAPCELL_ROW_84_1473 VGND VPWR sky130_fd_sc_hd__tapvpwrvgnd_1
XFILLER_13_756 VGND VGND VPWR VPWR sky130_fd_sc_hd__decap_3
XFILLER_9_727 VGND VGND VPWR VPWR sky130_fd_sc_hd__fill_1
XFILLER_100_82 VGND VGND VPWR VPWR sky130_fd_sc_hd__fill_2
XFILLER_40_586 VGND VGND VPWR VPWR sky130_fd_sc_hd__fill_2
XFILLER_8_237 VGND VGND VPWR VPWR sky130_fd_sc_hd__decap_3
XFILLER_9_738 VGND VGND VPWR VPWR sky130_fd_sc_hd__decap_3
Xclkbuf_leaf_57_CLK clkbuf_leaf_63_CLK/A VGND VGND VPWR VPWR _8678_/CLK sky130_fd_sc_hd__clkbuf_8
XTAP_TAPCELL_ROW_10_434 VGND VPWR sky130_fd_sc_hd__tapvpwrvgnd_1
XFILLER_125_113 VGND VGND VPWR VPWR sky130_fd_sc_hd__decap_3
XFILLER_60_97 VGND VGND VPWR VPWR sky130_fd_sc_hd__decap_3
XFILLER_4_421 VGND VGND VPWR VPWR sky130_fd_sc_hd__fill_2
XFILLER_5_15 VGND VGND VPWR VPWR sky130_fd_sc_hd__decap_3
XFILLER_113_319 VGND VGND VPWR VPWR sky130_fd_sc_hd__decap_3
XFILLER_5_48 VGND VGND VPWR VPWR sky130_fd_sc_hd__decap_3
XFILLER_106_371 VGND VGND VPWR VPWR sky130_fd_sc_hd__fill_1
XFILLER_79_222 VGND VGND VPWR VPWR sky130_fd_sc_hd__fill_2
XFILLER_133_190 VGND VGND VPWR VPWR sky130_fd_sc_hd__decap_3
XFILLER_0_660 VGND VGND VPWR VPWR sky130_fd_sc_hd__decap_3
XFILLER_0_682 VGND VGND VPWR VPWR sky130_fd_sc_hd__decap_3
XFILLER_121_396 VGND VGND VPWR VPWR sky130_fd_sc_hd__decap_3
XFILLER_94_203 VGND VGND VPWR VPWR sky130_fd_sc_hd__fill_2
XFILLER_95_726 VGND VGND VPWR VPWR sky130_fd_sc_hd__fill_2
XFILLER_125_90 VGND VGND VPWR VPWR sky130_fd_sc_hd__decap_3
XFILLER_82_409 VGND VGND VPWR VPWR sky130_fd_sc_hd__fill_2
XPHY_EDGE_ROW_13_Right_13 VGND VGND VPWR VPWR sky130_fd_sc_hd__decap_3
XFILLER_47_141 VGND VGND VPWR VPWR sky130_fd_sc_hd__fill_2
XFILLER_48_697 VGND VGND VPWR VPWR sky130_fd_sc_hd__decap_3
XFILLER_62_122 VGND VGND VPWR VPWR sky130_fd_sc_hd__fill_1
XFILLER_50_306 VGND VGND VPWR VPWR sky130_fd_sc_hd__fill_2
XFILLER_62_144 VGND VGND VPWR VPWR sky130_fd_sc_hd__decap_3
XFILLER_90_453 VGND VGND VPWR VPWR sky130_fd_sc_hd__decap_3
XFILLER_90_475 VGND VGND VPWR VPWR sky130_fd_sc_hd__fill_1
XTAP_TAPCELL_ROW_18_545 VGND VPWR sky130_fd_sc_hd__tapvpwrvgnd_1
X_3970_ _8718_/Q _8799_/Q _4550_/S VGND VGND VPWR VPWR _3970_/X sky130_fd_sc_hd__mux2_2
XFILLER_16_583 VGND VGND VPWR VPWR sky130_fd_sc_hd__decap_3
XFILLER_31_520 VGND VGND VPWR VPWR sky130_fd_sc_hd__decap_3
XFILLER_43_380 VGND VGND VPWR VPWR sky130_fd_sc_hd__decap_3
XFILLER_62_177 VGND VGND VPWR VPWR sky130_fd_sc_hd__decap_3
XFILLER_31_564 VGND VGND VPWR VPWR sky130_fd_sc_hd__decap_3
Xclkbuf_leaf_48_CLK clkbuf_leaf_48_CLK/A VGND VGND VPWR VPWR _8637_/CLK sky130_fd_sc_hd__clkbuf_8
X_5640_ _7863_/Q _4866_/A _5654_/S VGND VGND VPWR VPWR _5641_/A sky130_fd_sc_hd__mux2_2
XFILLER_129_441 VGND VGND VPWR VPWR sky130_fd_sc_hd__decap_3
XFILLER_129_452 VGND VGND VPWR VPWR sky130_fd_sc_hd__decap_3
XPHY_EDGE_ROW_22_Right_22 VGND VGND VPWR VPWR sky130_fd_sc_hd__decap_3
X_5571_ _5571_/A VGND VGND VPWR VPWR _7830_/D sky130_fd_sc_hd__buf_1
XFILLER_129_485 VGND VGND VPWR VPWR sky130_fd_sc_hd__decap_3
XFILLER_8_760 VGND VGND VPWR VPWR sky130_fd_sc_hd__decap_3
X_8290_ _8695_/CLK _8290_/D load_slew733/X VGND VGND VPWR VPWR _8290_/Q sky130_fd_sc_hd__dfrtp_2
X_7310_ _7310_/A VGND VGND VPWR VPWR _8714_/D sky130_fd_sc_hd__buf_1
X_4522_ _4520_/X _4521_/X _4522_/S VGND VGND VPWR VPWR _4522_/X sky130_fd_sc_hd__mux2_2
XFILLER_116_124 VGND VGND VPWR VPWR sky130_fd_sc_hd__decap_3
XFILLER_117_658 VGND VGND VPWR VPWR sky130_fd_sc_hd__fill_1
XFILLER_7_270 VGND VGND VPWR VPWR sky130_fd_sc_hd__fill_1
XFILLER_7_281 VGND VGND VPWR VPWR sky130_fd_sc_hd__fill_1
XFILLER_8_793 VGND VGND VPWR VPWR sky130_fd_sc_hd__decap_3
X_7241_ _7267_/A VGND VGND VPWR VPWR _7241_/X sky130_fd_sc_hd__clkbuf_1
X_4453_ _8113_/Q _8194_/Q _8275_/Q _8356_/Q _4454_/S _4455_/A VGND VGND VPWR VPWR
+ _4453_/X sky130_fd_sc_hd__mux4_2
XFILLER_131_105 VGND VGND VPWR VPWR sky130_fd_sc_hd__decap_3
XFILLER_132_628 VGND VGND VPWR VPWR sky130_fd_sc_hd__decap_3
XFILLER_131_116 VGND VGND VPWR VPWR sky130_fd_sc_hd__decap_3
XFILLER_98_542 VGND VGND VPWR VPWR sky130_fd_sc_hd__decap_3
XPHY_EDGE_ROW_123_Left_259 VGND VGND VPWR VPWR sky130_fd_sc_hd__decap_3
Xfanout706 fanout716/X VGND VGND VPWR VPWR wire707/A sky130_fd_sc_hd__clkdlybuf4s25_1
X_7172_ _4937_/X _8619_/Q _7172_/S VGND VGND VPWR VPWR _7173_/A sky130_fd_sc_hd__mux2_2
X_4384_ _3795_/X _4375_/X _4378_/X _4383_/X VGND VGND VPWR VPWR _4384_/X sky130_fd_sc_hd__o31a_2
XFILLER_112_330 VGND VGND VPWR VPWR sky130_fd_sc_hd__decap_3
XFILLER_112_341 VGND VGND VPWR VPWR sky130_fd_sc_hd__decap_3
XFILLER_131_149 VGND VGND VPWR VPWR sky130_fd_sc_hd__decap_3
XFILLER_86_704 VGND VGND VPWR VPWR sky130_fd_sc_hd__decap_3
XFILLER_98_564 VGND VGND VPWR VPWR sky130_fd_sc_hd__decap_3
XTAP_TAPCELL_ROW_55_1063 VGND VPWR sky130_fd_sc_hd__tapvpwrvgnd_1
Xfanout717 fanout719/X VGND VGND VPWR VPWR fanout717/X sky130_fd_sc_hd__clkdlybuf4s25_1
Xfanout728 fanout734/X VGND VGND VPWR VPWR fanout728/X sky130_fd_sc_hd__clkdlybuf4s25_1
Xfanout739 fanout744/X VGND VGND VPWR VPWR fanout739/X sky130_fd_sc_hd__clkdlybuf4s25_1
X_6123_ _8126_/Q _4907_/A _6137_/S VGND VGND VPWR VPWR _6124_/A sky130_fd_sc_hd__mux2_2
XFILLER_85_225 VGND VGND VPWR VPWR sky130_fd_sc_hd__decap_3
XFILLER_86_726 VGND VGND VPWR VPWR sky130_fd_sc_hd__decap_3
XFILLER_98_586 VGND VGND VPWR VPWR sky130_fd_sc_hd__fill_2
XPHY_EDGE_ROW_31_Right_31 VGND VGND VPWR VPWR sky130_fd_sc_hd__decap_3
X_6054_ _6054_/A VGND VGND VPWR VPWR _8093_/D sky130_fd_sc_hd__buf_1
X_5005_ _5005_/A VGND VGND VPWR VPWR _7571_/D sky130_fd_sc_hd__buf_1
XFILLER_38_141 VGND VGND VPWR VPWR sky130_fd_sc_hd__decap_3
XFILLER_38_163 VGND VGND VPWR VPWR sky130_fd_sc_hd__fill_2
XFILLER_54_601 VGND VGND VPWR VPWR sky130_fd_sc_hd__fill_2
XFILLER_85_269 VGND VGND VPWR VPWR sky130_fd_sc_hd__fill_1
XFILLER_94_770 VGND VGND VPWR VPWR sky130_fd_sc_hd__decap_3
XFILLER_38_174 VGND VGND VPWR VPWR sky130_fd_sc_hd__fill_2
XFILLER_54_645 VGND VGND VPWR VPWR sky130_fd_sc_hd__decap_3
XFILLER_66_494 VGND VGND VPWR VPWR sky130_fd_sc_hd__decap_3
XTAP_TAPCELL_ROW_37_810 VGND VPWR sky130_fd_sc_hd__tapvpwrvgnd_1
X_6956_ _4849_/X _8517_/Q _6958_/S VGND VGND VPWR VPWR _6957_/A sky130_fd_sc_hd__mux2_4
XFILLER_81_486 VGND VGND VPWR VPWR sky130_fd_sc_hd__decap_3
XPHY_EDGE_ROW_132_Left_268 VGND VGND VPWR VPWR sky130_fd_sc_hd__decap_3
X_5907_ _5907_/A VGND VGND VPWR VPWR _5907_/X sky130_fd_sc_hd__clkbuf_1
XFILLER_14_24 VGND VGND VPWR VPWR sky130_fd_sc_hd__decap_3
XFILLER_14_35 VGND VGND VPWR VPWR sky130_fd_sc_hd__decap_3
X_6887_ _4711_/X _8484_/Q _6895_/S VGND VGND VPWR VPWR _6888_/A sky130_fd_sc_hd__mux2_4
XFILLER_10_704 VGND VGND VPWR VPWR sky130_fd_sc_hd__decap_3
XFILLER_14_68 VGND VGND VPWR VPWR sky130_fd_sc_hd__decap_3
XFILLER_22_586 VGND VGND VPWR VPWR sky130_fd_sc_hd__fill_2
XPHY_EDGE_ROW_40_Right_40 VGND VGND VPWR VPWR sky130_fd_sc_hd__decap_3
X_8626_ _8788_/CLK _8626_/D fanout664/X VGND VGND VPWR VPWR _8626_/Q sky130_fd_sc_hd__dfrtp_2
Xclkbuf_leaf_39_CLK clkbuf_leaf_48_CLK/A VGND VGND VPWR VPWR _8771_/CLK sky130_fd_sc_hd__clkbuf_8
X_5838_ _5838_/A VGND VGND VPWR VPWR _7956_/D sky130_fd_sc_hd__buf_1
XFILLER_10_737 VGND VGND VPWR VPWR sky130_fd_sc_hd__decap_3
X_8557_ _8638_/CLK _8557_/D fanout585/X VGND VGND VPWR VPWR _8557_/Q sky130_fd_sc_hd__dfrtp_2
X_5769_ _5769_/A VGND VGND VPWR VPWR _7923_/D sky130_fd_sc_hd__buf_1
XFILLER_30_12 VGND VGND VPWR VPWR sky130_fd_sc_hd__decap_3
XFILLER_6_719 VGND VGND VPWR VPWR sky130_fd_sc_hd__decap_3
X_7508_ _8328_/CLK _7508_/D wire476/X VGND VGND VPWR VPWR _7508_/Q sky130_fd_sc_hd__dfrtp_2
XFILLER_107_113 VGND VGND VPWR VPWR sky130_fd_sc_hd__decap_3
XFILLER_135_444 VGND VGND VPWR VPWR sky130_fd_sc_hd__decap_3
X_8488_ _8569_/CLK _8488_/D load_slew494/X VGND VGND VPWR VPWR _8488_/Q sky130_fd_sc_hd__dfrtp_2
XFILLER_123_617 VGND VGND VPWR VPWR sky130_fd_sc_hd__decap_3
XFILLER_135_466 VGND VGND VPWR VPWR sky130_fd_sc_hd__fill_1
XFILLER_135_477 VGND VGND VPWR VPWR sky130_fd_sc_hd__decap_3
XFILLER_30_78 VGND VGND VPWR VPWR sky130_fd_sc_hd__decap_3
X_7439_ _8776_/Q _4916_/A _7449_/S VGND VGND VPWR VPWR _7440_/A sky130_fd_sc_hd__mux2_2
XFILLER_89_520 VGND VGND VPWR VPWR sky130_fd_sc_hd__decap_3
Xhold760 _8039_/Q VGND VGND VPWR VPWR hold760/X sky130_fd_sc_hd__dlygate4sd3_1
Xhold771 _8654_/Q VGND VGND VPWR VPWR hold771/X sky130_fd_sc_hd__dlygate4sd3_1
Xhold782 _7984_/Q VGND VGND VPWR VPWR hold782/X sky130_fd_sc_hd__dlygate4sd3_1
XFILLER_131_650 VGND VGND VPWR VPWR sky130_fd_sc_hd__decap_3
XFILLER_89_553 VGND VGND VPWR VPWR sky130_fd_sc_hd__decap_3
XFILLER_89_564 VGND VGND VPWR VPWR sky130_fd_sc_hd__decap_3
Xhold793 _7992_/Q VGND VGND VPWR VPWR hold793/X sky130_fd_sc_hd__dlygate4sd3_1
XFILLER_130_171 VGND VGND VPWR VPWR sky130_fd_sc_hd__decap_3
XFILLER_131_694 VGND VGND VPWR VPWR sky130_fd_sc_hd__decap_3
XFILLER_49_417 VGND VGND VPWR VPWR sky130_fd_sc_hd__decap_3
XFILLER_76_203 VGND VGND VPWR VPWR sky130_fd_sc_hd__decap_3
XFILLER_92_707 VGND VGND VPWR VPWR sky130_fd_sc_hd__decap_3
XFILLER_45_601 VGND VGND VPWR VPWR sky130_fd_sc_hd__decap_3
XTAP_TAPCELL_ROW_86_1502 VGND VPWR sky130_fd_sc_hd__tapvpwrvgnd_1
XFILLER_55_42 VGND VGND VPWR VPWR sky130_fd_sc_hd__decap_3
XFILLER_57_483 VGND VGND VPWR VPWR sky130_fd_sc_hd__decap_3
XFILLER_84_280 VGND VGND VPWR VPWR sky130_fd_sc_hd__decap_3
XFILLER_44_144 VGND VGND VPWR VPWR sky130_fd_sc_hd__fill_2
XFILLER_32_306 VGND VGND VPWR VPWR sky130_fd_sc_hd__fill_2
XTAP_TAPCELL_ROW_15_504 VGND VPWR sky130_fd_sc_hd__tapvpwrvgnd_1
XFILLER_13_520 VGND VGND VPWR VPWR sky130_fd_sc_hd__decap_3
XFILLER_25_380 VGND VGND VPWR VPWR sky130_fd_sc_hd__decap_3
XFILLER_25_391 VGND VGND VPWR VPWR sky130_fd_sc_hd__fill_1
XFILLER_13_564 VGND VGND VPWR VPWR sky130_fd_sc_hd__decap_3
XFILLER_71_41 VGND VGND VPWR VPWR sky130_fd_sc_hd__decap_3
XFILLER_9_546 VGND VGND VPWR VPWR sky130_fd_sc_hd__decap_3
XFILLER_126_433 VGND VGND VPWR VPWR sky130_fd_sc_hd__decap_3
XFILLER_5_741 VGND VGND VPWR VPWR sky130_fd_sc_hd__decap_3
XTAP_TAPCELL_ROW_97_1653 VGND VPWR sky130_fd_sc_hd__tapvpwrvgnd_1
XFILLER_126_477 VGND VGND VPWR VPWR sky130_fd_sc_hd__decap_3
XFILLER_5_774 VGND VGND VPWR VPWR sky130_fd_sc_hd__decap_3
XFILLER_113_105 VGND VGND VPWR VPWR sky130_fd_sc_hd__decap_3
XFILLER_113_116 VGND VGND VPWR VPWR sky130_fd_sc_hd__fill_2
XFILLER_4_284 VGND VGND VPWR VPWR sky130_fd_sc_hd__fill_1
XFILLER_5_785 VGND VGND VPWR VPWR sky130_fd_sc_hd__decap_3
XFILLER_106_190 VGND VGND VPWR VPWR sky130_fd_sc_hd__decap_3
XFILLER_122_694 VGND VGND VPWR VPWR sky130_fd_sc_hd__decap_3
XFILLER_67_214 VGND VGND VPWR VPWR sky130_fd_sc_hd__decap_3
XFILLER_67_225 VGND VGND VPWR VPWR sky130_fd_sc_hd__decap_3
XFILLER_67_236 VGND VGND VPWR VPWR sky130_fd_sc_hd__fill_1
XFILLER_67_258 VGND VGND VPWR VPWR sky130_fd_sc_hd__fill_1
XFILLER_96_93 VGND VGND VPWR VPWR sky130_fd_sc_hd__decap_3
XFILLER_48_472 VGND VGND VPWR VPWR sky130_fd_sc_hd__decap_3
XFILLER_83_729 VGND VGND VPWR VPWR sky130_fd_sc_hd__decap_3
XTAP_TAPCELL_ROW_124_2027 VGND VPWR sky130_fd_sc_hd__tapvpwrvgnd_1
XFILLER_36_634 VGND VGND VPWR VPWR sky130_fd_sc_hd__fill_1
XFILLER_48_483 VGND VGND VPWR VPWR sky130_fd_sc_hd__decap_3
X_6810_ _8448_/Q _4898_/A _6828_/S VGND VGND VPWR VPWR _6811_/A sky130_fd_sc_hd__mux2_2
XFILLER_51_615 VGND VGND VPWR VPWR sky130_fd_sc_hd__fill_1
XFILLER_63_486 VGND VGND VPWR VPWR sky130_fd_sc_hd__decap_3
XTAP_TAPCELL_ROW_106_1771 VGND VPWR sky130_fd_sc_hd__tapvpwrvgnd_1
XTAP_TAPCELL_ROW_106_1782 VGND VPWR sky130_fd_sc_hd__tapvpwrvgnd_1
X_7790_ _8694_/CLK _7790_/D load_slew729/X VGND VGND VPWR VPWR _7790_/Q sky130_fd_sc_hd__dfrtp_2
XFILLER_16_391 VGND VGND VPWR VPWR sky130_fd_sc_hd__decap_3
X_3953_ _3947_/X _3952_/X _4393_/A VGND VGND VPWR VPWR _3954_/A sky130_fd_sc_hd__mux2_2
X_6741_ _6741_/A VGND VGND VPWR VPWR _8415_/D sky130_fd_sc_hd__buf_2
X_3884_ _8387_/Q _8468_/Q _3887_/S VGND VGND VPWR VPWR _3884_/X sky130_fd_sc_hd__mux2_2
X_6672_ _6672_/A VGND VGND VPWR VPWR _8382_/D sky130_fd_sc_hd__buf_2
X_8411_ _8735_/CLK _8411_/D fanout528/X VGND VGND VPWR VPWR _8411_/Q sky130_fd_sc_hd__dfrtp_2
X_5623_ _7855_/Q _4833_/A _5633_/S VGND VGND VPWR VPWR _5624_/A sky130_fd_sc_hd__mux2_2
X_8342_ _8701_/CLK _8342_/D load_slew645/X VGND VGND VPWR VPWR _8342_/Q sky130_fd_sc_hd__dfrtp_2
XFILLER_129_293 VGND VGND VPWR VPWR sky130_fd_sc_hd__decap_3
XTAP_TAPCELL_ROW_135_2178 VGND VPWR sky130_fd_sc_hd__tapvpwrvgnd_1
XTAP_TAPCELL_ROW_135_2189 VGND VPWR sky130_fd_sc_hd__tapvpwrvgnd_1
X_5554_ _7822_/Q _5036_/A _5570_/S VGND VGND VPWR VPWR _5555_/A sky130_fd_sc_hd__mux2_2
XFILLER_132_403 VGND VGND VPWR VPWR sky130_fd_sc_hd__decap_3
X_8273_ _8678_/CLK _8273_/D fanout690/X VGND VGND VPWR VPWR _8273_/Q sky130_fd_sc_hd__dfrtp_2
X_5485_ _7790_/Q _4898_/A _5503_/S VGND VGND VPWR VPWR _5486_/A sky130_fd_sc_hd__mux2_2
X_4505_ _8442_/Q _8523_/Q _8604_/Q _8685_/Q _4502_/S _4503_/A VGND VGND VPWR VPWR
+ _4505_/X sky130_fd_sc_hd__mux4_2
XFILLER_116_15 VGND VGND VPWR VPWR sky130_fd_sc_hd__decap_3
XFILLER_132_436 VGND VGND VPWR VPWR sky130_fd_sc_hd__decap_3
XFILLER_6_80 VGND VGND VPWR VPWR sky130_fd_sc_hd__decap_3
XFILLER_6_91 VGND VGND VPWR VPWR sky130_fd_sc_hd__decap_3
X_7224_ wire234/X _4753_/X wire175/X wire205/X hold871/X VGND VGND VPWR VPWR _8656_/D
+ sky130_fd_sc_hd__a32o_2
X_4436_ _8355_/Q _3774_/X _4436_/B1 _8274_/Q _4677_/C1 VGND VGND VPWR VPWR _4436_/X
+ sky130_fd_sc_hd__o221a_2
XFILLER_113_650 VGND VGND VPWR VPWR sky130_fd_sc_hd__decap_3
XFILLER_132_469 VGND VGND VPWR VPWR sky130_fd_sc_hd__decap_3
Xfanout514 fanout516/X VGND VGND VPWR VPWR fanout514/X sky130_fd_sc_hd__clkdlybuf4s25_1
X_7155_ _7155_/A VGND VGND VPWR VPWR _8610_/D sky130_fd_sc_hd__buf_2
X_4367_ _8754_/Q _7529_/Q _4367_/S VGND VGND VPWR VPWR _4368_/B sky130_fd_sc_hd__mux2_2
XFILLER_58_203 VGND VGND VPWR VPWR sky130_fd_sc_hd__decap_3
XFILLER_98_361 VGND VGND VPWR VPWR sky130_fd_sc_hd__decap_3
Xfanout525 fanout527/X VGND VGND VPWR VPWR fanout525/X sky130_fd_sc_hd__clkdlybuf4s25_1
X_6106_ _8118_/Q _4874_/A _6116_/S VGND VGND VPWR VPWR _6107_/A sky130_fd_sc_hd__mux2_2
XFILLER_58_225 VGND VGND VPWR VPWR sky130_fd_sc_hd__fill_2
XFILLER_58_247 VGND VGND VPWR VPWR sky130_fd_sc_hd__decap_3
XFILLER_59_759 VGND VGND VPWR VPWR sky130_fd_sc_hd__decap_3
XFILLER_86_567 VGND VGND VPWR VPWR sky130_fd_sc_hd__fill_1
Xfanout569 fanout576/X VGND VGND VPWR VPWR fanout569/X sky130_fd_sc_hd__clkdlybuf4s25_1
X_7086_ _4765_/X hold945/X _7088_/S VGND VGND VPWR VPWR _7087_/A sky130_fd_sc_hd__mux2_1
X_4298_ _8343_/Q _3767_/A _3817_/A _8262_/Q _3758_/A VGND VGND VPWR VPWR _4298_/X
+ sky130_fd_sc_hd__o221a_2
XFILLER_100_355 VGND VGND VPWR VPWR sky130_fd_sc_hd__fill_1
XFILLER_27_601 VGND VGND VPWR VPWR sky130_fd_sc_hd__decap_3
XFILLER_27_612 VGND VGND VPWR VPWR sky130_fd_sc_hd__decap_3
XFILLER_86_589 VGND VGND VPWR VPWR sky130_fd_sc_hd__decap_3
X_6037_ _8085_/Q _4734_/A _6053_/S VGND VGND VPWR VPWR _6038_/A sky130_fd_sc_hd__mux2_2
XFILLER_132_47 VGND VGND VPWR VPWR sky130_fd_sc_hd__decap_3
XFILLER_67_781 VGND VGND VPWR VPWR sky130_fd_sc_hd__decap_3
XFILLER_73_228 VGND VGND VPWR VPWR sky130_fd_sc_hd__fill_2
XFILLER_25_12 VGND VGND VPWR VPWR sky130_fd_sc_hd__decap_3
XFILLER_26_133 VGND VGND VPWR VPWR sky130_fd_sc_hd__decap_3
XFILLER_26_144 VGND VGND VPWR VPWR sky130_fd_sc_hd__decap_3
XFILLER_42_604 VGND VGND VPWR VPWR sky130_fd_sc_hd__decap_3
XFILLER_66_291 VGND VGND VPWR VPWR sky130_fd_sc_hd__decap_3
XFILLER_92_29 VGND VGND VPWR VPWR sky130_fd_sc_hd__decap_3
XTAP_TAPCELL_ROW_68_1243 VGND VPWR sky130_fd_sc_hd__tapvpwrvgnd_1
XFILLER_25_45 VGND VGND VPWR VPWR sky130_fd_sc_hd__decap_3
XFILLER_42_637 VGND VGND VPWR VPWR sky130_fd_sc_hd__decap_3
XFILLER_54_497 VGND VGND VPWR VPWR sky130_fd_sc_hd__decap_3
X_7988_ _8483_/CLK _7988_/D fanout506/X VGND VGND VPWR VPWR _7988_/Q sky130_fd_sc_hd__dfrtp_2
XFILLER_25_78 VGND VGND VPWR VPWR sky130_fd_sc_hd__decap_3
XFILLER_41_136 VGND VGND VPWR VPWR sky130_fd_sc_hd__decap_3
XFILLER_42_648 VGND VGND VPWR VPWR sky130_fd_sc_hd__decap_3
XTAP_TAPCELL_ROW_81_1421 VGND VPWR sky130_fd_sc_hd__tapvpwrvgnd_1
XTAP_TAPCELL_ROW_81_1432 VGND VPWR sky130_fd_sc_hd__tapvpwrvgnd_1
X_6939_ _7002_/S VGND VGND VPWR VPWR _6958_/S sky130_fd_sc_hd__buf_6
XFILLER_22_361 VGND VGND VPWR VPWR sky130_fd_sc_hd__decap_3
XFILLER_41_169 VGND VGND VPWR VPWR sky130_fd_sc_hd__fill_1
XFILLER_41_11 VGND VGND VPWR VPWR sky130_fd_sc_hd__fill_1
XTAP_TAPCELL_ROW_40_849 VGND VPWR sky130_fd_sc_hd__tapvpwrvgnd_1
X_8609_ _8688_/CLK _8609_/D load_slew572/X VGND VGND VPWR VPWR _8609_/Q sky130_fd_sc_hd__dfrtp_2
XFILLER_108_433 VGND VGND VPWR VPWR sky130_fd_sc_hd__decap_3
XTAP_TAPCELL_ROW_20_573 VGND VPWR sky130_fd_sc_hd__tapvpwrvgnd_1
XFILLER_108_477 VGND VGND VPWR VPWR sky130_fd_sc_hd__fill_1
XTAP_TAPCELL_ROW_79_1394 VGND VPWR sky130_fd_sc_hd__tapvpwrvgnd_1
Xclkbuf_5_0__f_CLK clkbuf_4_0_0_CLK/X VGND VGND VPWR VPWR clkbuf_leaf_3_CLK/A sky130_fd_sc_hd__clkbuf_16
XFILLER_2_722 VGND VGND VPWR VPWR sky130_fd_sc_hd__decap_3
XFILLER_2_755 VGND VGND VPWR VPWR sky130_fd_sc_hd__fill_1
XFILLER_2_766 VGND VGND VPWR VPWR sky130_fd_sc_hd__decap_3
XFILLER_96_309 VGND VGND VPWR VPWR sky130_fd_sc_hd__decap_3
XFILLER_104_683 VGND VGND VPWR VPWR sky130_fd_sc_hd__fill_1
XFILLER_110_119 VGND VGND VPWR VPWR sky130_fd_sc_hd__decap_3
XFILLER_2_799 VGND VGND VPWR VPWR sky130_fd_sc_hd__fill_2
XTAP_TAPCELL_ROW_92_1583 VGND VPWR sky130_fd_sc_hd__tapvpwrvgnd_1
XFILLER_131_491 VGND VGND VPWR VPWR sky130_fd_sc_hd__decap_3
XFILLER_2_27 VGND VGND VPWR VPWR sky130_fd_sc_hd__fill_1
XFILLER_2_38 VGND VGND VPWR VPWR sky130_fd_sc_hd__decap_3
XFILLER_49_225 VGND VGND VPWR VPWR sky130_fd_sc_hd__fill_2
XFILLER_77_534 VGND VGND VPWR VPWR sky130_fd_sc_hd__decap_3
XFILLER_65_729 VGND VGND VPWR VPWR sky130_fd_sc_hd__decap_3
XFILLER_77_578 VGND VGND VPWR VPWR sky130_fd_sc_hd__decap_3
XFILLER_17_111 VGND VGND VPWR VPWR sky130_fd_sc_hd__fill_1
XFILLER_18_645 VGND VGND VPWR VPWR sky130_fd_sc_hd__decap_3
XFILLER_66_85 VGND VGND VPWR VPWR sky130_fd_sc_hd__decap_3
XFILLER_45_464 VGND VGND VPWR VPWR sky130_fd_sc_hd__decap_3
XFILLER_73_762 VGND VGND VPWR VPWR sky130_fd_sc_hd__decap_3
XFILLER_33_626 VGND VGND VPWR VPWR sky130_fd_sc_hd__decap_3
XFILLER_45_497 VGND VGND VPWR VPWR sky130_fd_sc_hd__decap_3
XFILLER_72_272 VGND VGND VPWR VPWR sky130_fd_sc_hd__decap_3
XTAP_TAPCELL_ROW_28_684 VGND VPWR sky130_fd_sc_hd__tapvpwrvgnd_1
XFILLER_17_199 VGND VGND VPWR VPWR sky130_fd_sc_hd__decap_3
XFILLER_32_147 VGND VGND VPWR VPWR sky130_fd_sc_hd__fill_2
XFILLER_33_659 VGND VGND VPWR VPWR sky130_fd_sc_hd__decap_3
XFILLER_41_670 VGND VGND VPWR VPWR sky130_fd_sc_hd__fill_2
XFILLER_9_343 VGND VGND VPWR VPWR sky130_fd_sc_hd__fill_1
XFILLER_9_365 VGND VGND VPWR VPWR sky130_fd_sc_hd__decap_3
XFILLER_127_753 VGND VGND VPWR VPWR sky130_fd_sc_hd__decap_3
XPHY_EDGE_ROW_124_Right_124 VGND VGND VPWR VPWR sky130_fd_sc_hd__decap_3
Xoutput106 _4094_/X VGND VGND VPWR VPWR rdata[27] sky130_fd_sc_hd__clkdlybuf4s25_1
XFILLER_114_436 VGND VGND VPWR VPWR sky130_fd_sc_hd__decap_3
XFILLER_127_797 VGND VGND VPWR VPWR sky130_fd_sc_hd__decap_3
Xoutput128 _4313_/X VGND VGND VPWR VPWR rdata[47] sky130_fd_sc_hd__clkdlybuf4s25_1
Xoutput139 _4431_/X VGND VGND VPWR VPWR rdata[57] sky130_fd_sc_hd__clkdlybuf4s25_1
Xoutput117 _4202_/X VGND VGND VPWR VPWR rdata[37] sky130_fd_sc_hd__clkdlybuf4s25_1
X_5270_ _5333_/S VGND VGND VPWR VPWR _5289_/S sky130_fd_sc_hd__buf_2
XFILLER_99_169 VGND VGND VPWR VPWR sky130_fd_sc_hd__decap_3
X_4221_ _4221_/A _4221_/B VGND VGND VPWR VPWR _4221_/X sky130_fd_sc_hd__or2_2
XFILLER_101_108 VGND VGND VPWR VPWR sky130_fd_sc_hd__decap_3
XTAP_TAPCELL_ROW_52_1022 VGND VPWR sky130_fd_sc_hd__tapvpwrvgnd_1
XFILLER_68_556 VGND VGND VPWR VPWR sky130_fd_sc_hd__decap_3
X_4152_ _8330_/Q _3921_/A _3889_/A _8249_/Q _3890_/A VGND VGND VPWR VPWR _4152_/X
+ sky130_fd_sc_hd__o221a_2
XFILLER_110_675 VGND VGND VPWR VPWR sky130_fd_sc_hd__decap_3
XFILLER_49_770 VGND VGND VPWR VPWR sky130_fd_sc_hd__decap_3
XFILLER_68_589 VGND VGND VPWR VPWR sky130_fd_sc_hd__fill_1
XTAP_TAPCELL_ROW_108_1800 VGND VPWR sky130_fd_sc_hd__tapvpwrvgnd_1
X_4083_ _7665_/Q _3750_/X _3752_/X _7584_/Q _4083_/C1 VGND VGND VPWR VPWR _4083_/X
+ sky130_fd_sc_hd__o221a_2
XTAP_TAPCELL_ROW_108_1811 VGND VPWR sky130_fd_sc_hd__tapvpwrvgnd_1
X_7911_ _8731_/CLK _7911_/D load_slew496/X VGND VGND VPWR VPWR _7911_/Q sky130_fd_sc_hd__dfrtp_2
XFILLER_102_17 VGND VGND VPWR VPWR sky130_fd_sc_hd__decap_3
XFILLER_64_751 VGND VGND VPWR VPWR sky130_fd_sc_hd__decap_3
XFILLER_24_604 VGND VGND VPWR VPWR sky130_fd_sc_hd__decap_3
XFILLER_24_637 VGND VGND VPWR VPWR sky130_fd_sc_hd__decap_3
XFILLER_36_486 VGND VGND VPWR VPWR sky130_fd_sc_hd__decap_3
XFILLER_51_401 VGND VGND VPWR VPWR sky130_fd_sc_hd__fill_2
XFILLER_64_773 VGND VGND VPWR VPWR sky130_fd_sc_hd__fill_2
X_7842_ _7923_/CLK _7842_/D fanout615/X VGND VGND VPWR VPWR _7842_/Q sky130_fd_sc_hd__dfrtp_2
XFILLER_24_648 VGND VGND VPWR VPWR sky130_fd_sc_hd__decap_3
XFILLER_51_423 VGND VGND VPWR VPWR sky130_fd_sc_hd__decap_3
X_7773_ _8019_/CLK _7773_/D load_slew714/X VGND VGND VPWR VPWR _7773_/Q sky130_fd_sc_hd__dfrtp_2
X_4985_ _4985_/A VGND VGND VPWR VPWR _4985_/X sky130_fd_sc_hd__buf_1
XFILLER_11_309 VGND VGND VPWR VPWR sky130_fd_sc_hd__fill_1
XFILLER_23_169 VGND VGND VPWR VPWR sky130_fd_sc_hd__fill_2
X_3936_ _8067_/Q _8148_/Q _8229_/Q _8310_/Q _3996_/S _4455_/A VGND VGND VPWR VPWR
+ _3936_/X sky130_fd_sc_hd__mux4_2
X_6724_ _6724_/A VGND VGND VPWR VPWR _8407_/D sky130_fd_sc_hd__buf_2
XTAP_TAPCELL_ROW_63_1173 VGND VPWR sky130_fd_sc_hd__tapvpwrvgnd_1
X_3867_ _7728_/Q _7809_/Q _7890_/Q _7971_/Q _3868_/S _3869_/A VGND VGND VPWR VPWR
+ _3867_/X sky130_fd_sc_hd__mux4_2
X_6655_ _6655_/A VGND VGND VPWR VPWR _8376_/D sky130_fd_sc_hd__buf_2
XTAP_TAPCELL_ROW_119_1962 VGND VPWR sky130_fd_sc_hd__tapvpwrvgnd_1
X_3798_ _8057_/Q _8138_/Q _3814_/S VGND VGND VPWR VPWR _3798_/X sky130_fd_sc_hd__mux2_2
X_6586_ _6586_/A VGND VGND VPWR VPWR _8343_/D sky130_fd_sc_hd__buf_2
X_5606_ _7847_/Q _4799_/A _5612_/S VGND VGND VPWR VPWR _5607_/A sky130_fd_sc_hd__mux2_2
XFILLER_11_36 VGND VGND VPWR VPWR sky130_fd_sc_hd__decap_3
X_8325_ _8658_/CLK _8325_/D load_slew529/X VGND VGND VPWR VPWR _8325_/Q sky130_fd_sc_hd__dfrtp_2
X_5537_ _7814_/Q _5003_/A _5549_/S VGND VGND VPWR VPWR _5538_/A sky130_fd_sc_hd__mux2_2
XFILLER_117_263 VGND VGND VPWR VPWR sky130_fd_sc_hd__fill_1
XFILLER_11_69 VGND VGND VPWR VPWR sky130_fd_sc_hd__decap_3
XFILLER_127_36 VGND VGND VPWR VPWR sky130_fd_sc_hd__decap_3
XFILLER_132_200 VGND VGND VPWR VPWR sky130_fd_sc_hd__decap_3
XFILLER_133_712 VGND VGND VPWR VPWR sky130_fd_sc_hd__decap_3
X_8256_ _8734_/CLK _8256_/D fanout527/X VGND VGND VPWR VPWR _8256_/Q sky130_fd_sc_hd__dfrtp_2
XFILLER_105_447 VGND VGND VPWR VPWR sky130_fd_sc_hd__fill_1
XFILLER_127_69 VGND VGND VPWR VPWR sky130_fd_sc_hd__decap_3
XFILLER_132_233 VGND VGND VPWR VPWR sky130_fd_sc_hd__decap_3
XFILLER_133_756 VGND VGND VPWR VPWR sky130_fd_sc_hd__decap_3
XFILLER_2_9 VGND VGND VPWR VPWR sky130_fd_sc_hd__decap_3
XFILLER_78_309 VGND VGND VPWR VPWR sky130_fd_sc_hd__decap_3
X_7207_ _7213_/A1 _5036_/X _7216_/A3 _7216_/B1 hold801/X VGND VGND VPWR VPWR _8642_/D
+ sky130_fd_sc_hd__a32o_2
X_5468_ _7782_/Q _4865_/A _5482_/S VGND VGND VPWR VPWR _5469_/A sky130_fd_sc_hd__mux2_2
XFILLER_120_417 VGND VGND VPWR VPWR sky130_fd_sc_hd__decap_3
XFILLER_132_277 VGND VGND VPWR VPWR sky130_fd_sc_hd__decap_3
Xfanout311 fanout314/X VGND VGND VPWR VPWR _3988_/A sky130_fd_sc_hd__clkdlybuf4s25_1
Xfanout322 wire330/A VGND VGND VPWR VPWR _4342_/B2 sky130_fd_sc_hd__clkdlybuf4s25_1
X_8187_ _8754_/CLK _8187_/D load_slew691/X VGND VGND VPWR VPWR _8187_/Q sky130_fd_sc_hd__dfrtp_2
X_5399_ _5399_/A VGND VGND VPWR VPWR _7749_/D sky130_fd_sc_hd__buf_1
X_4419_ _4458_/B2 _4410_/X _4413_/X _4418_/X VGND VGND VPWR VPWR _4419_/X sky130_fd_sc_hd__o31a_2
Xfanout333 _4110_/S1 VGND VGND VPWR VPWR _4106_/S1 sky130_fd_sc_hd__clkdlybuf4s25_1
Xfanout344 fanout364/X VGND VGND VPWR VPWR fanout344/X sky130_fd_sc_hd__clkdlybuf4s25_1
Xfanout355 _4496_/A1 VGND VGND VPWR VPWR _4082_/A sky130_fd_sc_hd__clkdlybuf4s25_1
X_7138_ _7138_/A VGND VGND VPWR VPWR _8602_/D sky130_fd_sc_hd__buf_2
XFILLER_47_729 VGND VGND VPWR VPWR sky130_fd_sc_hd__fill_2
XTAP_TAPCELL_ROW_6_379 VGND VPWR sky130_fd_sc_hd__tapvpwrvgnd_1
Xfanout388 _4636_/S1 VGND VGND VPWR VPWR _4581_/A1 sky130_fd_sc_hd__clkdlybuf4s25_1
X_7069_ _7174_/S VGND VGND VPWR VPWR _7088_/S sky130_fd_sc_hd__buf_4
XFILLER_46_217 VGND VGND VPWR VPWR sky130_fd_sc_hd__decap_3
XFILLER_46_239 VGND VGND VPWR VPWR sky130_fd_sc_hd__decap_3
XFILLER_74_526 VGND VGND VPWR VPWR sky130_fd_sc_hd__decap_3
XFILLER_86_386 VGND VGND VPWR VPWR sky130_fd_sc_hd__decap_3
XFILLER_36_44 VGND VGND VPWR VPWR sky130_fd_sc_hd__fill_1
XFILLER_55_762 VGND VGND VPWR VPWR sky130_fd_sc_hd__decap_3
XTAP_TAPCELL_ROW_45_919 VGND VPWR sky130_fd_sc_hd__tapvpwrvgnd_1
XFILLER_14_103 VGND VGND VPWR VPWR sky130_fd_sc_hd__decap_3
XFILLER_36_88 VGND VGND VPWR VPWR sky130_fd_sc_hd__decap_3
XFILLER_70_710 VGND VGND VPWR VPWR sky130_fd_sc_hd__decap_3
XFILLER_14_136 VGND VGND VPWR VPWR sky130_fd_sc_hd__decap_3
XFILLER_15_659 VGND VGND VPWR VPWR sky130_fd_sc_hd__fill_1
XFILLER_42_434 VGND VGND VPWR VPWR sky130_fd_sc_hd__fill_2
XFILLER_54_283 VGND VGND VPWR VPWR sky130_fd_sc_hd__fill_2
XFILLER_82_592 VGND VGND VPWR VPWR sky130_fd_sc_hd__decap_3
XTAP_TAPCELL_ROW_25_643 VGND VPWR sky130_fd_sc_hd__tapvpwrvgnd_1
XFILLER_14_147 VGND VGND VPWR VPWR sky130_fd_sc_hd__fill_1
XFILLER_30_607 VGND VGND VPWR VPWR sky130_fd_sc_hd__fill_1
XFILLER_128_528 VGND VGND VPWR VPWR sky130_fd_sc_hd__decap_3
XFILLER_7_803 VGND VGND VPWR VPWR sky130_fd_sc_hd__fill_1
Xinput19 wdata[24] VGND VGND VPWR VPWR _4706_/A sky130_fd_sc_hd__clkdlybuf4s25_1
Xwire701 wire701/A VGND VGND VPWR VPWR wire701/X sky130_fd_sc_hd__clkbuf_4
XFILLER_109_720 VGND VGND VPWR VPWR sky130_fd_sc_hd__decap_3
XFILLER_128_539 VGND VGND VPWR VPWR sky130_fd_sc_hd__decap_3
XFILLER_108_241 VGND VGND VPWR VPWR sky130_fd_sc_hd__decap_3
XFILLER_109_753 VGND VGND VPWR VPWR sky130_fd_sc_hd__fill_1
XTAP_TAPCELL_ROW_94_1612 VGND VPWR sky130_fd_sc_hd__tapvpwrvgnd_1
XFILLER_2_530 VGND VGND VPWR VPWR sky130_fd_sc_hd__fill_2
XFILLER_111_428 VGND VGND VPWR VPWR sky130_fd_sc_hd__decap_3
XFILLER_35_9 VGND VGND VPWR VPWR sky130_fd_sc_hd__decap_3
XFILLER_77_331 VGND VGND VPWR VPWR sky130_fd_sc_hd__decap_3
XFILLER_77_51 VGND VGND VPWR VPWR sky130_fd_sc_hd__decap_3
XFILLER_37_228 VGND VGND VPWR VPWR sky130_fd_sc_hd__decap_3
XFILLER_133_90 VGND VGND VPWR VPWR sky130_fd_sc_hd__decap_3
XFILLER_92_356 VGND VGND VPWR VPWR sky130_fd_sc_hd__decap_3
XFILLER_93_50 VGND VGND VPWR VPWR sky130_fd_sc_hd__decap_3
XFILLER_33_412 VGND VGND VPWR VPWR sky130_fd_sc_hd__decap_3
XFILLER_46_784 VGND VGND VPWR VPWR sky130_fd_sc_hd__decap_3
XTAP_TAPCELL_ROW_103_1730 VGND VPWR sky130_fd_sc_hd__tapvpwrvgnd_1
XFILLER_21_629 VGND VGND VPWR VPWR sky130_fd_sc_hd__decap_3
XFILLER_33_478 VGND VGND VPWR VPWR sky130_fd_sc_hd__fill_2
XFILLER_60_253 VGND VGND VPWR VPWR sky130_fd_sc_hd__decap_3
XTAP_TAPCELL_ROW_103_1741 VGND VPWR sky130_fd_sc_hd__tapvpwrvgnd_1
XFILLER_33_489 VGND VGND VPWR VPWR sky130_fd_sc_hd__fill_2
X_4770_ _4769_/X _7516_/Q _4778_/S VGND VGND VPWR VPWR _4771_/A sky130_fd_sc_hd__mux2_2
XFILLER_119_528 VGND VGND VPWR VPWR sky130_fd_sc_hd__decap_3
X_3721_ _3721_/A VGND VGND VPWR VPWR _8045_/D sky130_fd_sc_hd__buf_1
XFILLER_9_184 VGND VGND VPWR VPWR sky130_fd_sc_hd__decap_3
X_6440_ _4853_/X _8275_/Q _6440_/S VGND VGND VPWR VPWR _6441_/A sky130_fd_sc_hd__mux2_2
XFILLER_127_550 VGND VGND VPWR VPWR sky130_fd_sc_hd__decap_3
XFILLER_127_561 VGND VGND VPWR VPWR sky130_fd_sc_hd__decap_3
XTAP_TAPCELL_ROW_132_2137 VGND VPWR sky130_fd_sc_hd__tapvpwrvgnd_1
X_6371_ _4715_/X hold974/X _6377_/S VGND VGND VPWR VPWR _6372_/A sky130_fd_sc_hd__mux2_1
XFILLER_114_200 VGND VGND VPWR VPWR sky130_fd_sc_hd__fill_1
XFILLER_127_594 VGND VGND VPWR VPWR sky130_fd_sc_hd__decap_3
X_8110_ _8593_/CLK _8110_/D load_slew710/X VGND VGND VPWR VPWR _8110_/Q sky130_fd_sc_hd__dfrtp_2
X_5322_ _5322_/A VGND VGND VPWR VPWR _7713_/D sky130_fd_sc_hd__buf_1
XFILLER_115_767 VGND VGND VPWR VPWR sky130_fd_sc_hd__decap_3
XFILLER_130_704 VGND VGND VPWR VPWR sky130_fd_sc_hd__decap_3
XFILLER_130_737 VGND VGND VPWR VPWR sky130_fd_sc_hd__decap_3
XTAP_TAPCELL_ROW_114_1892 VGND VPWR sky130_fd_sc_hd__tapvpwrvgnd_1
X_8041_ _8697_/CLK _8041_/D load_slew718/X VGND VGND VPWR VPWR _8041_/Q sky130_fd_sc_hd__dfrtp_2
X_5253_ _5253_/A VGND VGND VPWR VPWR _7680_/D sky130_fd_sc_hd__buf_1
X_5184_ _7648_/Q _4985_/X _5184_/S VGND VGND VPWR VPWR _5185_/A sky130_fd_sc_hd__mux2_2
X_4204_ _8254_/Q _3889_/X _4203_/X _4151_/A _4315_/C1 VGND VGND VPWR VPWR _4204_/X
+ sky130_fd_sc_hd__o221a_2
XFILLER_29_729 VGND VGND VPWR VPWR sky130_fd_sc_hd__decap_3
XFILLER_3_81 VGND VGND VPWR VPWR sky130_fd_sc_hd__decap_3
X_4135_ _4151_/A _4133_/X _4134_/X VGND VGND VPWR VPWR _4135_/X sky130_fd_sc_hd__o21a_2
XFILLER_110_483 VGND VGND VPWR VPWR sky130_fd_sc_hd__fill_1
XFILLER_83_301 VGND VGND VPWR VPWR sky130_fd_sc_hd__decap_3
XFILLER_95_172 VGND VGND VPWR VPWR sky130_fd_sc_hd__decap_3
XTAP_TAPCELL_ROW_3_338 VGND VPWR sky130_fd_sc_hd__tapvpwrvgnd_1
XFILLER_56_559 VGND VGND VPWR VPWR sky130_fd_sc_hd__decap_3
X_4066_ _8403_/Q _8484_/Q _4100_/S VGND VGND VPWR VPWR _4066_/X sky130_fd_sc_hd__mux2_2
XFILLER_52_710 VGND VGND VPWR VPWR sky130_fd_sc_hd__decap_3
XFILLER_64_570 VGND VGND VPWR VPWR sky130_fd_sc_hd__decap_3
XFILLER_83_378 VGND VGND VPWR VPWR sky130_fd_sc_hd__fill_1
XTAP_TAPCELL_ROW_65_1202 VGND VPWR sky130_fd_sc_hd__tapvpwrvgnd_1
XFILLER_51_220 VGND VGND VPWR VPWR sky130_fd_sc_hd__decap_3
X_7825_ _8730_/CLK _7825_/D load_slew499/X VGND VGND VPWR VPWR _7825_/Q sky130_fd_sc_hd__dfrtp_2
XFILLER_12_607 VGND VGND VPWR VPWR sky130_fd_sc_hd__decap_3
XFILLER_24_456 VGND VGND VPWR VPWR sky130_fd_sc_hd__decap_3
XFILLER_51_253 VGND VGND VPWR VPWR sky130_fd_sc_hd__decap_3
XFILLER_24_489 VGND VGND VPWR VPWR sky130_fd_sc_hd__fill_2
XTAP_TAPCELL_ROW_22_602 VGND VPWR sky130_fd_sc_hd__tapvpwrvgnd_1
X_7756_ _8495_/CLK _7756_/D load_slew511/X VGND VGND VPWR VPWR _7756_/Q sky130_fd_sc_hd__dfrtp_2
X_4968_ _4968_/A _4984_/B VGND VGND VPWR VPWR _4969_/A sky130_fd_sc_hd__and2_2
X_3919_ _8390_/Q _8471_/Q _3973_/S VGND VGND VPWR VPWR _3920_/B sky130_fd_sc_hd__mux2_2
X_7687_ _8750_/CLK _7687_/D load_slew636/X VGND VGND VPWR VPWR _7687_/Q sky130_fd_sc_hd__dfrtp_2
X_6707_ _8399_/Q _5035_/A _6723_/S VGND VGND VPWR VPWR _6708_/A sky130_fd_sc_hd__mux2_2
X_4899_ _4899_/A VGND VGND VPWR VPWR _4899_/X sky130_fd_sc_hd__buf_1
XFILLER_20_662 VGND VGND VPWR VPWR sky130_fd_sc_hd__decap_3
XFILLER_20_684 VGND VGND VPWR VPWR sky130_fd_sc_hd__fill_2
XFILLER_22_35 VGND VGND VPWR VPWR sky130_fd_sc_hd__decap_3
XTAP_TAPCELL_ROW_50_988 VGND VPWR sky130_fd_sc_hd__tapvpwrvgnd_1
XTAP_TAPCELL_ROW_50_999 VGND VPWR sky130_fd_sc_hd__tapvpwrvgnd_1
X_6638_ _4903_/X _8368_/Q _6654_/S VGND VGND VPWR VPWR _6639_/A sky130_fd_sc_hd__mux2_2
XFILLER_106_701 VGND VGND VPWR VPWR sky130_fd_sc_hd__decap_3
XFILLER_118_6 VGND VGND VPWR VPWR sky130_fd_sc_hd__decap_3
XFILLER_22_68 VGND VGND VPWR VPWR sky130_fd_sc_hd__decap_3
XFILLER_106_734 VGND VGND VPWR VPWR sky130_fd_sc_hd__decap_3
XFILLER_133_520 VGND VGND VPWR VPWR sky130_fd_sc_hd__decap_3
X_8308_ _8794_/CLK _8308_/D load_slew579/X VGND VGND VPWR VPWR _8308_/Q sky130_fd_sc_hd__dfrtp_2
X_6569_ _6569_/A VGND VGND VPWR VPWR _8335_/D sky130_fd_sc_hd__buf_2
XFILLER_0_6 VGND VGND VPWR VPWR sky130_fd_sc_hd__decap_3
XFILLER_133_553 VGND VGND VPWR VPWR sky130_fd_sc_hd__decap_3
XTAP_TAPCELL_ROW_76_1353 VGND VPWR sky130_fd_sc_hd__tapvpwrvgnd_1
XFILLER_105_266 VGND VGND VPWR VPWR sky130_fd_sc_hd__decap_3
XFILLER_133_564 VGND VGND VPWR VPWR sky130_fd_sc_hd__decap_3
XFILLER_79_629 VGND VGND VPWR VPWR sky130_fd_sc_hd__decap_3
X_8239_ _8648_/CLK _8239_/D load_slew489/X VGND VGND VPWR VPWR _8239_/Q sky130_fd_sc_hd__dfrtp_2
XFILLER_120_236 VGND VGND VPWR VPWR sky130_fd_sc_hd__fill_2
XFILLER_133_597 VGND VGND VPWR VPWR sky130_fd_sc_hd__decap_3
XFILLER_87_640 VGND VGND VPWR VPWR sky130_fd_sc_hd__decap_3
XFILLER_120_247 VGND VGND VPWR VPWR sky130_fd_sc_hd__decap_3
XFILLER_75_802 VGND VGND VPWR VPWR sky130_fd_sc_hd__fill_2
XFILLER_86_150 VGND VGND VPWR VPWR sky130_fd_sc_hd__decap_3
XFILLER_87_673 VGND VGND VPWR VPWR sky130_fd_sc_hd__decap_3
XFILLER_74_312 VGND VGND VPWR VPWR sky130_fd_sc_hd__fill_1
XFILLER_86_183 VGND VGND VPWR VPWR sky130_fd_sc_hd__decap_3
XFILLER_28_740 VGND VGND VPWR VPWR sky130_fd_sc_hd__fill_2
XFILLER_47_98 VGND VGND VPWR VPWR sky130_fd_sc_hd__decap_3
XFILLER_74_334 VGND VGND VPWR VPWR sky130_fd_sc_hd__decap_3
XFILLER_103_60 VGND VGND VPWR VPWR sky130_fd_sc_hd__decap_3
XFILLER_34_209 VGND VGND VPWR VPWR sky130_fd_sc_hd__decap_3
XFILLER_55_570 VGND VGND VPWR VPWR sky130_fd_sc_hd__decap_3
XFILLER_62_529 VGND VGND VPWR VPWR sky130_fd_sc_hd__decap_3
XFILLER_27_294 VGND VGND VPWR VPWR sky130_fd_sc_hd__decap_3
XFILLER_42_220 VGND VGND VPWR VPWR sky130_fd_sc_hd__fill_2
XFILLER_43_732 VGND VGND VPWR VPWR sky130_fd_sc_hd__fill_1
XFILLER_43_754 VGND VGND VPWR VPWR sky130_fd_sc_hd__decap_3
XFILLER_15_467 VGND VGND VPWR VPWR sky130_fd_sc_hd__decap_3
XFILLER_42_242 VGND VGND VPWR VPWR sky130_fd_sc_hd__decap_3
XFILLER_42_253 VGND VGND VPWR VPWR sky130_fd_sc_hd__decap_3
XFILLER_42_264 VGND VGND VPWR VPWR sky130_fd_sc_hd__decap_3
XFILLER_63_53 VGND VGND VPWR VPWR sky130_fd_sc_hd__decap_3
XPHY_EDGE_ROW_69_Right_69 VGND VGND VPWR VPWR sky130_fd_sc_hd__decap_3
XFILLER_8_15 VGND VGND VPWR VPWR sky130_fd_sc_hd__decap_3
XFILLER_11_662 VGND VGND VPWR VPWR sky130_fd_sc_hd__fill_1
XFILLER_11_673 VGND VGND VPWR VPWR sky130_fd_sc_hd__decap_3
XFILLER_128_336 VGND VGND VPWR VPWR sky130_fd_sc_hd__decap_3
XFILLER_7_611 VGND VGND VPWR VPWR sky130_fd_sc_hd__decap_3
XFILLER_8_59 VGND VGND VPWR VPWR sky130_fd_sc_hd__decap_3
Xwire531 wire531/A VGND VGND VPWR VPWR wire531/X sky130_fd_sc_hd__clkbuf_4
XFILLER_128_358 VGND VGND VPWR VPWR sky130_fd_sc_hd__decap_3
XFILLER_6_132 VGND VGND VPWR VPWR sky130_fd_sc_hd__decap_3
XFILLER_7_644 VGND VGND VPWR VPWR sky130_fd_sc_hd__decap_3
XFILLER_109_561 VGND VGND VPWR VPWR sky130_fd_sc_hd__decap_3
XFILLER_109_583 VGND VGND VPWR VPWR sky130_fd_sc_hd__decap_3
XFILLER_6_165 VGND VGND VPWR VPWR sky130_fd_sc_hd__fill_2
XFILLER_7_688 VGND VGND VPWR VPWR sky130_fd_sc_hd__decap_3
XFILLER_124_531 VGND VGND VPWR VPWR sky130_fd_sc_hd__fill_1
XPHY_EDGE_ROW_78_Right_78 VGND VGND VPWR VPWR sky130_fd_sc_hd__decap_3
XFILLER_112_704 VGND VGND VPWR VPWR sky130_fd_sc_hd__decap_3
Xload_slew503 fanout502/X VGND VGND VPWR VPWR load_slew503/X sky130_fd_sc_hd__buf_4
XFILLER_111_225 VGND VGND VPWR VPWR sky130_fd_sc_hd__fill_2
XFILLER_88_83 VGND VGND VPWR VPWR sky130_fd_sc_hd__fill_1
XFILLER_88_94 VGND VGND VPWR VPWR sky130_fd_sc_hd__decap_3
Xload_slew536 fanout535/X VGND VGND VPWR VPWR load_slew536/X sky130_fd_sc_hd__buf_2
XFILLER_111_258 VGND VGND VPWR VPWR sky130_fd_sc_hd__decap_3
Xload_slew558 fanout557/X VGND VGND VPWR VPWR load_slew558/X sky130_fd_sc_hd__clkbuf_4
XFILLER_120_781 VGND VGND VPWR VPWR sky130_fd_sc_hd__fill_2
XFILLER_38_515 VGND VGND VPWR VPWR sky130_fd_sc_hd__decap_3
XFILLER_77_172 VGND VGND VPWR VPWR sky130_fd_sc_hd__decap_3
XFILLER_78_684 VGND VGND VPWR VPWR sky130_fd_sc_hd__decap_3
XFILLER_65_334 VGND VGND VPWR VPWR sky130_fd_sc_hd__fill_2
XFILLER_80_304 VGND VGND VPWR VPWR sky130_fd_sc_hd__decap_3
XFILLER_80_315 VGND VGND VPWR VPWR sky130_fd_sc_hd__fill_1
X_5940_ _5944_/A1 _5934_/X _4875_/X _5935_/X hold818/X VGND VGND VPWR VPWR _8027_/D
+ sky130_fd_sc_hd__a32o_2
XFILLER_18_272 VGND VGND VPWR VPWR sky130_fd_sc_hd__decap_3
XFILLER_34_721 VGND VGND VPWR VPWR sky130_fd_sc_hd__decap_3
XFILLER_80_337 VGND VGND VPWR VPWR sky130_fd_sc_hd__decap_3
XPHY_EDGE_ROW_87_Right_87 VGND VGND VPWR VPWR sky130_fd_sc_hd__decap_3
XFILLER_61_551 VGND VGND VPWR VPWR sky130_fd_sc_hd__decap_3
X_7610_ _8672_/CLK _7610_/D load_slew689/X VGND VGND VPWR VPWR _7610_/Q sky130_fd_sc_hd__dfrtp_2
X_5871_ _5880_/A1 _5869_/X _4989_/X _5870_/X hold815/X VGND VGND VPWR VPWR _7973_/D
+ sky130_fd_sc_hd__a32o_2
X_8590_ _8672_/CLK _8590_/D load_slew689/X VGND VGND VPWR VPWR _8590_/Q sky130_fd_sc_hd__dfrtp_2
X_4822_ _4951_/A VGND VGND VPWR VPWR _4860_/B sky130_fd_sc_hd__clkbuf_1
XTAP_TAPCELL_ROW_60_1132 VGND VPWR sky130_fd_sc_hd__tapvpwrvgnd_1
X_7541_ _8029_/CLK _7541_/D load_slew570/X VGND VGND VPWR VPWR _7541_/Q sky130_fd_sc_hd__dfrtp_2
X_4753_ _4753_/A VGND VGND VPWR VPWR _4753_/X sky130_fd_sc_hd__buf_1
X_7472_ _4985_/X _8792_/Q _7474_/S VGND VGND VPWR VPWR _7473_/A sky130_fd_sc_hd__mux2_2
XFILLER_119_369 VGND VGND VPWR VPWR sky130_fd_sc_hd__fill_2
XTAP_TAPCELL_ROW_116_1910 VGND VPWR sky130_fd_sc_hd__tapvpwrvgnd_1
X_6423_ _6423_/A VGND VGND VPWR VPWR _8266_/D sky130_fd_sc_hd__buf_2
X_4684_ _4681_/X _4682_/X _4683_/X _4684_/B2 _4684_/C1 VGND VGND VPWR VPWR _4684_/X
+ sky130_fd_sc_hd__a221o_2
XPHY_EDGE_ROW_96_Right_96 VGND VGND VPWR VPWR sky130_fd_sc_hd__decap_3
XTAP_TAPCELL_ROW_116_1921 VGND VPWR sky130_fd_sc_hd__tapvpwrvgnd_1
XTAP_TAPCELL_ROW_8_408 VGND VPWR sky130_fd_sc_hd__tapvpwrvgnd_1
X_6354_ _5023_/X _8234_/Q _6356_/S VGND VGND VPWR VPWR _6355_/A sky130_fd_sc_hd__mux2_2
XFILLER_103_726 VGND VGND VPWR VPWR sky130_fd_sc_hd__fill_2
XFILLER_130_501 VGND VGND VPWR VPWR sky130_fd_sc_hd__decap_3
X_6285_ _4887_/X _8202_/Q _6289_/S VGND VGND VPWR VPWR _6286_/A sky130_fd_sc_hd__mux2_4
X_5305_ _5305_/A VGND VGND VPWR VPWR _7705_/D sky130_fd_sc_hd__buf_1
XFILLER_115_597 VGND VGND VPWR VPWR sky130_fd_sc_hd__fill_1
XFILLER_130_545 VGND VGND VPWR VPWR sky130_fd_sc_hd__decap_3
XFILLER_88_437 VGND VGND VPWR VPWR sky130_fd_sc_hd__fill_1
X_8024_ _8765_/CLK _8024_/D load_slew582/X VGND VGND VPWR VPWR _8024_/Q sky130_fd_sc_hd__dfrtp_2
X_5236_ _5236_/A VGND VGND VPWR VPWR _7672_/D sky130_fd_sc_hd__buf_1
XFILLER_124_15 VGND VGND VPWR VPWR sky130_fd_sc_hd__decap_3
XFILLER_130_578 VGND VGND VPWR VPWR sky130_fd_sc_hd__decap_3
XFILLER_130_589 VGND VGND VPWR VPWR sky130_fd_sc_hd__decap_3
XFILLER_56_301 VGND VGND VPWR VPWR sky130_fd_sc_hd__decap_3
XFILLER_69_673 VGND VGND VPWR VPWR sky130_fd_sc_hd__decap_3
XTAP_TAPCELL_ROW_71_1283 VGND VPWR sky130_fd_sc_hd__tapvpwrvgnd_1
X_5167_ _5167_/A VGND VGND VPWR VPWR _7639_/D sky130_fd_sc_hd__buf_1
XFILLER_84_665 VGND VGND VPWR VPWR sky130_fd_sc_hd__decap_3
X_5098_ _4815_/X _7608_/Q _5116_/S VGND VGND VPWR VPWR _5099_/A sky130_fd_sc_hd__mux2_2
X_4118_ _8084_/Q _8165_/Q _8246_/Q _8327_/Q _4166_/S0 _4166_/S1 VGND VGND VPWR VPWR
+ _4118_/X sky130_fd_sc_hd__mux4_2
XFILLER_17_24 VGND VGND VPWR VPWR sky130_fd_sc_hd__decap_3
XFILLER_83_164 VGND VGND VPWR VPWR sky130_fd_sc_hd__decap_3
XFILLER_84_698 VGND VGND VPWR VPWR sky130_fd_sc_hd__fill_2
X_4049_ _4047_/X _4048_/X _4514_/S VGND VGND VPWR VPWR _4049_/X sky130_fd_sc_hd__mux2_2
XFILLER_17_57 VGND VGND VPWR VPWR sky130_fd_sc_hd__decap_3
XFILLER_25_732 VGND VGND VPWR VPWR sky130_fd_sc_hd__decap_3
XFILLER_71_337 VGND VGND VPWR VPWR sky130_fd_sc_hd__decap_3
XFILLER_83_186 VGND VGND VPWR VPWR sky130_fd_sc_hd__decap_3
XFILLER_24_231 VGND VGND VPWR VPWR sky130_fd_sc_hd__decap_3
XFILLER_24_253 VGND VGND VPWR VPWR sky130_fd_sc_hd__fill_1
XFILLER_52_551 VGND VGND VPWR VPWR sky130_fd_sc_hd__decap_3
XFILLER_12_404 VGND VGND VPWR VPWR sky130_fd_sc_hd__decap_3
XFILLER_40_735 VGND VGND VPWR VPWR sky130_fd_sc_hd__decap_3
XTAP_TAPCELL_ROW_35_782 VGND VPWR sky130_fd_sc_hd__tapvpwrvgnd_1
X_8788_ _8788_/CLK _8788_/D fanout664/X VGND VGND VPWR VPWR _8788_/Q sky130_fd_sc_hd__dfrtp_2
X_7808_ _8462_/CLK _7808_/D wire669/X VGND VGND VPWR VPWR _7808_/Q sky130_fd_sc_hd__dfrtp_2
XFILLER_40_757 VGND VGND VPWR VPWR sky130_fd_sc_hd__decap_3
XFILLER_8_419 VGND VGND VPWR VPWR sky130_fd_sc_hd__fill_1
X_7739_ _8470_/CLK _7739_/D fanout586/X VGND VGND VPWR VPWR _7739_/Q sky130_fd_sc_hd__dfrtp_2
XFILLER_33_78 VGND VGND VPWR VPWR sky130_fd_sc_hd__fill_2
XFILLER_116_3 VGND VGND VPWR VPWR sky130_fd_sc_hd__decap_3
XFILLER_3_102 VGND VGND VPWR VPWR sky130_fd_sc_hd__decap_3
XFILLER_4_625 VGND VGND VPWR VPWR sky130_fd_sc_hd__decap_3
XFILLER_106_542 VGND VGND VPWR VPWR sky130_fd_sc_hd__decap_3
XFILLER_106_575 VGND VGND VPWR VPWR sky130_fd_sc_hd__fill_2
XFILLER_133_361 VGND VGND VPWR VPWR sky130_fd_sc_hd__decap_3
XFILLER_4_669 VGND VGND VPWR VPWR sky130_fd_sc_hd__decap_3
XPHY_EDGE_ROW_18_Left_154 VGND VGND VPWR VPWR sky130_fd_sc_hd__decap_3
XFILLER_121_534 VGND VGND VPWR VPWR sky130_fd_sc_hd__decap_3
XFILLER_79_426 VGND VGND VPWR VPWR sky130_fd_sc_hd__decap_3
XFILLER_121_567 VGND VGND VPWR VPWR sky130_fd_sc_hd__decap_3
XFILLER_47_334 VGND VGND VPWR VPWR sky130_fd_sc_hd__fill_2
XFILLER_75_643 VGND VGND VPWR VPWR sky130_fd_sc_hd__decap_3
XTAP_TAPCELL_ROW_89_1533 VGND VPWR sky130_fd_sc_hd__tapvpwrvgnd_1
XTAP_TAPCELL_ROW_89_1544 VGND VPWR sky130_fd_sc_hd__tapvpwrvgnd_1
XFILLER_114_81 VGND VGND VPWR VPWR sky130_fd_sc_hd__decap_3
XFILLER_16_710 VGND VGND VPWR VPWR sky130_fd_sc_hd__fill_2
XFILLER_74_41 VGND VGND VPWR VPWR sky130_fd_sc_hd__decap_3
XFILLER_74_52 VGND VGND VPWR VPWR sky130_fd_sc_hd__decap_3
XFILLER_62_337 VGND VGND VPWR VPWR sky130_fd_sc_hd__decap_3
XFILLER_74_197 VGND VGND VPWR VPWR sky130_fd_sc_hd__decap_3
XFILLER_90_635 VGND VGND VPWR VPWR sky130_fd_sc_hd__decap_3
XFILLER_90_657 VGND VGND VPWR VPWR sky130_fd_sc_hd__decap_3
XPHY_EDGE_ROW_27_Left_163 VGND VGND VPWR VPWR sky130_fd_sc_hd__decap_3
XFILLER_90_679 VGND VGND VPWR VPWR sky130_fd_sc_hd__decap_3
XFILLER_130_80 VGND VGND VPWR VPWR sky130_fd_sc_hd__decap_3
XFILLER_43_584 VGND VGND VPWR VPWR sky130_fd_sc_hd__fill_1
XFILLER_130_91 VGND VGND VPWR VPWR sky130_fd_sc_hd__decap_3
XFILLER_30_234 VGND VGND VPWR VPWR sky130_fd_sc_hd__decap_3
XFILLER_90_62 VGND VGND VPWR VPWR sky130_fd_sc_hd__decap_3
XFILLER_128_100 VGND VGND VPWR VPWR sky130_fd_sc_hd__decap_3
XFILLER_129_612 VGND VGND VPWR VPWR sky130_fd_sc_hd__decap_3
XFILLER_129_623 VGND VGND VPWR VPWR sky130_fd_sc_hd__decap_3
XFILLER_30_278 VGND VGND VPWR VPWR sky130_fd_sc_hd__decap_3
XTAP_TAPCELL_ROW_13_476 VGND VPWR sky130_fd_sc_hd__tapvpwrvgnd_1
XFILLER_128_133 VGND VGND VPWR VPWR sky130_fd_sc_hd__decap_3
XFILLER_128_144 VGND VGND VPWR VPWR sky130_fd_sc_hd__decap_3
XFILLER_129_656 VGND VGND VPWR VPWR sky130_fd_sc_hd__decap_3
XFILLER_7_430 VGND VGND VPWR VPWR sky130_fd_sc_hd__decap_3
XFILLER_128_177 VGND VGND VPWR VPWR sky130_fd_sc_hd__decap_3
XFILLER_109_391 VGND VGND VPWR VPWR sky130_fd_sc_hd__fill_1
XPHY_EDGE_ROW_36_Left_172 VGND VGND VPWR VPWR sky130_fd_sc_hd__decap_3
XFILLER_99_93 VGND VGND VPWR VPWR sky130_fd_sc_hd__decap_3
XFILLER_31_3 VGND VGND VPWR VPWR sky130_fd_sc_hd__decap_3
XFILLER_3_691 VGND VGND VPWR VPWR sky130_fd_sc_hd__decap_3
XFILLER_97_223 VGND VGND VPWR VPWR sky130_fd_sc_hd__fill_1
XFILLER_98_757 VGND VGND VPWR VPWR sky130_fd_sc_hd__decap_3
XTAP_TAPCELL_ROW_111_1840 VGND VPWR sky130_fd_sc_hd__tapvpwrvgnd_1
Xload_slew300 fanout299/X VGND VGND VPWR VPWR _3853_/C1 sky130_fd_sc_hd__buf_2
XFILLER_100_707 VGND VGND VPWR VPWR sky130_fd_sc_hd__decap_3
XFILLER_97_256 VGND VGND VPWR VPWR sky130_fd_sc_hd__decap_3
XTAP_TAPCELL_ROW_111_1851 VGND VPWR sky130_fd_sc_hd__tapvpwrvgnd_1
X_6070_ _8101_/Q _4802_/A _6074_/S VGND VGND VPWR VPWR _6071_/A sky130_fd_sc_hd__mux2_2
XFILLER_112_589 VGND VGND VPWR VPWR sky130_fd_sc_hd__decap_3
Xload_slew377 _3755_/S1 VGND VGND VPWR VPWR _3825_/A sky130_fd_sc_hd__clkbuf_4
Xload_slew366 _4273_/A VGND VGND VPWR VPWR _4261_/A sky130_fd_sc_hd__clkbuf_4
X_5021_ _5021_/A VGND VGND VPWR VPWR _7575_/D sky130_fd_sc_hd__buf_1
XFILLER_66_654 VGND VGND VPWR VPWR sky130_fd_sc_hd__decap_3
XTAP_TAPCELL_ROW_127_2069 VGND VPWR sky130_fd_sc_hd__tapvpwrvgnd_1
Xload_slew399 _4091_/S0 VGND VGND VPWR VPWR _4090_/S0 sky130_fd_sc_hd__buf_4
XFILLER_66_687 VGND VGND VPWR VPWR sky130_fd_sc_hd__decap_3
XFILLER_66_698 VGND VGND VPWR VPWR sky130_fd_sc_hd__fill_2
XPHY_EDGE_ROW_45_Left_181 VGND VGND VPWR VPWR sky130_fd_sc_hd__decap_3
XFILLER_0_60 VGND VGND VPWR VPWR sky130_fd_sc_hd__decap_3
X_8711_ _8792_/CLK _8711_/D fanout656/A VGND VGND VPWR VPWR _8711_/Q sky130_fd_sc_hd__dfrtp_2
X_6972_ _6972_/A VGND VGND VPWR VPWR _8524_/D sky130_fd_sc_hd__buf_6
X_5923_ _5931_/A1 _5921_/X _4815_/X _5922_/X hold876/X VGND VGND VPWR VPWR _8013_/D
+ sky130_fd_sc_hd__a32o_2
X_8642_ _8648_/CLK _8642_/D fanout492/X VGND VGND VPWR VPWR _8642_/Q sky130_fd_sc_hd__dfrtp_2
X_5854_ _8051_/Q _6658_/B VGND VGND VPWR VPWR _7282_/A sky130_fd_sc_hd__nand2_2
XFILLER_21_223 VGND VGND VPWR VPWR sky130_fd_sc_hd__fill_1
XFILLER_21_234 VGND VGND VPWR VPWR sky130_fd_sc_hd__decap_3
XFILLER_22_746 VGND VGND VPWR VPWR sky130_fd_sc_hd__fill_2
XTAP_TAPCELL_ROW_32_741 VGND VPWR sky130_fd_sc_hd__tapvpwrvgnd_1
X_8573_ _8658_/CLK _8573_/D load_slew529/X VGND VGND VPWR VPWR _8573_/Q sky130_fd_sc_hd__dfrtp_2
X_4805_ _4805_/A VGND VGND VPWR VPWR _7524_/D sky130_fd_sc_hd__buf_1
X_7524_ _8669_/CLK _7524_/D fanout635/X VGND VGND VPWR VPWR _7524_/Q sky130_fd_sc_hd__dfrtp_2
X_5785_ _5785_/A VGND VGND VPWR VPWR _7931_/D sky130_fd_sc_hd__buf_1
XFILLER_119_15 VGND VGND VPWR VPWR sky130_fd_sc_hd__decap_3
X_4736_ _4735_/X _4736_/A1 _4736_/S VGND VGND VPWR VPWR _4737_/A sky130_fd_sc_hd__mux2_2
XFILLER_119_48 VGND VGND VPWR VPWR sky130_fd_sc_hd__decap_3
XFILLER_134_103 VGND VGND VPWR VPWR sky130_fd_sc_hd__decap_3
XFILLER_135_637 VGND VGND VPWR VPWR sky130_fd_sc_hd__decap_3
XPHY_EDGE_ROW_54_Left_190 VGND VGND VPWR VPWR sky130_fd_sc_hd__decap_3
X_7455_ _7455_/A VGND VGND VPWR VPWR _7474_/S sky130_fd_sc_hd__buf_2
X_4667_ _8133_/Q _8214_/Q _8295_/Q _8376_/Q _4670_/S0 _4651_/A VGND VGND VPWR VPWR
+ _4667_/X sky130_fd_sc_hd__mux4_2
XFILLER_134_136 VGND VGND VPWR VPWR sky130_fd_sc_hd__decap_3
XFILLER_134_147 VGND VGND VPWR VPWR sky130_fd_sc_hd__decap_3
XFILLER_135_648 VGND VGND VPWR VPWR sky130_fd_sc_hd__decap_3
Xhold920 _8590_/Q VGND VGND VPWR VPWR hold920/X sky130_fd_sc_hd__dlygate4sd3_1
Xhold931 _8587_/Q VGND VGND VPWR VPWR hold931/X sky130_fd_sc_hd__dlygate4sd3_1
X_7386_ _8751_/Q _4810_/A _7386_/S VGND VGND VPWR VPWR _7387_/A sky130_fd_sc_hd__mux2_2
X_6406_ _6406_/A VGND VGND VPWR VPWR _8258_/D sky130_fd_sc_hd__buf_2
XFILLER_1_617 VGND VGND VPWR VPWR sky130_fd_sc_hd__decap_3
XFILLER_89_724 VGND VGND VPWR VPWR sky130_fd_sc_hd__decap_3
XTAP_TAPCELL_ROW_73_1312 VGND VPWR sky130_fd_sc_hd__tapvpwrvgnd_1
Xhold942 _8588_/Q VGND VGND VPWR VPWR hold942/X sky130_fd_sc_hd__dlygate4sd3_1
Xhold953 _8567_/Q VGND VGND VPWR VPWR hold953/X sky130_fd_sc_hd__dlygate4sd3_1
Xhold964 _8551_/Q VGND VGND VPWR VPWR hold964/X sky130_fd_sc_hd__dlygate4sd3_1
X_6337_ _6484_/S VGND VGND VPWR VPWR _6356_/S sky130_fd_sc_hd__buf_4
X_4598_ _4633_/A _4596_/X _4597_/X VGND VGND VPWR VPWR _4598_/X sky130_fd_sc_hd__o21a_2
XFILLER_0_116 VGND VGND VPWR VPWR sky130_fd_sc_hd__decap_3
XFILLER_103_523 VGND VGND VPWR VPWR sky130_fd_sc_hd__decap_3
XFILLER_135_47 VGND VGND VPWR VPWR sky130_fd_sc_hd__decap_3
Xhold975 _8245_/Q VGND VGND VPWR VPWR hold975/X sky130_fd_sc_hd__dlygate4sd3_1
Xhold986 _7532_/Q VGND VGND VPWR VPWR hold986/X sky130_fd_sc_hd__dlygate4sd3_1
Xhold997 _7833_/Q VGND VGND VPWR VPWR hold997/X sky130_fd_sc_hd__dlygate4sd3_1
XFILLER_103_556 VGND VGND VPWR VPWR sky130_fd_sc_hd__fill_1
XFILLER_135_69 VGND VGND VPWR VPWR sky130_fd_sc_hd__decap_3
XFILLER_88_245 VGND VGND VPWR VPWR sky130_fd_sc_hd__decap_3
XFILLER_88_256 VGND VGND VPWR VPWR sky130_fd_sc_hd__decap_3
X_6268_ _4853_/X _8194_/Q _6268_/S VGND VGND VPWR VPWR _6269_/A sky130_fd_sc_hd__mux2_4
XFILLER_28_12 VGND VGND VPWR VPWR sky130_fd_sc_hd__decap_3
XFILLER_48_109 VGND VGND VPWR VPWR sky130_fd_sc_hd__fill_2
XFILLER_57_610 VGND VGND VPWR VPWR sky130_fd_sc_hd__decap_3
X_8007_ _8749_/CLK _8007_/D load_slew621/X VGND VGND VPWR VPWR _8007_/Q sky130_fd_sc_hd__dfrtp_2
X_6199_ _4715_/X _8161_/Q _6205_/S VGND VGND VPWR VPWR _6200_/A sky130_fd_sc_hd__mux2_4
X_5219_ _5219_/A VGND VGND VPWR VPWR _7664_/D sky130_fd_sc_hd__buf_1
XFILLER_130_397 VGND VGND VPWR VPWR sky130_fd_sc_hd__decap_3
XFILLER_29_334 VGND VGND VPWR VPWR sky130_fd_sc_hd__fill_2
XFILLER_28_78 VGND VGND VPWR VPWR sky130_fd_sc_hd__decap_3
XFILLER_57_665 VGND VGND VPWR VPWR sky130_fd_sc_hd__decap_3
XFILLER_57_676 VGND VGND VPWR VPWR sky130_fd_sc_hd__fill_2
XFILLER_56_197 VGND VGND VPWR VPWR sky130_fd_sc_hd__fill_1
XFILLER_71_101 VGND VGND VPWR VPWR sky130_fd_sc_hd__decap_3
XFILLER_44_359 VGND VGND VPWR VPWR sky130_fd_sc_hd__fill_2
XFILLER_71_145 VGND VGND VPWR VPWR sky130_fd_sc_hd__fill_2
XFILLER_12_212 VGND VGND VPWR VPWR sky130_fd_sc_hd__decap_3
XFILLER_13_724 VGND VGND VPWR VPWR sky130_fd_sc_hd__decap_3
XFILLER_13_735 VGND VGND VPWR VPWR sky130_fd_sc_hd__decap_3
XFILLER_25_573 VGND VGND VPWR VPWR sky130_fd_sc_hd__decap_3
XTAP_TAPCELL_ROW_84_1463 VGND VPWR sky130_fd_sc_hd__tapvpwrvgnd_1
XTAP_TAPCELL_ROW_84_1474 VGND VPWR sky130_fd_sc_hd__tapvpwrvgnd_1
XFILLER_13_768 VGND VGND VPWR VPWR sky130_fd_sc_hd__decap_3
XFILLER_44_88 VGND VGND VPWR VPWR sky130_fd_sc_hd__decap_3
XFILLER_9_706 VGND VGND VPWR VPWR sky130_fd_sc_hd__decap_3
XFILLER_100_50 VGND VGND VPWR VPWR sky130_fd_sc_hd__fill_2
XFILLER_100_94 VGND VGND VPWR VPWR sky130_fd_sc_hd__decap_3
XFILLER_60_43 VGND VGND VPWR VPWR sky130_fd_sc_hd__fill_2
XFILLER_126_604 VGND VGND VPWR VPWR sky130_fd_sc_hd__decap_3
XTAP_TAPCELL_ROW_10_435 VGND VPWR sky130_fd_sc_hd__tapvpwrvgnd_1
XFILLER_126_648 VGND VGND VPWR VPWR sky130_fd_sc_hd__decap_3
XFILLER_5_27 VGND VGND VPWR VPWR sky130_fd_sc_hd__decap_3
XFILLER_69_41 VGND VGND VPWR VPWR sky130_fd_sc_hd__decap_3
XFILLER_106_394 VGND VGND VPWR VPWR sky130_fd_sc_hd__decap_3
XFILLER_134_681 VGND VGND VPWR VPWR sky130_fd_sc_hd__decap_3
XFILLER_79_234 VGND VGND VPWR VPWR sky130_fd_sc_hd__decap_3
XFILLER_121_386 VGND VGND VPWR VPWR sky130_fd_sc_hd__decap_3
XFILLER_94_215 VGND VGND VPWR VPWR sky130_fd_sc_hd__decap_3
XFILLER_95_738 VGND VGND VPWR VPWR sky130_fd_sc_hd__decap_3
XFILLER_0_694 VGND VGND VPWR VPWR sky130_fd_sc_hd__decap_3
XFILLER_47_164 VGND VGND VPWR VPWR sky130_fd_sc_hd__decap_3
XFILLER_63_613 VGND VGND VPWR VPWR sky130_fd_sc_hd__decap_3
XFILLER_63_635 VGND VGND VPWR VPWR sky130_fd_sc_hd__decap_3
XFILLER_75_484 VGND VGND VPWR VPWR sky130_fd_sc_hd__decap_3
XFILLER_90_421 VGND VGND VPWR VPWR sky130_fd_sc_hd__decap_3
XFILLER_90_432 VGND VGND VPWR VPWR sky130_fd_sc_hd__decap_3
XTAP_TAPCELL_ROW_18_546 VGND VPWR sky130_fd_sc_hd__tapvpwrvgnd_1
XFILLER_50_318 VGND VGND VPWR VPWR sky130_fd_sc_hd__decap_3
XFILLER_90_498 VGND VGND VPWR VPWR sky130_fd_sc_hd__decap_3
XFILLER_16_595 VGND VGND VPWR VPWR sky130_fd_sc_hd__decap_3
XFILLER_129_420 VGND VGND VPWR VPWR sky130_fd_sc_hd__decap_3
XFILLER_12_790 VGND VGND VPWR VPWR sky130_fd_sc_hd__decap_3
XFILLER_79_3 VGND VGND VPWR VPWR sky130_fd_sc_hd__fill_1
X_5570_ _7830_/Q _4727_/A _5570_/S VGND VGND VPWR VPWR _5571_/A sky130_fd_sc_hd__mux2_2
XFILLER_117_604 VGND VGND VPWR VPWR sky130_fd_sc_hd__decap_3
XFILLER_117_626 VGND VGND VPWR VPWR sky130_fd_sc_hd__fill_2
XFILLER_129_464 VGND VGND VPWR VPWR sky130_fd_sc_hd__decap_3
XFILLER_7_260 VGND VGND VPWR VPWR sky130_fd_sc_hd__fill_2
XFILLER_8_772 VGND VGND VPWR VPWR sky130_fd_sc_hd__decap_3
X_4521_ _8444_/Q _8525_/Q _8606_/Q _8687_/Q _4523_/S0 _4531_/S1 VGND VGND VPWR VPWR
+ _4521_/X sky130_fd_sc_hd__mux4_2
XFILLER_116_114 VGND VGND VPWR VPWR sky130_fd_sc_hd__fill_1
XFILLER_129_497 VGND VGND VPWR VPWR sky130_fd_sc_hd__decap_3
X_7240_ _7228_/X _4807_/X _7242_/A3 _7242_/B1 hold775/X VGND VGND VPWR VPWR _8669_/D
+ sky130_fd_sc_hd__a32o_2
X_4452_ _4605_/A1 _4450_/X _4451_/X _4112_/S VGND VGND VPWR VPWR _4452_/X sky130_fd_sc_hd__a31o_2
XFILLER_116_158 VGND VGND VPWR VPWR sky130_fd_sc_hd__decap_3
XFILLER_132_607 VGND VGND VPWR VPWR sky130_fd_sc_hd__decap_3
XFILLER_131_128 VGND VGND VPWR VPWR sky130_fd_sc_hd__decap_3
X_7171_ _7171_/A VGND VGND VPWR VPWR _8618_/D sky130_fd_sc_hd__buf_2
X_4383_ _4444_/A1 _4379_/X _4382_/X _4458_/B2 VGND VGND VPWR VPWR _4383_/X sky130_fd_sc_hd__a211o_2
XFILLER_112_353 VGND VGND VPWR VPWR sky130_fd_sc_hd__fill_2
XTAP_TAPCELL_ROW_55_1064 VGND VPWR sky130_fd_sc_hd__tapvpwrvgnd_1
X_6122_ _6122_/A VGND VGND VPWR VPWR _8125_/D sky130_fd_sc_hd__buf_1
XFILLER_112_386 VGND VGND VPWR VPWR sky130_fd_sc_hd__decap_3
XFILLER_98_598 VGND VGND VPWR VPWR sky130_fd_sc_hd__fill_2
X_6053_ _8093_/Q _4768_/A _6053_/S VGND VGND VPWR VPWR _6054_/A sky130_fd_sc_hd__mux2_2
X_5004_ _5003_/X _7571_/Q _5028_/S VGND VGND VPWR VPWR _5005_/A sky130_fd_sc_hd__mux2_2
XFILLER_26_304 VGND VGND VPWR VPWR sky130_fd_sc_hd__decap_3
XFILLER_38_131 VGND VGND VPWR VPWR sky130_fd_sc_hd__decap_3
XFILLER_66_473 VGND VGND VPWR VPWR sky130_fd_sc_hd__decap_3
XFILLER_94_782 VGND VGND VPWR VPWR sky130_fd_sc_hd__fill_1
XFILLER_38_197 VGND VGND VPWR VPWR sky130_fd_sc_hd__decap_3
XFILLER_54_624 VGND VGND VPWR VPWR sky130_fd_sc_hd__decap_3
XFILLER_93_281 VGND VGND VPWR VPWR sky130_fd_sc_hd__fill_1
XTAP_TAPCELL_ROW_37_811 VGND VPWR sky130_fd_sc_hd__tapvpwrvgnd_1
XFILLER_54_657 VGND VGND VPWR VPWR sky130_fd_sc_hd__decap_3
XFILLER_81_443 VGND VGND VPWR VPWR sky130_fd_sc_hd__decap_3
X_6955_ _6955_/A VGND VGND VPWR VPWR _8516_/D sky130_fd_sc_hd__buf_6
XFILLER_22_510 VGND VGND VPWR VPWR sky130_fd_sc_hd__fill_1
XFILLER_41_318 VGND VGND VPWR VPWR sky130_fd_sc_hd__fill_2
XFILLER_53_167 VGND VGND VPWR VPWR sky130_fd_sc_hd__fill_1
XFILLER_53_178 VGND VGND VPWR VPWR sky130_fd_sc_hd__decap_3
X_5906_ _5906_/A1 _5906_/A2 _4769_/X _5906_/B1 hold912/X VGND VGND VPWR VPWR _8002_/D
+ sky130_fd_sc_hd__a32o_2
XFILLER_62_690 VGND VGND VPWR VPWR sky130_fd_sc_hd__decap_3
X_8625_ _8786_/CLK _8625_/D load_slew676/X VGND VGND VPWR VPWR _8625_/Q sky130_fd_sc_hd__dfrtp_2
X_6886_ _6886_/A VGND VGND VPWR VPWR _8483_/D sky130_fd_sc_hd__buf_6
XFILLER_10_716 VGND VGND VPWR VPWR sky130_fd_sc_hd__decap_3
XFILLER_14_47 VGND VGND VPWR VPWR sky130_fd_sc_hd__decap_3
X_5837_ _7956_/Q _4917_/A _5847_/S VGND VGND VPWR VPWR _5838_/A sky130_fd_sc_hd__mux2_2
XFILLER_10_749 VGND VGND VPWR VPWR sky130_fd_sc_hd__decap_3
X_8556_ _8638_/CLK _8556_/D fanout583/X VGND VGND VPWR VPWR _8556_/Q sky130_fd_sc_hd__dfrtp_2
X_5768_ _7923_/Q _4777_/A _5784_/S VGND VGND VPWR VPWR _5769_/A sky130_fd_sc_hd__mux2_2
X_8487_ _8646_/CLK _8487_/D wire531/X VGND VGND VPWR VPWR _8487_/Q sky130_fd_sc_hd__dfrtp_2
X_7507_ _8733_/CLK _7507_/D wire476/A VGND VGND VPWR VPWR _7507_/Q sky130_fd_sc_hd__dfrtp_2
X_4719_ _4719_/A VGND VGND VPWR VPWR _4719_/X sky130_fd_sc_hd__clkbuf_1
XFILLER_30_35 VGND VGND VPWR VPWR sky130_fd_sc_hd__decap_3
X_7438_ _7438_/A VGND VGND VPWR VPWR _8775_/D sky130_fd_sc_hd__buf_1
X_5699_ _5699_/A VGND VGND VPWR VPWR _7890_/D sky130_fd_sc_hd__buf_1
XFILLER_100_6 VGND VGND VPWR VPWR sky130_fd_sc_hd__fill_2
XFILLER_107_147 VGND VGND VPWR VPWR sky130_fd_sc_hd__decap_3
XFILLER_107_169 VGND VGND VPWR VPWR sky130_fd_sc_hd__decap_3
XFILLER_123_629 VGND VGND VPWR VPWR sky130_fd_sc_hd__fill_1
XFILLER_116_681 VGND VGND VPWR VPWR sky130_fd_sc_hd__decap_3
XFILLER_122_106 VGND VGND VPWR VPWR sky130_fd_sc_hd__decap_3
XFILLER_135_489 VGND VGND VPWR VPWR sky130_fd_sc_hd__decap_3
Xclkbuf_5_19__f_CLK clkbuf_4_9_0_CLK/X VGND VGND VPWR VPWR clkload6/A sky130_fd_sc_hd__clkbuf_16
Xhold761 _8686_/Q VGND VGND VPWR VPWR hold761/X sky130_fd_sc_hd__dlygate4sd3_1
Xhold772 _8623_/Q VGND VGND VPWR VPWR hold772/X sky130_fd_sc_hd__dlygate4sd3_1
X_7369_ _7369_/A VGND VGND VPWR VPWR _8742_/D sky130_fd_sc_hd__buf_1
Xhold783 _8663_/Q VGND VGND VPWR VPWR hold783/X sky130_fd_sc_hd__dlygate4sd3_1
Xhold794 _7988_/Q VGND VGND VPWR VPWR hold794/X sky130_fd_sc_hd__dlygate4sd3_1
XFILLER_130_150 VGND VGND VPWR VPWR sky130_fd_sc_hd__decap_3
XFILLER_131_662 VGND VGND VPWR VPWR sky130_fd_sc_hd__decap_3
XFILLER_131_673 VGND VGND VPWR VPWR sky130_fd_sc_hd__decap_3
XFILLER_76_215 VGND VGND VPWR VPWR sky130_fd_sc_hd__decap_3
XFILLER_77_716 VGND VGND VPWR VPWR sky130_fd_sc_hd__decap_3
XFILLER_77_738 VGND VGND VPWR VPWR sky130_fd_sc_hd__decap_3
XFILLER_89_576 VGND VGND VPWR VPWR sky130_fd_sc_hd__decap_3
XFILLER_130_183 VGND VGND VPWR VPWR sky130_fd_sc_hd__decap_3
XFILLER_76_259 VGND VGND VPWR VPWR sky130_fd_sc_hd__decap_3
XTAP_TAPCELL_ROW_86_1503 VGND VPWR sky130_fd_sc_hd__tapvpwrvgnd_1
XFILLER_17_337 VGND VGND VPWR VPWR sky130_fd_sc_hd__fill_2
XFILLER_29_175 VGND VGND VPWR VPWR sky130_fd_sc_hd__decap_3
XFILLER_45_635 VGND VGND VPWR VPWR sky130_fd_sc_hd__fill_1
XFILLER_72_421 VGND VGND VPWR VPWR sky130_fd_sc_hd__decap_3
XFILLER_17_359 VGND VGND VPWR VPWR sky130_fd_sc_hd__decap_3
XFILLER_55_54 VGND VGND VPWR VPWR sky130_fd_sc_hd__fill_2
XFILLER_84_292 VGND VGND VPWR VPWR sky130_fd_sc_hd__decap_3
XFILLER_44_189 VGND VGND VPWR VPWR sky130_fd_sc_hd__decap_3
XPHY_EDGE_ROW_105_Right_105 VGND VGND VPWR VPWR sky130_fd_sc_hd__decap_3
XTAP_TAPCELL_ROW_15_505 VGND VPWR sky130_fd_sc_hd__tapvpwrvgnd_1
XFILLER_111_60 VGND VGND VPWR VPWR sky130_fd_sc_hd__decap_3
XFILLER_13_532 VGND VGND VPWR VPWR sky130_fd_sc_hd__decap_3
XFILLER_53_690 VGND VGND VPWR VPWR sky130_fd_sc_hd__fill_1
XFILLER_111_93 VGND VGND VPWR VPWR sky130_fd_sc_hd__decap_3
XFILLER_40_351 VGND VGND VPWR VPWR sky130_fd_sc_hd__decap_3
XFILLER_40_362 VGND VGND VPWR VPWR sky130_fd_sc_hd__fill_2
XFILLER_71_53 VGND VGND VPWR VPWR sky130_fd_sc_hd__decap_3
XFILLER_9_503 VGND VGND VPWR VPWR sky130_fd_sc_hd__fill_1
XFILLER_40_395 VGND VGND VPWR VPWR sky130_fd_sc_hd__decap_3
XFILLER_9_536 VGND VGND VPWR VPWR sky130_fd_sc_hd__fill_1
XFILLER_126_445 VGND VGND VPWR VPWR sky130_fd_sc_hd__decap_3
XTAP_TAPCELL_ROW_97_1654 VGND VPWR sky130_fd_sc_hd__tapvpwrvgnd_1
XFILLER_5_753 VGND VGND VPWR VPWR sky130_fd_sc_hd__decap_3
XFILLER_126_489 VGND VGND VPWR VPWR sky130_fd_sc_hd__decap_3
XFILLER_5_797 VGND VGND VPWR VPWR sky130_fd_sc_hd__decap_3
XFILLER_113_139 VGND VGND VPWR VPWR sky130_fd_sc_hd__fill_2
XFILLER_122_651 VGND VGND VPWR VPWR sky130_fd_sc_hd__decap_3
XFILLER_96_61 VGND VGND VPWR VPWR sky130_fd_sc_hd__decap_3
XFILLER_121_172 VGND VGND VPWR VPWR sky130_fd_sc_hd__decap_3
XFILLER_121_183 VGND VGND VPWR VPWR sky130_fd_sc_hd__decap_3
XFILLER_83_719 VGND VGND VPWR VPWR sky130_fd_sc_hd__fill_2
XFILLER_95_579 VGND VGND VPWR VPWR sky130_fd_sc_hd__decap_3
XFILLER_82_218 VGND VGND VPWR VPWR sky130_fd_sc_hd__decap_3
XTAP_TAPCELL_ROW_124_2028 VGND VPWR sky130_fd_sc_hd__tapvpwrvgnd_1
XFILLER_35_145 VGND VGND VPWR VPWR sky130_fd_sc_hd__fill_1
XFILLER_91_752 VGND VGND VPWR VPWR sky130_fd_sc_hd__decap_3
XFILLER_90_262 VGND VGND VPWR VPWR sky130_fd_sc_hd__decap_3
XFILLER_91_796 VGND VGND VPWR VPWR sky130_fd_sc_hd__decap_3
XTAP_TAPCELL_ROW_106_1772 VGND VPWR sky130_fd_sc_hd__tapvpwrvgnd_1
X_6740_ _8415_/Q _4760_/A _6744_/S VGND VGND VPWR VPWR _6741_/A sky130_fd_sc_hd__mux2_2
XFILLER_44_690 VGND VGND VPWR VPWR sky130_fd_sc_hd__decap_3
XFILLER_50_137 VGND VGND VPWR VPWR sky130_fd_sc_hd__decap_3
XTAP_TAPCELL_ROW_106_1783 VGND VPWR sky130_fd_sc_hd__tapvpwrvgnd_1
X_3952_ _3925_/A _3948_/X _3950_/X _3951_/X VGND VGND VPWR VPWR _3952_/X sky130_fd_sc_hd__a22o_2
XFILLER_31_351 VGND VGND VPWR VPWR sky130_fd_sc_hd__decap_3
X_3883_ _8306_/Q _4295_/A2 _3882_/X VGND VGND VPWR VPWR _3883_/X sky130_fd_sc_hd__o21a_2
X_6671_ _8382_/Q _4964_/A _6681_/S VGND VGND VPWR VPWR _6672_/A sky130_fd_sc_hd__mux2_2
XTAP_TAPCELL_ROW_42_880 VGND VPWR sky130_fd_sc_hd__tapvpwrvgnd_1
X_8410_ _8410_/CLK _8410_/D load_slew524/X VGND VGND VPWR VPWR _8410_/Q sky130_fd_sc_hd__dfrtp_2
X_5622_ _5622_/A VGND VGND VPWR VPWR _7854_/D sky130_fd_sc_hd__buf_1
XFILLER_129_261 VGND VGND VPWR VPWR sky130_fd_sc_hd__decap_3
X_8341_ _8740_/CLK _8341_/D load_slew538/X VGND VGND VPWR VPWR _8341_/Q sky130_fd_sc_hd__dfrtp_2
X_5553_ _5553_/A VGND VGND VPWR VPWR _7821_/D sky130_fd_sc_hd__buf_1
XFILLER_117_445 VGND VGND VPWR VPWR sky130_fd_sc_hd__decap_3
XTAP_TAPCELL_ROW_135_2179 VGND VPWR sky130_fd_sc_hd__tapvpwrvgnd_1
X_4504_ _8027_/Q _3784_/X _4631_/A2 _7946_/Q _4462_/A VGND VGND VPWR VPWR _4504_/X
+ sky130_fd_sc_hd__o221a_2
XFILLER_105_607 VGND VGND VPWR VPWR sky130_fd_sc_hd__decap_3
XFILLER_117_467 VGND VGND VPWR VPWR sky130_fd_sc_hd__decap_3
X_8272_ _8754_/CLK _8272_/D load_slew699/X VGND VGND VPWR VPWR _8272_/Q sky130_fd_sc_hd__dfrtp_2
X_5484_ _5505_/S VGND VGND VPWR VPWR _5503_/S sky130_fd_sc_hd__buf_2
XFILLER_132_415 VGND VGND VPWR VPWR sky130_fd_sc_hd__decap_3
X_7223_ wire234/X _4749_/X wire175/X wire205/X hold835/X VGND VGND VPWR VPWR _8655_/D
+ sky130_fd_sc_hd__a32o_2
X_4435_ _8112_/Q _8193_/Q _4435_/S VGND VGND VPWR VPWR _4435_/X sky130_fd_sc_hd__mux2_2
XFILLER_116_27 VGND VGND VPWR VPWR sky130_fd_sc_hd__fill_1
XFILLER_116_38 VGND VGND VPWR VPWR sky130_fd_sc_hd__decap_3
XFILLER_132_448 VGND VGND VPWR VPWR sky130_fd_sc_hd__decap_3
Xfanout504 fanout506/X VGND VGND VPWR VPWR fanout504/X sky130_fd_sc_hd__clkdlybuf4s25_1
X_7154_ _4899_/X _8610_/Q _7172_/S VGND VGND VPWR VPWR _7155_/A sky130_fd_sc_hd__mux2_2
X_4366_ _8106_/Q _8187_/Q _8268_/Q _8349_/Q _4367_/S _4368_/A VGND VGND VPWR VPWR
+ _4366_/X sky130_fd_sc_hd__mux4_2
Xfanout537 fanout539/X VGND VGND VPWR VPWR fanout537/X sky130_fd_sc_hd__clkdlybuf4s25_1
Xfanout548 fanout613/X VGND VGND VPWR VPWR fanout548/X sky130_fd_sc_hd__clkdlybuf4s25_1
X_6105_ _6105_/A VGND VGND VPWR VPWR _8117_/D sky130_fd_sc_hd__buf_1
XFILLER_100_312 VGND VGND VPWR VPWR sky130_fd_sc_hd__decap_3
XFILLER_100_334 VGND VGND VPWR VPWR sky130_fd_sc_hd__decap_3
XFILLER_86_546 VGND VGND VPWR VPWR sky130_fd_sc_hd__decap_3
Xfanout559 fanout561/X VGND VGND VPWR VPWR fanout559/X sky130_fd_sc_hd__clkdlybuf4s25_1
X_7085_ _7085_/A VGND VGND VPWR VPWR _8577_/D sky130_fd_sc_hd__buf_2
X_4297_ _8100_/Q _8181_/Q _4305_/S VGND VGND VPWR VPWR _4297_/X sky130_fd_sc_hd__mux2_2
XFILLER_132_15 VGND VGND VPWR VPWR sky130_fd_sc_hd__decap_3
X_6036_ _6036_/A VGND VGND VPWR VPWR _8084_/D sky130_fd_sc_hd__buf_1
XFILLER_132_59 VGND VGND VPWR VPWR sky130_fd_sc_hd__decap_3
XFILLER_39_473 VGND VGND VPWR VPWR sky130_fd_sc_hd__fill_2
XTAP_TAPCELL_ROW_68_1244 VGND VPWR sky130_fd_sc_hd__tapvpwrvgnd_1
XFILLER_14_318 VGND VGND VPWR VPWR sky130_fd_sc_hd__decap_3
XFILLER_25_24 VGND VGND VPWR VPWR sky130_fd_sc_hd__decap_3
XFILLER_26_178 VGND VGND VPWR VPWR sky130_fd_sc_hd__decap_3
XFILLER_42_616 VGND VGND VPWR VPWR sky130_fd_sc_hd__fill_1
XFILLER_54_465 VGND VGND VPWR VPWR sky130_fd_sc_hd__decap_3
X_7987_ _8645_/CLK _7987_/D load_slew499/X VGND VGND VPWR VPWR _7987_/Q sky130_fd_sc_hd__dfrtp_2
XFILLER_25_57 VGND VGND VPWR VPWR sky130_fd_sc_hd__decap_3
XFILLER_41_148 VGND VGND VPWR VPWR sky130_fd_sc_hd__decap_3
XTAP_TAPCELL_ROW_81_1422 VGND VPWR sky130_fd_sc_hd__tapvpwrvgnd_1
XTAP_TAPCELL_ROW_81_1433 VGND VPWR sky130_fd_sc_hd__tapvpwrvgnd_1
X_6938_ _6938_/A VGND VGND VPWR VPWR _8508_/D sky130_fd_sc_hd__buf_6
X_6869_ _6869_/A VGND VGND VPWR VPWR _8475_/D sky130_fd_sc_hd__buf_6
X_8608_ _8608_/CLK _8608_/D fanout548/X VGND VGND VPWR VPWR _8608_/Q sky130_fd_sc_hd__dfrtp_2
XFILLER_6_506 VGND VGND VPWR VPWR sky130_fd_sc_hd__decap_3
X_8539_ _8624_/CLK _8539_/D load_slew647/X VGND VGND VPWR VPWR _8539_/Q sky130_fd_sc_hd__dfrtp_2
XFILLER_41_78 VGND VGND VPWR VPWR sky130_fd_sc_hd__decap_3
XTAP_TAPCELL_ROW_20_574 VGND VPWR sky130_fd_sc_hd__tapvpwrvgnd_1
XFILLER_108_467 VGND VGND VPWR VPWR sky130_fd_sc_hd__decap_3
XFILLER_135_253 VGND VGND VPWR VPWR sky130_fd_sc_hd__decap_3
XTAP_TAPCELL_ROW_79_1395 VGND VPWR sky130_fd_sc_hd__tapvpwrvgnd_1
XFILLER_135_297 VGND VGND VPWR VPWR sky130_fd_sc_hd__decap_3
XFILLER_2_701 VGND VGND VPWR VPWR sky130_fd_sc_hd__decap_3
XFILLER_2_734 VGND VGND VPWR VPWR sky130_fd_sc_hd__decap_3
XFILLER_89_340 VGND VGND VPWR VPWR sky130_fd_sc_hd__decap_3
XFILLER_9_3 VGND VGND VPWR VPWR sky130_fd_sc_hd__decap_3
XFILLER_2_778 VGND VGND VPWR VPWR sky130_fd_sc_hd__decap_3
XFILLER_89_362 VGND VGND VPWR VPWR sky130_fd_sc_hd__decap_3
XTAP_TAPCELL_ROW_92_1584 VGND VPWR sky130_fd_sc_hd__tapvpwrvgnd_1
XFILLER_103_172 VGND VGND VPWR VPWR sky130_fd_sc_hd__decap_3
XFILLER_131_470 VGND VGND VPWR VPWR sky130_fd_sc_hd__decap_3
XFILLER_58_760 VGND VGND VPWR VPWR sky130_fd_sc_hd__decap_3
XFILLER_66_97 VGND VGND VPWR VPWR sky130_fd_sc_hd__fill_2
XFILLER_92_527 VGND VGND VPWR VPWR sky130_fd_sc_hd__decap_3
XFILLER_45_432 VGND VGND VPWR VPWR sky130_fd_sc_hd__decap_3
XFILLER_72_262 VGND VGND VPWR VPWR sky130_fd_sc_hd__decap_3
XFILLER_73_785 VGND VGND VPWR VPWR sky130_fd_sc_hd__decap_3
XFILLER_17_189 VGND VGND VPWR VPWR sky130_fd_sc_hd__decap_3
XFILLER_32_137 VGND VGND VPWR VPWR sky130_fd_sc_hd__decap_3
XFILLER_33_638 VGND VGND VPWR VPWR sky130_fd_sc_hd__decap_3
XFILLER_72_284 VGND VGND VPWR VPWR sky130_fd_sc_hd__decap_3
XTAP_TAPCELL_ROW_28_685 VGND VPWR sky130_fd_sc_hd__tapvpwrvgnd_1
XFILLER_82_85 VGND VGND VPWR VPWR sky130_fd_sc_hd__decap_3
XFILLER_9_300 VGND VGND VPWR VPWR sky130_fd_sc_hd__fill_1
XFILLER_15_90 VGND VGND VPWR VPWR sky130_fd_sc_hd__decap_3
XFILLER_41_682 VGND VGND VPWR VPWR sky130_fd_sc_hd__decap_3
XFILLER_9_311 VGND VGND VPWR VPWR sky130_fd_sc_hd__decap_3
XFILLER_9_333 VGND VGND VPWR VPWR sky130_fd_sc_hd__decap_3
XFILLER_40_192 VGND VGND VPWR VPWR sky130_fd_sc_hd__decap_3
XFILLER_127_721 VGND VGND VPWR VPWR sky130_fd_sc_hd__decap_3
XFILLER_127_732 VGND VGND VPWR VPWR sky130_fd_sc_hd__decap_3
XFILLER_9_399 VGND VGND VPWR VPWR sky130_fd_sc_hd__fill_1
XFILLER_126_253 VGND VGND VPWR VPWR sky130_fd_sc_hd__fill_2
XFILLER_127_765 VGND VGND VPWR VPWR sky130_fd_sc_hd__decap_3
Xoutput107 _4105_/X VGND VGND VPWR VPWR rdata[28] sky130_fd_sc_hd__clkdlybuf4s25_1
Xoutput129 _4325_/X VGND VGND VPWR VPWR rdata[48] sky130_fd_sc_hd__clkdlybuf4s25_1
Xoutput118 _4214_/X VGND VGND VPWR VPWR rdata[38] sky130_fd_sc_hd__clkdlybuf4s25_1
X_4220_ _8417_/Q _8498_/Q _8579_/Q _8660_/Q _4140_/S _4227_/A VGND VGND VPWR VPWR
+ _4221_/B sky130_fd_sc_hd__mux4_2
XTAP_TAPCELL_ROW_52_1023 VGND VPWR sky130_fd_sc_hd__tapvpwrvgnd_1
XFILLER_68_524 VGND VGND VPWR VPWR sky130_fd_sc_hd__decap_3
XFILLER_68_546 VGND VGND VPWR VPWR sky130_fd_sc_hd__fill_1
X_4151_ _4151_/A _4151_/B VGND VGND VPWR VPWR _4151_/X sky130_fd_sc_hd__or2_2
XFILLER_110_654 VGND VGND VPWR VPWR sky130_fd_sc_hd__decap_3
XFILLER_68_568 VGND VGND VPWR VPWR sky130_fd_sc_hd__fill_1
XFILLER_83_505 VGND VGND VPWR VPWR sky130_fd_sc_hd__decap_3
X_4082_ _4082_/A _4082_/B VGND VGND VPWR VPWR _4082_/X sky130_fd_sc_hd__or2_2
XFILLER_110_698 VGND VGND VPWR VPWR sky130_fd_sc_hd__fill_2
XFILLER_48_270 VGND VGND VPWR VPWR sky130_fd_sc_hd__decap_3
XFILLER_49_782 VGND VGND VPWR VPWR sky130_fd_sc_hd__fill_2
XTAP_TAPCELL_ROW_108_1801 VGND VPWR sky130_fd_sc_hd__tapvpwrvgnd_1
X_7910_ _8649_/CLK _7910_/D fanout500/X VGND VGND VPWR VPWR _7910_/Q sky130_fd_sc_hd__dfrtp_2
XFILLER_36_421 VGND VGND VPWR VPWR sky130_fd_sc_hd__fill_1
XFILLER_64_763 VGND VGND VPWR VPWR sky130_fd_sc_hd__fill_1
XTAP_TAPCELL_ROW_47_950 VGND VPWR sky130_fd_sc_hd__tapvpwrvgnd_1
X_7841_ _7923_/CLK _7841_/D load_slew616/X VGND VGND VPWR VPWR _7841_/Q sky130_fd_sc_hd__dfrtp_2
XFILLER_102_29 VGND VGND VPWR VPWR sky130_fd_sc_hd__decap_3
XFILLER_63_284 VGND VGND VPWR VPWR sky130_fd_sc_hd__decap_3
X_7772_ _8678_/CLK _7772_/D fanout690/X VGND VGND VPWR VPWR _7772_/Q sky130_fd_sc_hd__dfrtp_2
X_4984_ _4984_/A _4984_/B VGND VGND VPWR VPWR _4985_/A sky130_fd_sc_hd__and2_2
X_3935_ _4605_/A1 _3933_/X _3934_/X _4112_/S VGND VGND VPWR VPWR _3935_/X sky130_fd_sc_hd__a31o_2
X_6723_ _8407_/Q _4726_/A _6723_/S VGND VGND VPWR VPWR _6724_/A sky130_fd_sc_hd__mux2_2
XTAP_TAPCELL_ROW_63_1174 VGND VPWR sky130_fd_sc_hd__tapvpwrvgnd_1
X_6654_ _4937_/X _8376_/Q _6654_/S VGND VGND VPWR VPWR _6655_/A sky130_fd_sc_hd__mux2_2
X_3866_ _3866_/A VGND VGND VPWR VPWR _3866_/X sky130_fd_sc_hd__buf_1
X_5605_ _5605_/A VGND VGND VPWR VPWR _7846_/D sky130_fd_sc_hd__buf_1
XFILLER_118_721 VGND VGND VPWR VPWR sky130_fd_sc_hd__decap_3
XFILLER_118_743 VGND VGND VPWR VPWR sky130_fd_sc_hd__decap_3
XFILLER_11_15 VGND VGND VPWR VPWR sky130_fd_sc_hd__decap_3
XTAP_TAPCELL_ROW_119_1952 VGND VPWR sky130_fd_sc_hd__tapvpwrvgnd_1
X_3797_ _3840_/S _3789_/X _3793_/X _3796_/X VGND VGND VPWR VPWR _3797_/X sky130_fd_sc_hd__a22o_2
X_6585_ _4799_/X _8343_/Q _6591_/S VGND VGND VPWR VPWR _6586_/A sky130_fd_sc_hd__mux2_2
XFILLER_117_220 VGND VGND VPWR VPWR sky130_fd_sc_hd__decap_3
XFILLER_11_48 VGND VGND VPWR VPWR sky130_fd_sc_hd__decap_3
XFILLER_127_15 VGND VGND VPWR VPWR sky130_fd_sc_hd__decap_3
XTAP_TAPCELL_ROW_119_1963 VGND VPWR sky130_fd_sc_hd__tapvpwrvgnd_1
X_8324_ _8729_/CLK _8324_/D load_slew489/X VGND VGND VPWR VPWR _8324_/Q sky130_fd_sc_hd__dfrtp_2
X_5536_ _5536_/A VGND VGND VPWR VPWR _7813_/D sky130_fd_sc_hd__buf_1
XFILLER_127_48 VGND VGND VPWR VPWR sky130_fd_sc_hd__decap_3
XFILLER_132_212 VGND VGND VPWR VPWR sky130_fd_sc_hd__decap_3
XFILLER_133_724 VGND VGND VPWR VPWR sky130_fd_sc_hd__decap_3
XFILLER_133_735 VGND VGND VPWR VPWR sky130_fd_sc_hd__decap_3
X_8255_ _8737_/CLK _8255_/D wire519/X VGND VGND VPWR VPWR _8255_/Q sky130_fd_sc_hd__dfrtp_2
X_5467_ _5467_/A VGND VGND VPWR VPWR _7781_/D sky130_fd_sc_hd__buf_1
XFILLER_132_245 VGND VGND VPWR VPWR sky130_fd_sc_hd__decap_3
XFILLER_133_768 VGND VGND VPWR VPWR sky130_fd_sc_hd__decap_3
X_7206_ _7213_/A1 _5031_/X _7216_/A3 _7216_/B1 hold897/X VGND VGND VPWR VPWR _8641_/D
+ sky130_fd_sc_hd__a32o_2
X_4418_ _4415_/X _4416_/X _4417_/X _4456_/C1 _4510_/A1 VGND VGND VPWR VPWR _4418_/X
+ sky130_fd_sc_hd__a221o_2
XFILLER_132_256 VGND VGND VPWR VPWR sky130_fd_sc_hd__decap_3
XFILLER_59_502 VGND VGND VPWR VPWR sky130_fd_sc_hd__fill_2
Xfanout301 _4092_/S VGND VGND VPWR VPWR wire302/A sky130_fd_sc_hd__clkdlybuf4s25_1
X_8186_ _8547_/CLK _8186_/D load_slew649/X VGND VGND VPWR VPWR _8186_/Q sky130_fd_sc_hd__dfrtp_2
X_5398_ _7749_/Q _4726_/A _5398_/S VGND VGND VPWR VPWR _5399_/A sky130_fd_sc_hd__mux2_2
XFILLER_132_289 VGND VGND VPWR VPWR sky130_fd_sc_hd__decap_3
X_7137_ _4866_/X hold954/X _7151_/S VGND VGND VPWR VPWR _7138_/A sky130_fd_sc_hd__mux2_1
X_4349_ _8753_/Q _7528_/Q _4675_/S VGND VGND VPWR VPWR _4349_/X sky130_fd_sc_hd__mux2_2
XFILLER_59_557 VGND VGND VPWR VPWR sky130_fd_sc_hd__decap_3
XFILLER_59_579 VGND VGND VPWR VPWR sky130_fd_sc_hd__fill_2
XFILLER_86_365 VGND VGND VPWR VPWR sky130_fd_sc_hd__decap_3
Xfanout367 fanout371/X VGND VGND VPWR VPWR _4330_/A sky130_fd_sc_hd__clkdlybuf4s25_1
Xfanout378 _3849_/S1 VGND VGND VPWR VPWR _3862_/A sky130_fd_sc_hd__clkdlybuf4s25_1
X_7068_ _7068_/A VGND VGND VPWR VPWR _8569_/D sky130_fd_sc_hd__buf_2
XFILLER_100_153 VGND VGND VPWR VPWR sky130_fd_sc_hd__fill_2
X_6019_ _6019_/A VGND VGND VPWR VPWR _8076_/D sky130_fd_sc_hd__buf_2
XFILLER_100_197 VGND VGND VPWR VPWR sky130_fd_sc_hd__decap_3
XFILLER_27_421 VGND VGND VPWR VPWR sky130_fd_sc_hd__decap_3
XFILLER_39_281 VGND VGND VPWR VPWR sky130_fd_sc_hd__decap_3
XFILLER_55_752 VGND VGND VPWR VPWR sky130_fd_sc_hd__decap_3
XFILLER_36_78 VGND VGND VPWR VPWR sky130_fd_sc_hd__decap_3
XFILLER_55_785 VGND VGND VPWR VPWR sky130_fd_sc_hd__fill_1
XFILLER_70_722 VGND VGND VPWR VPWR sky130_fd_sc_hd__decap_3
XFILLER_14_115 VGND VGND VPWR VPWR sky130_fd_sc_hd__decap_3
XFILLER_42_424 VGND VGND VPWR VPWR sky130_fd_sc_hd__fill_1
XFILLER_11_800 VGND VGND VPWR VPWR sky130_fd_sc_hd__decap_3
XFILLER_42_457 VGND VGND VPWR VPWR sky130_fd_sc_hd__fill_1
XTAP_TAPCELL_ROW_25_644 VGND VPWR sky130_fd_sc_hd__tapvpwrvgnd_1
XFILLER_10_321 VGND VGND VPWR VPWR sky130_fd_sc_hd__fill_1
XFILLER_10_343 VGND VGND VPWR VPWR sky130_fd_sc_hd__decap_3
XFILLER_128_507 VGND VGND VPWR VPWR sky130_fd_sc_hd__decap_3
XFILLER_22_192 VGND VGND VPWR VPWR sky130_fd_sc_hd__decap_3
XFILLER_52_88 VGND VGND VPWR VPWR sky130_fd_sc_hd__decap_3
XFILLER_10_365 VGND VGND VPWR VPWR sky130_fd_sc_hd__decap_3
Xwire746 wire746/A VGND VGND VPWR VPWR wire746/X sky130_fd_sc_hd__clkbuf_4
XFILLER_108_253 VGND VGND VPWR VPWR sky130_fd_sc_hd__fill_2
XTAP_TAPCELL_ROW_94_1602 VGND VPWR sky130_fd_sc_hd__tapvpwrvgnd_1
XTAP_TAPCELL_ROW_94_1613 VGND VPWR sky130_fd_sc_hd__tapvpwrvgnd_1
XFILLER_108_264 VGND VGND VPWR VPWR sky130_fd_sc_hd__decap_3
XFILLER_123_223 VGND VGND VPWR VPWR sky130_fd_sc_hd__fill_1
XFILLER_117_81 VGND VGND VPWR VPWR sky130_fd_sc_hd__decap_3
Xload_slew729 fanout728/X VGND VGND VPWR VPWR load_slew729/X sky130_fd_sc_hd__buf_4
Xload_slew718 fanout717/X VGND VGND VPWR VPWR load_slew718/X sky130_fd_sc_hd__buf_2
XFILLER_132_790 VGND VGND VPWR VPWR sky130_fd_sc_hd__decap_3
XFILLER_2_586 VGND VGND VPWR VPWR sky130_fd_sc_hd__fill_2
XFILLER_28_9 VGND VGND VPWR VPWR sky130_fd_sc_hd__decap_3
XFILLER_65_505 VGND VGND VPWR VPWR sky130_fd_sc_hd__decap_3
XFILLER_77_343 VGND VGND VPWR VPWR sky130_fd_sc_hd__fill_2
XFILLER_18_410 VGND VGND VPWR VPWR sky130_fd_sc_hd__fill_1
XFILLER_37_218 VGND VGND VPWR VPWR sky130_fd_sc_hd__decap_3
XFILLER_92_335 VGND VGND VPWR VPWR sky130_fd_sc_hd__decap_3
XFILLER_33_402 VGND VGND VPWR VPWR sky130_fd_sc_hd__fill_1
XFILLER_45_240 VGND VGND VPWR VPWR sky130_fd_sc_hd__fill_1
XFILLER_45_262 VGND VGND VPWR VPWR sky130_fd_sc_hd__decap_3
XFILLER_33_424 VGND VGND VPWR VPWR sky130_fd_sc_hd__decap_3
XFILLER_61_744 VGND VGND VPWR VPWR sky130_fd_sc_hd__decap_3
XFILLER_61_788 VGND VGND VPWR VPWR sky130_fd_sc_hd__fill_1
XTAP_TAPCELL_ROW_103_1731 VGND VPWR sky130_fd_sc_hd__tapvpwrvgnd_1
X_3720_ _3705_/C _3719_/X _3727_/B VGND VGND VPWR VPWR _3721_/A sky130_fd_sc_hd__o21ba_2
XFILLER_9_141 VGND VGND VPWR VPWR sky130_fd_sc_hd__fill_2
X_6370_ _6370_/A VGND VGND VPWR VPWR _8241_/D sky130_fd_sc_hd__buf_2
XFILLER_115_702 VGND VGND VPWR VPWR sky130_fd_sc_hd__fill_2
XFILLER_115_735 VGND VGND VPWR VPWR sky130_fd_sc_hd__fill_2
XFILLER_127_573 VGND VGND VPWR VPWR sky130_fd_sc_hd__decap_3
XTAP_TAPCELL_ROW_132_2138 VGND VPWR sky130_fd_sc_hd__tapvpwrvgnd_1
X_5321_ hold992/X _4917_/X _5331_/S VGND VGND VPWR VPWR _5322_/A sky130_fd_sc_hd__mux2_2
XFILLER_114_223 VGND VGND VPWR VPWR sky130_fd_sc_hd__fill_1
XFILLER_88_608 VGND VGND VPWR VPWR sky130_fd_sc_hd__decap_3
X_8040_ _8698_/CLK _8040_/D load_slew748/X VGND VGND VPWR VPWR _8040_/Q sky130_fd_sc_hd__dfrtp_2
XFILLER_102_418 VGND VGND VPWR VPWR sky130_fd_sc_hd__fill_2
XFILLER_115_779 VGND VGND VPWR VPWR sky130_fd_sc_hd__decap_3
XFILLER_130_716 VGND VGND VPWR VPWR sky130_fd_sc_hd__decap_3
XFILLER_69_800 VGND VGND VPWR VPWR sky130_fd_sc_hd__decap_3
XTAP_TAPCELL_ROW_114_1882 VGND VPWR sky130_fd_sc_hd__tapvpwrvgnd_1
X_5252_ _7680_/Q _4777_/X _5268_/S VGND VGND VPWR VPWR _5253_/A sky130_fd_sc_hd__mux2_2
XFILLER_130_749 VGND VGND VPWR VPWR sky130_fd_sc_hd__decap_3
XTAP_TAPCELL_ROW_114_1893 VGND VPWR sky130_fd_sc_hd__tapvpwrvgnd_1
X_5183_ _5183_/A VGND VGND VPWR VPWR _7647_/D sky130_fd_sc_hd__buf_1
X_4203_ _8092_/Q _8173_/Q _4209_/S VGND VGND VPWR VPWR _4203_/X sky130_fd_sc_hd__mux2_2
XFILLER_3_60 VGND VGND VPWR VPWR sky130_fd_sc_hd__decap_3
XFILLER_96_641 VGND VGND VPWR VPWR sky130_fd_sc_hd__decap_3
XFILLER_96_663 VGND VGND VPWR VPWR sky130_fd_sc_hd__fill_2
X_4134_ _8329_/Q _4350_/A2 _4160_/B _8248_/Q _3791_/A VGND VGND VPWR VPWR _4134_/X
+ sky130_fd_sc_hd__o221a_2
XFILLER_3_93 VGND VGND VPWR VPWR sky130_fd_sc_hd__decap_3
XFILLER_68_398 VGND VGND VPWR VPWR sky130_fd_sc_hd__fill_1
XFILLER_83_313 VGND VGND VPWR VPWR sky130_fd_sc_hd__decap_3
XFILLER_95_184 VGND VGND VPWR VPWR sky130_fd_sc_hd__decap_3
XTAP_TAPCELL_ROW_3_328 VGND VPWR sky130_fd_sc_hd__tapvpwrvgnd_1
XTAP_TAPCELL_ROW_3_339 VGND VPWR sky130_fd_sc_hd__tapvpwrvgnd_1
XFILLER_83_335 VGND VGND VPWR VPWR sky130_fd_sc_hd__fill_1
X_4065_ _4065_/A VGND VGND VPWR VPWR _4065_/X sky130_fd_sc_hd__clkbuf_2
XFILLER_36_251 VGND VGND VPWR VPWR sky130_fd_sc_hd__fill_1
XFILLER_83_368 VGND VGND VPWR VPWR sky130_fd_sc_hd__fill_1
XTAP_TAPCELL_ROW_65_1203 VGND VPWR sky130_fd_sc_hd__tapvpwrvgnd_1
XFILLER_24_424 VGND VGND VPWR VPWR sky130_fd_sc_hd__fill_2
XFILLER_52_744 VGND VGND VPWR VPWR sky130_fd_sc_hd__decap_3
XFILLER_64_582 VGND VGND VPWR VPWR sky130_fd_sc_hd__fill_2
X_7824_ _8645_/CLK _7824_/D fanout502/X VGND VGND VPWR VPWR _7824_/Q sky130_fd_sc_hd__dfrtp_2
XFILLER_12_619 VGND VGND VPWR VPWR sky130_fd_sc_hd__decap_3
XFILLER_24_468 VGND VGND VPWR VPWR sky130_fd_sc_hd__decap_3
XFILLER_51_265 VGND VGND VPWR VPWR sky130_fd_sc_hd__decap_3
XFILLER_51_287 VGND VGND VPWR VPWR sky130_fd_sc_hd__decap_3
XTAP_TAPCELL_ROW_22_603 VGND VPWR sky130_fd_sc_hd__tapvpwrvgnd_1
X_7755_ _8495_/CLK _7755_/D load_slew511/X VGND VGND VPWR VPWR _7755_/Q sky130_fd_sc_hd__dfrtp_2
X_4967_ _4967_/A VGND VGND VPWR VPWR _7562_/D sky130_fd_sc_hd__buf_1
XFILLER_132_9 VGND VGND VPWR VPWR sky130_fd_sc_hd__decap_3
XFILLER_22_14 VGND VGND VPWR VPWR sky130_fd_sc_hd__decap_3
X_3918_ _7975_/Q _3784_/X _3917_/X _3993_/A _3925_/A VGND VGND VPWR VPWR _3918_/X
+ sky130_fd_sc_hd__o221a_2
X_7686_ _8669_/CLK _7686_/D load_slew636/X VGND VGND VPWR VPWR _7686_/Q sky130_fd_sc_hd__dfrtp_2
X_6706_ _6706_/A VGND VGND VPWR VPWR _8398_/D sky130_fd_sc_hd__buf_2
X_4898_ _4898_/A _4902_/B VGND VGND VPWR VPWR _4899_/A sky130_fd_sc_hd__and2_2
XFILLER_22_47 VGND VGND VPWR VPWR sky130_fd_sc_hd__decap_3
XTAP_TAPCELL_ROW_50_989 VGND VPWR sky130_fd_sc_hd__tapvpwrvgnd_1
X_3849_ _8060_/Q _8141_/Q _8222_/Q _8303_/Q _3845_/S _3849_/S1 VGND VGND VPWR VPWR
+ _3849_/X sky130_fd_sc_hd__mux4_2
X_6637_ _6637_/A VGND VGND VPWR VPWR _8367_/D sky130_fd_sc_hd__buf_2
X_6568_ _4765_/X _8335_/Q _6570_/S VGND VGND VPWR VPWR _6569_/A sky130_fd_sc_hd__mux2_2
X_8307_ _8335_/CLK _8307_/D fanout542/X VGND VGND VPWR VPWR _8307_/Q sky130_fd_sc_hd__dfrtp_2
X_5519_ _5519_/A VGND VGND VPWR VPWR _7805_/D sky130_fd_sc_hd__buf_1
XFILLER_106_757 VGND VGND VPWR VPWR sky130_fd_sc_hd__decap_3
XFILLER_133_532 VGND VGND VPWR VPWR sky130_fd_sc_hd__decap_3
XTAP_TAPCELL_ROW_76_1354 VGND VPWR sky130_fd_sc_hd__tapvpwrvgnd_1
X_6499_ _4969_/X _8302_/Q _6507_/S VGND VGND VPWR VPWR _6500_/A sky130_fd_sc_hd__mux2_2
XFILLER_133_576 VGND VGND VPWR VPWR sky130_fd_sc_hd__decap_3
X_8238_ _8400_/CLK _8238_/D wire555/X VGND VGND VPWR VPWR _8238_/Q sky130_fd_sc_hd__dfrtp_2
XFILLER_120_215 VGND VGND VPWR VPWR sky130_fd_sc_hd__decap_3
X_8169_ _8493_/CLK _8169_/D load_slew480/X VGND VGND VPWR VPWR _8169_/Q sky130_fd_sc_hd__dfrtp_2
XFILLER_120_259 VGND VGND VPWR VPWR sky130_fd_sc_hd__fill_2
XFILLER_101_484 VGND VGND VPWR VPWR sky130_fd_sc_hd__fill_2
XFILLER_47_55 VGND VGND VPWR VPWR sky130_fd_sc_hd__fill_1
XFILLER_74_302 VGND VGND VPWR VPWR sky130_fd_sc_hd__decap_3
XFILLER_86_162 VGND VGND VPWR VPWR sky130_fd_sc_hd__decap_3
XFILLER_47_549 VGND VGND VPWR VPWR sky130_fd_sc_hd__decap_3
XFILLER_27_251 VGND VGND VPWR VPWR sky130_fd_sc_hd__decap_3
XFILLER_62_519 VGND VGND VPWR VPWR sky130_fd_sc_hd__decap_3
XFILLER_74_368 VGND VGND VPWR VPWR sky130_fd_sc_hd__decap_3
XFILLER_103_72 VGND VGND VPWR VPWR sky130_fd_sc_hd__decap_3
XFILLER_27_284 VGND VGND VPWR VPWR sky130_fd_sc_hd__fill_1
XFILLER_55_582 VGND VGND VPWR VPWR sky130_fd_sc_hd__decap_3
XFILLER_63_43 VGND VGND VPWR VPWR sky130_fd_sc_hd__fill_1
XFILLER_30_416 VGND VGND VPWR VPWR sky130_fd_sc_hd__decap_3
XFILLER_63_98 VGND VGND VPWR VPWR sky130_fd_sc_hd__decap_3
XFILLER_30_449 VGND VGND VPWR VPWR sky130_fd_sc_hd__decap_3
XFILLER_8_27 VGND VGND VPWR VPWR sky130_fd_sc_hd__fill_1
XFILLER_8_38 VGND VGND VPWR VPWR sky130_fd_sc_hd__decap_3
XFILLER_11_685 VGND VGND VPWR VPWR sky130_fd_sc_hd__decap_3
XFILLER_7_623 VGND VGND VPWR VPWR sky130_fd_sc_hd__decap_3
XFILLER_10_162 VGND VGND VPWR VPWR sky130_fd_sc_hd__decap_3
XFILLER_10_173 VGND VGND VPWR VPWR sky130_fd_sc_hd__decap_3
XFILLER_6_144 VGND VGND VPWR VPWR sky130_fd_sc_hd__decap_3
XFILLER_7_656 VGND VGND VPWR VPWR sky130_fd_sc_hd__decap_3
XFILLER_12_80 VGND VGND VPWR VPWR sky130_fd_sc_hd__decap_3
XFILLER_109_595 VGND VGND VPWR VPWR sky130_fd_sc_hd__decap_3
XFILLER_128_80 VGND VGND VPWR VPWR sky130_fd_sc_hd__decap_3
XFILLER_128_91 VGND VGND VPWR VPWR sky130_fd_sc_hd__decap_3
XFILLER_124_554 VGND VGND VPWR VPWR sky130_fd_sc_hd__decap_3
XFILLER_88_73 VGND VGND VPWR VPWR sky130_fd_sc_hd__fill_1
XFILLER_124_587 VGND VGND VPWR VPWR sky130_fd_sc_hd__fill_1
XFILLER_124_598 VGND VGND VPWR VPWR sky130_fd_sc_hd__decap_3
Xload_slew526 fanout525/X VGND VGND VPWR VPWR load_slew526/X sky130_fd_sc_hd__buf_4
Xload_slew515 fanout514/X VGND VGND VPWR VPWR load_slew515/X sky130_fd_sc_hd__clkbuf_4
XFILLER_26_6 VGND VGND VPWR VPWR sky130_fd_sc_hd__decap_3
XFILLER_78_641 VGND VGND VPWR VPWR sky130_fd_sc_hd__decap_3
XFILLER_19_785 VGND VGND VPWR VPWR sky130_fd_sc_hd__decap_3
XFILLER_53_508 VGND VGND VPWR VPWR sky130_fd_sc_hd__decap_3
XFILLER_65_368 VGND VGND VPWR VPWR sky130_fd_sc_hd__decap_3
XFILLER_18_284 VGND VGND VPWR VPWR sky130_fd_sc_hd__decap_3
XFILLER_34_733 VGND VGND VPWR VPWR sky130_fd_sc_hd__fill_2
XFILLER_46_582 VGND VGND VPWR VPWR sky130_fd_sc_hd__decap_3
X_5870_ _5948_/A VGND VGND VPWR VPWR _5870_/X sky130_fd_sc_hd__clkbuf_1
XFILLER_34_755 VGND VGND VPWR VPWR sky130_fd_sc_hd__fill_1
X_4821_ _4821_/A VGND VGND VPWR VPWR _7528_/D sky130_fd_sc_hd__buf_1
XFILLER_21_405 VGND VGND VPWR VPWR sky130_fd_sc_hd__decap_3
XFILLER_61_585 VGND VGND VPWR VPWR sky130_fd_sc_hd__decap_3
XFILLER_21_449 VGND VGND VPWR VPWR sky130_fd_sc_hd__decap_3
XTAP_TAPCELL_ROW_60_1133 VGND VPWR sky130_fd_sc_hd__tapvpwrvgnd_1
X_7540_ _8638_/CLK _7540_/D load_slew596/X VGND VGND VPWR VPWR _7540_/Q sky130_fd_sc_hd__dfrtp_2
X_4752_ _4752_/A _4776_/B VGND VGND VPWR VPWR _4753_/A sky130_fd_sc_hd__and2_2
XFILLER_119_326 VGND VGND VPWR VPWR sky130_fd_sc_hd__decap_3
X_7471_ _7471_/A VGND VGND VPWR VPWR _8791_/D sky130_fd_sc_hd__buf_1
X_4683_ _8458_/Q _8539_/Q _8620_/Q _8701_/Q _4680_/S _4344_/A VGND VGND VPWR VPWR
+ _4683_/X sky130_fd_sc_hd__mux4_2
X_6422_ _4815_/X _6422_/A1 _6440_/S VGND VGND VPWR VPWR _6423_/A sky130_fd_sc_hd__mux2_1
XFILLER_134_307 VGND VGND VPWR VPWR sky130_fd_sc_hd__fill_1
XFILLER_134_318 VGND VGND VPWR VPWR sky130_fd_sc_hd__decap_3
XTAP_TAPCELL_ROW_116_1911 VGND VPWR sky130_fd_sc_hd__tapvpwrvgnd_1
XTAP_TAPCELL_ROW_116_1922 VGND VPWR sky130_fd_sc_hd__tapvpwrvgnd_1
XTAP_TAPCELL_ROW_8_409 VGND VPWR sky130_fd_sc_hd__tapvpwrvgnd_1
X_6353_ _6353_/A VGND VGND VPWR VPWR _8233_/D sky130_fd_sc_hd__buf_2
XFILLER_0_309 VGND VGND VPWR VPWR sky130_fd_sc_hd__decap_3
X_6284_ _6284_/A VGND VGND VPWR VPWR _8201_/D sky130_fd_sc_hd__buf_6
X_5304_ _7705_/Q _4883_/X _5310_/S VGND VGND VPWR VPWR _5305_/A sky130_fd_sc_hd__mux2_2
XFILLER_103_738 VGND VGND VPWR VPWR sky130_fd_sc_hd__decap_3
XFILLER_103_749 VGND VGND VPWR VPWR sky130_fd_sc_hd__fill_2
XFILLER_130_513 VGND VGND VPWR VPWR sky130_fd_sc_hd__decap_3
XFILLER_88_427 VGND VGND VPWR VPWR sky130_fd_sc_hd__fill_1
X_8023_ _8029_/CLK _8023_/D fanout576/X VGND VGND VPWR VPWR _8023_/Q sky130_fd_sc_hd__dfrtp_2
X_5235_ _7672_/Q _4745_/X _5247_/S VGND VGND VPWR VPWR _5236_/A sky130_fd_sc_hd__mux2_2
XFILLER_102_248 VGND VGND VPWR VPWR sky130_fd_sc_hd__decap_3
XFILLER_124_27 VGND VGND VPWR VPWR sky130_fd_sc_hd__fill_1
XFILLER_124_38 VGND VGND VPWR VPWR sky130_fd_sc_hd__decap_3
XFILLER_130_557 VGND VGND VPWR VPWR sky130_fd_sc_hd__decap_3
XFILLER_111_771 VGND VGND VPWR VPWR sky130_fd_sc_hd__decap_3
XFILLER_96_460 VGND VGND VPWR VPWR sky130_fd_sc_hd__decap_3
XTAP_TAPCELL_ROW_71_1284 VGND VPWR sky130_fd_sc_hd__tapvpwrvgnd_1
X_5166_ _7639_/Q _4945_/X _5184_/S VGND VGND VPWR VPWR _5167_/A sky130_fd_sc_hd__mux2_2
XFILLER_29_549 VGND VGND VPWR VPWR sky130_fd_sc_hd__fill_2
X_5097_ _5160_/S VGND VGND VPWR VPWR _5116_/S sky130_fd_sc_hd__buf_2
X_4117_ _4117_/A _4117_/B VGND VGND VPWR VPWR _4117_/X sky130_fd_sc_hd__or2_2
XFILLER_17_36 VGND VGND VPWR VPWR sky130_fd_sc_hd__decap_3
XFILLER_44_519 VGND VGND VPWR VPWR sky130_fd_sc_hd__decap_3
XFILLER_56_368 VGND VGND VPWR VPWR sky130_fd_sc_hd__decap_3
XFILLER_71_316 VGND VGND VPWR VPWR sky130_fd_sc_hd__fill_2
X_4048_ _8077_/Q _8158_/Q _8239_/Q _8320_/Q _4091_/S0 _4091_/S1 VGND VGND VPWR VPWR
+ _4048_/X sky130_fd_sc_hd__mux4_2
XFILLER_17_69 VGND VGND VPWR VPWR sky130_fd_sc_hd__decap_3
XFILLER_25_744 VGND VGND VPWR VPWR sky130_fd_sc_hd__fill_1
XFILLER_37_593 VGND VGND VPWR VPWR sky130_fd_sc_hd__fill_1
XFILLER_83_198 VGND VGND VPWR VPWR sky130_fd_sc_hd__decap_3
XFILLER_25_766 VGND VGND VPWR VPWR sky130_fd_sc_hd__decap_3
XFILLER_52_563 VGND VGND VPWR VPWR sky130_fd_sc_hd__decap_3
XFILLER_12_416 VGND VGND VPWR VPWR sky130_fd_sc_hd__decap_3
XFILLER_25_799 VGND VGND VPWR VPWR sky130_fd_sc_hd__decap_3
XTAP_TAPCELL_ROW_35_783 VGND VPWR sky130_fd_sc_hd__tapvpwrvgnd_1
X_8787_ _8788_/CLK _8787_/D fanout664/X VGND VGND VPWR VPWR _8787_/Q sky130_fd_sc_hd__dfrtp_2
X_7807_ _8789_/CLK _7807_/D wire680/X VGND VGND VPWR VPWR _7807_/Q sky130_fd_sc_hd__dfrtp_2
X_5999_ _8067_/Q input7/X _6011_/S VGND VGND VPWR VPWR _6000_/A sky130_fd_sc_hd__mux2_2
XFILLER_33_57 VGND VGND VPWR VPWR sky130_fd_sc_hd__decap_3
X_7738_ _8477_/CLK _7738_/D load_slew605/X VGND VGND VPWR VPWR _7738_/Q sky130_fd_sc_hd__dfrtp_2
XFILLER_130_6 VGND VGND VPWR VPWR sky130_fd_sc_hd__decap_3
X_7669_ _7669_/CLK _7669_/D fanout475/A VGND VGND VPWR VPWR _7669_/Q sky130_fd_sc_hd__dfrtp_2
XFILLER_4_604 VGND VGND VPWR VPWR sky130_fd_sc_hd__decap_3
XFILLER_3_125 VGND VGND VPWR VPWR sky130_fd_sc_hd__decap_3
XFILLER_4_637 VGND VGND VPWR VPWR sky130_fd_sc_hd__decap_3
XFILLER_4_648 VGND VGND VPWR VPWR sky130_fd_sc_hd__decap_3
XFILLER_106_554 VGND VGND VPWR VPWR sky130_fd_sc_hd__decap_3
XFILLER_133_340 VGND VGND VPWR VPWR sky130_fd_sc_hd__decap_3
XFILLER_3_169 VGND VGND VPWR VPWR sky130_fd_sc_hd__fill_2
XFILLER_79_405 VGND VGND VPWR VPWR sky130_fd_sc_hd__decap_3
XFILLER_106_587 VGND VGND VPWR VPWR sky130_fd_sc_hd__fill_1
XFILLER_106_598 VGND VGND VPWR VPWR sky130_fd_sc_hd__fill_1
XFILLER_133_373 VGND VGND VPWR VPWR sky130_fd_sc_hd__decap_3
XFILLER_102_760 VGND VGND VPWR VPWR sky130_fd_sc_hd__decap_3
XFILLER_59_162 VGND VGND VPWR VPWR sky130_fd_sc_hd__decap_3
XFILLER_87_460 VGND VGND VPWR VPWR sky130_fd_sc_hd__decap_3
XFILLER_94_419 VGND VGND VPWR VPWR sky130_fd_sc_hd__fill_1
XFILLER_101_281 VGND VGND VPWR VPWR sky130_fd_sc_hd__decap_3
XFILLER_75_633 VGND VGND VPWR VPWR sky130_fd_sc_hd__fill_1
XTAP_TAPCELL_ROW_89_1534 VGND VPWR sky130_fd_sc_hd__tapvpwrvgnd_1
XTAP_TAPCELL_ROW_89_1545 VGND VPWR sky130_fd_sc_hd__tapvpwrvgnd_1
XFILLER_74_165 VGND VGND VPWR VPWR sky130_fd_sc_hd__fill_1
XFILLER_75_688 VGND VGND VPWR VPWR sky130_fd_sc_hd__decap_3
XFILLER_28_571 VGND VGND VPWR VPWR sky130_fd_sc_hd__decap_3
XFILLER_74_64 VGND VGND VPWR VPWR sky130_fd_sc_hd__fill_1
XFILLER_43_552 VGND VGND VPWR VPWR sky130_fd_sc_hd__decap_3
XFILLER_55_390 VGND VGND VPWR VPWR sky130_fd_sc_hd__fill_2
XFILLER_74_97 VGND VGND VPWR VPWR sky130_fd_sc_hd__decap_3
XFILLER_15_276 VGND VGND VPWR VPWR sky130_fd_sc_hd__decap_3
XFILLER_16_799 VGND VGND VPWR VPWR sky130_fd_sc_hd__decap_3
XFILLER_70_360 VGND VGND VPWR VPWR sky130_fd_sc_hd__decap_3
XFILLER_31_747 VGND VGND VPWR VPWR sky130_fd_sc_hd__decap_3
XFILLER_31_769 VGND VGND VPWR VPWR sky130_fd_sc_hd__decap_3
XFILLER_90_41 VGND VGND VPWR VPWR sky130_fd_sc_hd__decap_3
XFILLER_128_112 VGND VGND VPWR VPWR sky130_fd_sc_hd__decap_3
XFILLER_129_635 VGND VGND VPWR VPWR sky130_fd_sc_hd__decap_3
XFILLER_30_268 VGND VGND VPWR VPWR sky130_fd_sc_hd__fill_1
XFILLER_90_85 VGND VGND VPWR VPWR sky130_fd_sc_hd__decap_3
XFILLER_129_668 VGND VGND VPWR VPWR sky130_fd_sc_hd__decap_3
XFILLER_7_442 VGND VGND VPWR VPWR sky130_fd_sc_hd__decap_3
XTAP_TAPCELL_ROW_13_477 VGND VPWR sky130_fd_sc_hd__tapvpwrvgnd_1
XFILLER_116_307 VGND VGND VPWR VPWR sky130_fd_sc_hd__fill_1
XFILLER_116_318 VGND VGND VPWR VPWR sky130_fd_sc_hd__decap_3
XFILLER_128_156 VGND VGND VPWR VPWR sky130_fd_sc_hd__decap_3
XFILLER_129_679 VGND VGND VPWR VPWR sky130_fd_sc_hd__decap_3
XFILLER_109_370 VGND VGND VPWR VPWR sky130_fd_sc_hd__decap_3
XFILLER_128_189 VGND VGND VPWR VPWR sky130_fd_sc_hd__decap_3
Xload_slew312 _3988_/A VGND VGND VPWR VPWR _3900_/S sky130_fd_sc_hd__buf_4
XTAP_TAPCELL_ROW_111_1841 VGND VPWR sky130_fd_sc_hd__tapvpwrvgnd_1
XTAP_TAPCELL_ROW_111_1852 VGND VPWR sky130_fd_sc_hd__tapvpwrvgnd_1
Xload_slew356 _4082_/A VGND VGND VPWR VPWR _3910_/A sky130_fd_sc_hd__buf_2
Xload_slew345 fanout344/X VGND VGND VPWR VPWR _4151_/A sky130_fd_sc_hd__clkbuf_4
Xload_slew334 _4106_/S1 VGND VGND VPWR VPWR _4091_/S1 sky130_fd_sc_hd__clkbuf_4
Xload_slew323 _4342_/B2 VGND VGND VPWR VPWR _4444_/A1 sky130_fd_sc_hd__clkbuf_4
X_5020_ _5019_/X _7575_/Q _5028_/S VGND VGND VPWR VPWR _5021_/A sky130_fd_sc_hd__mux2_2
XFILLER_100_719 VGND VGND VPWR VPWR sky130_fd_sc_hd__decap_3
XFILLER_24_3 VGND VGND VPWR VPWR sky130_fd_sc_hd__decap_3
XFILLER_66_611 VGND VGND VPWR VPWR sky130_fd_sc_hd__decap_3
Xload_slew389 _4581_/A1 VGND VGND VPWR VPWR _4621_/A sky130_fd_sc_hd__clkbuf_4
XPHY_EDGE_ROW_119_Right_119 VGND VGND VPWR VPWR sky130_fd_sc_hd__decap_3
XFILLER_26_519 VGND VGND VPWR VPWR sky130_fd_sc_hd__fill_2
XFILLER_65_165 VGND VGND VPWR VPWR sky130_fd_sc_hd__decap_3
XFILLER_66_666 VGND VGND VPWR VPWR sky130_fd_sc_hd__decap_3
XFILLER_0_50 VGND VGND VPWR VPWR sky130_fd_sc_hd__decap_3
XFILLER_65_187 VGND VGND VPWR VPWR sky130_fd_sc_hd__decap_3
X_8710_ _8710_/CLK _8710_/D fanout665/X VGND VGND VPWR VPWR _8710_/Q sky130_fd_sc_hd__dfrtp_2
X_6971_ _4879_/X _8524_/Q _6979_/S VGND VGND VPWR VPWR _6972_/A sky130_fd_sc_hd__mux2_4
XFILLER_0_72 VGND VGND VPWR VPWR sky130_fd_sc_hd__decap_3
XFILLER_0_94 VGND VGND VPWR VPWR sky130_fd_sc_hd__decap_3
X_5922_ _5948_/A VGND VGND VPWR VPWR _5922_/X sky130_fd_sc_hd__clkbuf_1
X_8641_ _8731_/CLK _8641_/D fanout497/X VGND VGND VPWR VPWR _8641_/Q sky130_fd_sc_hd__dfrtp_2
X_5853_ _5947_/A VGND VGND VPWR VPWR _5853_/X sky130_fd_sc_hd__clkbuf_1
XTAP_TAPCELL_ROW_32_742 VGND VPWR sky130_fd_sc_hd__tapvpwrvgnd_1
X_8572_ _8658_/CLK _8572_/D load_slew515/X VGND VGND VPWR VPWR _8572_/Q sky130_fd_sc_hd__dfrtp_2
X_5784_ _7931_/Q _4811_/A _5784_/S VGND VGND VPWR VPWR _5785_/A sky130_fd_sc_hd__mux2_2
X_4804_ _4803_/X _4804_/A1 _4820_/S VGND VGND VPWR VPWR _4805_/A sky130_fd_sc_hd__mux2_2
XFILLER_9_81 VGND VGND VPWR VPWR sky130_fd_sc_hd__decap_3
X_7523_ _8748_/CLK _7523_/D fanout542/X VGND VGND VPWR VPWR _7523_/Q sky130_fd_sc_hd__dfrtp_2
X_4735_ _4735_/A VGND VGND VPWR VPWR _4735_/X sky130_fd_sc_hd__buf_1
XFILLER_119_123 VGND VGND VPWR VPWR sky130_fd_sc_hd__fill_1
XFILLER_119_27 VGND VGND VPWR VPWR sky130_fd_sc_hd__decap_3
X_7454_ _7454_/A VGND VGND VPWR VPWR _8783_/D sky130_fd_sc_hd__buf_1
X_4666_ _4666_/A1 _4657_/X _4660_/X _4665_/X VGND VGND VPWR VPWR _4666_/X sky130_fd_sc_hd__o31a_2
XFILLER_128_690 VGND VGND VPWR VPWR sky130_fd_sc_hd__decap_3
XFILLER_134_115 VGND VGND VPWR VPWR sky130_fd_sc_hd__decap_3
Xhold910 _8626_/Q VGND VGND VPWR VPWR hold910/X sky130_fd_sc_hd__dlygate4sd3_1
Xhold921 _8257_/Q VGND VGND VPWR VPWR hold921/X sky130_fd_sc_hd__dlygate4sd3_1
X_7385_ _7385_/A VGND VGND VPWR VPWR _8750_/D sky130_fd_sc_hd__buf_1
X_6405_ _4782_/X hold933/X _6419_/S VGND VGND VPWR VPWR _6406_/A sky130_fd_sc_hd__mux2_1
X_4597_ _7712_/Q _3774_/X _4645_/B1 _7631_/Q _4677_/C1 VGND VGND VPWR VPWR _4597_/X
+ sky130_fd_sc_hd__o221a_2
XFILLER_131_800 VGND VGND VPWR VPWR sky130_fd_sc_hd__decap_3
XFILLER_134_159 VGND VGND VPWR VPWR sky130_fd_sc_hd__decap_3
XFILLER_1_607 VGND VGND VPWR VPWR sky130_fd_sc_hd__decap_3
XTAP_TAPCELL_ROW_73_1313 VGND VPWR sky130_fd_sc_hd__tapvpwrvgnd_1
Xclkbuf_leaf_143_CLK clkbuf_leaf_1_CLK/A VGND VGND VPWR VPWR _8732_/CLK sky130_fd_sc_hd__clkbuf_8
Xhold932 _8580_/Q VGND VGND VPWR VPWR hold932/X sky130_fd_sc_hd__dlygate4sd3_1
Xhold943 _8573_/Q VGND VGND VPWR VPWR hold943/X sky130_fd_sc_hd__dlygate4sd3_1
Xhold954 _8602_/Q VGND VGND VPWR VPWR hold954/X sky130_fd_sc_hd__dlygate4sd3_1
X_6336_ _6336_/A VGND VGND VPWR VPWR _8225_/D sky130_fd_sc_hd__buf_2
XFILLER_0_106 VGND VGND VPWR VPWR sky130_fd_sc_hd__decap_3
XFILLER_135_15 VGND VGND VPWR VPWR sky130_fd_sc_hd__decap_3
XFILLER_1_629 VGND VGND VPWR VPWR sky130_fd_sc_hd__decap_3
XFILLER_89_747 VGND VGND VPWR VPWR sky130_fd_sc_hd__decap_3
Xhold965 _7588_/Q VGND VGND VPWR VPWR hold965/X sky130_fd_sc_hd__dlygate4sd3_1
Xhold976 _7700_/Q VGND VGND VPWR VPWR hold976/X sky130_fd_sc_hd__dlygate4sd3_1
Xhold987 _7602_/Q VGND VGND VPWR VPWR hold987/X sky130_fd_sc_hd__dlygate4sd3_1
Xhold998 _7554_/Q VGND VGND VPWR VPWR hold998/X sky130_fd_sc_hd__dlygate4sd3_1
XFILLER_130_321 VGND VGND VPWR VPWR sky130_fd_sc_hd__fill_2
XFILLER_130_332 VGND VGND VPWR VPWR sky130_fd_sc_hd__decap_3
XFILLER_89_769 VGND VGND VPWR VPWR sky130_fd_sc_hd__decap_3
X_6267_ _6267_/A VGND VGND VPWR VPWR _8193_/D sky130_fd_sc_hd__buf_6
XFILLER_130_365 VGND VGND VPWR VPWR sky130_fd_sc_hd__fill_2
XFILLER_29_302 VGND VGND VPWR VPWR sky130_fd_sc_hd__decap_3
XFILLER_76_419 VGND VGND VPWR VPWR sky130_fd_sc_hd__fill_1
X_8006_ _8745_/CLK _8006_/D wire618/X VGND VGND VPWR VPWR _8006_/Q sky130_fd_sc_hd__dfrtp_2
X_6198_ _6198_/A VGND VGND VPWR VPWR _8160_/D sky130_fd_sc_hd__buf_6
X_5218_ _7664_/Q _4711_/X _5226_/S VGND VGND VPWR VPWR _5219_/A sky130_fd_sc_hd__mux2_2
XFILLER_28_24 VGND VGND VPWR VPWR sky130_fd_sc_hd__decap_3
XFILLER_28_35 VGND VGND VPWR VPWR sky130_fd_sc_hd__decap_3
XFILLER_96_290 VGND VGND VPWR VPWR sky130_fd_sc_hd__decap_3
X_5149_ _5149_/A VGND VGND VPWR VPWR _7632_/D sky130_fd_sc_hd__buf_1
XFILLER_17_508 VGND VGND VPWR VPWR sky130_fd_sc_hd__decap_3
XFILLER_71_113 VGND VGND VPWR VPWR sky130_fd_sc_hd__decap_3
XFILLER_44_12 VGND VGND VPWR VPWR sky130_fd_sc_hd__decap_3
XFILLER_52_371 VGND VGND VPWR VPWR sky130_fd_sc_hd__decap_3
XTAP_TAPCELL_ROW_84_1464 VGND VPWR sky130_fd_sc_hd__tapvpwrvgnd_1
XTAP_TAPCELL_ROW_84_1475 VGND VPWR sky130_fd_sc_hd__tapvpwrvgnd_1
XFILLER_12_224 VGND VGND VPWR VPWR sky130_fd_sc_hd__decap_3
XFILLER_13_747 VGND VGND VPWR VPWR sky130_fd_sc_hd__decap_3
XFILLER_40_533 VGND VGND VPWR VPWR sky130_fd_sc_hd__fill_2
XFILLER_9_718 VGND VGND VPWR VPWR sky130_fd_sc_hd__decap_3
XFILLER_8_217 VGND VGND VPWR VPWR sky130_fd_sc_hd__decap_3
XFILLER_9_729 VGND VGND VPWR VPWR sky130_fd_sc_hd__decap_3
XFILLER_126_616 VGND VGND VPWR VPWR sky130_fd_sc_hd__decap_3
XTAP_TAPCELL_ROW_10_436 VGND VPWR sky130_fd_sc_hd__tapvpwrvgnd_1
XFILLER_109_60 VGND VGND VPWR VPWR sky130_fd_sc_hd__decap_3
XFILLER_134_660 VGND VGND VPWR VPWR sky130_fd_sc_hd__decap_3
XFILLER_5_39 VGND VGND VPWR VPWR sky130_fd_sc_hd__decap_3
XFILLER_69_20 VGND VGND VPWR VPWR sky130_fd_sc_hd__decap_3
Xclkbuf_leaf_134_CLK clkload1/A VGND VGND VPWR VPWR _8746_/CLK sky130_fd_sc_hd__clkbuf_8
XFILLER_134_693 VGND VGND VPWR VPWR sky130_fd_sc_hd__decap_3
XFILLER_4_489 VGND VGND VPWR VPWR sky130_fd_sc_hd__decap_3
XFILLER_121_321 VGND VGND VPWR VPWR sky130_fd_sc_hd__decap_3
XFILLER_121_332 VGND VGND VPWR VPWR sky130_fd_sc_hd__decap_3
XFILLER_121_343 VGND VGND VPWR VPWR sky130_fd_sc_hd__decap_3
XFILLER_133_181 VGND VGND VPWR VPWR sky130_fd_sc_hd__decap_3
XFILLER_69_97 VGND VGND VPWR VPWR sky130_fd_sc_hd__fill_2
XFILLER_79_246 VGND VGND VPWR VPWR sky130_fd_sc_hd__decap_3
XFILLER_0_651 VGND VGND VPWR VPWR sky130_fd_sc_hd__decap_3
XFILLER_0_673 VGND VGND VPWR VPWR sky130_fd_sc_hd__decap_3
XFILLER_79_268 VGND VGND VPWR VPWR sky130_fd_sc_hd__fill_2
XFILLER_79_279 VGND VGND VPWR VPWR sky130_fd_sc_hd__fill_1
XFILLER_10_9 VGND VGND VPWR VPWR sky130_fd_sc_hd__decap_3
XFILLER_125_81 VGND VGND VPWR VPWR sky130_fd_sc_hd__decap_3
XFILLER_87_290 VGND VGND VPWR VPWR sky130_fd_sc_hd__decap_3
XFILLER_94_227 VGND VGND VPWR VPWR sky130_fd_sc_hd__decap_3
XFILLER_47_187 VGND VGND VPWR VPWR sky130_fd_sc_hd__decap_3
XFILLER_63_647 VGND VGND VPWR VPWR sky130_fd_sc_hd__fill_1
XFILLER_16_530 VGND VGND VPWR VPWR sky130_fd_sc_hd__fill_2
XTAP_TAPCELL_ROW_18_547 VGND VPWR sky130_fd_sc_hd__tapvpwrvgnd_1
XFILLER_62_168 VGND VGND VPWR VPWR sky130_fd_sc_hd__decap_3
XFILLER_90_477 VGND VGND VPWR VPWR sky130_fd_sc_hd__fill_2
XFILLER_31_544 VGND VGND VPWR VPWR sky130_fd_sc_hd__decap_3
XFILLER_93_6 VGND VGND VPWR VPWR sky130_fd_sc_hd__fill_1
XFILLER_31_555 VGND VGND VPWR VPWR sky130_fd_sc_hd__decap_3
XFILLER_129_432 VGND VGND VPWR VPWR sky130_fd_sc_hd__decap_3
XFILLER_8_740 VGND VGND VPWR VPWR sky130_fd_sc_hd__decap_3
XFILLER_129_476 VGND VGND VPWR VPWR sky130_fd_sc_hd__decap_3
X_4520_ _8120_/Q _8201_/Q _8282_/Q _8363_/Q _4523_/S0 _4531_/S1 VGND VGND VPWR VPWR
+ _4520_/X sky130_fd_sc_hd__mux4_2
XFILLER_116_137 VGND VGND VPWR VPWR sky130_fd_sc_hd__decap_3
XFILLER_8_784 VGND VGND VPWR VPWR sky130_fd_sc_hd__decap_3
X_4451_ _7698_/Q _3995_/B _4652_/B1 _7617_/Q VGND VGND VPWR VPWR _4451_/X sky130_fd_sc_hd__o22a_2
XFILLER_132_619 VGND VGND VPWR VPWR sky130_fd_sc_hd__decap_3
Xclkbuf_leaf_125_CLK clkbuf_leaf_91_CLK/A VGND VGND VPWR VPWR _8750_/CLK sky130_fd_sc_hd__clkbuf_8
X_7170_ _4933_/X hold924/X _7172_/S VGND VGND VPWR VPWR _7171_/A sky130_fd_sc_hd__mux2_1
XFILLER_125_671 VGND VGND VPWR VPWR sky130_fd_sc_hd__fill_1
XFILLER_125_693 VGND VGND VPWR VPWR sky130_fd_sc_hd__decap_3
XFILLER_98_533 VGND VGND VPWR VPWR sky130_fd_sc_hd__decap_3
X_6121_ _8125_/Q _4902_/A _6137_/S VGND VGND VPWR VPWR _6122_/A sky130_fd_sc_hd__mux2_2
X_4382_ _4415_/A _4380_/X _4381_/X VGND VGND VPWR VPWR _4382_/X sky130_fd_sc_hd__o21a_2
XFILLER_112_321 VGND VGND VPWR VPWR sky130_fd_sc_hd__decap_3
XTAP_TAPCELL_ROW_55_1065 VGND VPWR sky130_fd_sc_hd__tapvpwrvgnd_1
Xfanout708 fanout716/X VGND VGND VPWR VPWR fanout708/X sky130_fd_sc_hd__clkdlybuf4s25_1
Xfanout719 fanout736/X VGND VGND VPWR VPWR fanout719/X sky130_fd_sc_hd__clkdlybuf4s25_1
XFILLER_79_780 VGND VGND VPWR VPWR sky130_fd_sc_hd__decap_3
XPHY_EDGE_ROW_7_Right_7 VGND VGND VPWR VPWR sky130_fd_sc_hd__decap_3
X_6052_ _6052_/A VGND VGND VPWR VPWR _8092_/D sky130_fd_sc_hd__buf_1
XFILLER_38_121 VGND VGND VPWR VPWR sky130_fd_sc_hd__fill_1
XFILLER_78_290 VGND VGND VPWR VPWR sky130_fd_sc_hd__decap_3
XPHY_EDGE_ROW_0_Left_136 VGND VGND VPWR VPWR sky130_fd_sc_hd__decap_3
X_5003_ _5003_/A VGND VGND VPWR VPWR _5003_/X sky130_fd_sc_hd__buf_1
XFILLER_121_17 VGND VGND VPWR VPWR sky130_fd_sc_hd__decap_3
XFILLER_26_327 VGND VGND VPWR VPWR sky130_fd_sc_hd__fill_1
XFILLER_38_187 VGND VGND VPWR VPWR sky130_fd_sc_hd__fill_2
XFILLER_53_113 VGND VGND VPWR VPWR sky130_fd_sc_hd__fill_1
XFILLER_54_636 VGND VGND VPWR VPWR sky130_fd_sc_hd__decap_3
XTAP_TAPCELL_ROW_37_812 VGND VPWR sky130_fd_sc_hd__tapvpwrvgnd_1
XFILLER_26_349 VGND VGND VPWR VPWR sky130_fd_sc_hd__fill_1
X_6954_ _4845_/X _8516_/Q _6958_/S VGND VGND VPWR VPWR _6955_/A sky130_fd_sc_hd__mux2_4
X_5905_ _5906_/A1 _5906_/A2 _4765_/X _5906_/B1 hold903/X VGND VGND VPWR VPWR _8001_/D
+ sky130_fd_sc_hd__a32o_2
XFILLER_14_15 VGND VGND VPWR VPWR sky130_fd_sc_hd__decap_3
XFILLER_34_371 VGND VGND VPWR VPWR sky130_fd_sc_hd__decap_3
X_8624_ _8624_/CLK _8624_/D wire669/X VGND VGND VPWR VPWR _8624_/Q sky130_fd_sc_hd__dfrtp_2
X_6885_ _4707_/X _8483_/Q _6895_/S VGND VGND VPWR VPWR _6886_/A sky130_fd_sc_hd__mux2_4
XFILLER_14_59 VGND VGND VPWR VPWR sky130_fd_sc_hd__decap_3
X_5836_ _5836_/A VGND VGND VPWR VPWR _7955_/D sky130_fd_sc_hd__buf_1
XFILLER_10_728 VGND VGND VPWR VPWR sky130_fd_sc_hd__decap_3
X_8555_ _8799_/CLK _8555_/D fanout595/A VGND VGND VPWR VPWR _8555_/Q sky130_fd_sc_hd__dfrtp_2
X_5767_ _5767_/A VGND VGND VPWR VPWR _7922_/D sky130_fd_sc_hd__buf_1
XFILLER_135_402 VGND VGND VPWR VPWR sky130_fd_sc_hd__fill_2
X_8486_ _8648_/CLK _8486_/D fanout492/X VGND VGND VPWR VPWR _8486_/Q sky130_fd_sc_hd__dfrtp_2
X_7506_ _8731_/CLK _7506_/D load_slew496/X VGND VGND VPWR VPWR _7506_/Q sky130_fd_sc_hd__dfrtp_2
X_5698_ _7890_/Q _4981_/A _5700_/S VGND VGND VPWR VPWR _5699_/A sky130_fd_sc_hd__mux2_2
X_4718_ _4718_/A _4726_/B VGND VGND VPWR VPWR _4719_/A sky130_fd_sc_hd__and2_2
XFILLER_135_435 VGND VGND VPWR VPWR sky130_fd_sc_hd__decap_3
X_7437_ _8775_/Q _4912_/A _7449_/S VGND VGND VPWR VPWR _7438_/A sky130_fd_sc_hd__mux2_2
X_4649_ _4651_/A _4647_/X _4648_/X VGND VGND VPWR VPWR _4649_/X sky130_fd_sc_hd__o21a_2
XFILLER_135_457 VGND VGND VPWR VPWR sky130_fd_sc_hd__decap_3
Xclkbuf_leaf_116_CLK clkbuf_5_16__f_CLK/X VGND VGND VPWR VPWR _8745_/CLK sky130_fd_sc_hd__clkbuf_8
XFILLER_122_118 VGND VGND VPWR VPWR sky130_fd_sc_hd__decap_3
Xhold762 _8699_/Q VGND VGND VPWR VPWR hold762/X sky130_fd_sc_hd__dlygate4sd3_1
Xhold773 _8645_/Q VGND VGND VPWR VPWR hold773/X sky130_fd_sc_hd__dlygate4sd3_1
X_7368_ _8742_/Q _4772_/A _7386_/S VGND VGND VPWR VPWR _7369_/A sky130_fd_sc_hd__mux2_2
XFILLER_103_321 VGND VGND VPWR VPWR sky130_fd_sc_hd__fill_2
XFILLER_115_181 VGND VGND VPWR VPWR sky130_fd_sc_hd__decap_3
XFILLER_131_641 VGND VGND VPWR VPWR sky130_fd_sc_hd__decap_3
Xhold784 _8012_/Q VGND VGND VPWR VPWR hold784/X sky130_fd_sc_hd__dlygate4sd3_1
Xhold795 _8019_/Q VGND VGND VPWR VPWR hold795/X sky130_fd_sc_hd__dlygate4sd3_1
X_7299_ _7299_/A VGND VGND VPWR VPWR _8709_/D sky130_fd_sc_hd__buf_1
X_6319_ _4953_/X _8217_/Q _6335_/S VGND VGND VPWR VPWR _6320_/A sky130_fd_sc_hd__mux2_2
XFILLER_130_162 VGND VGND VPWR VPWR sky130_fd_sc_hd__decap_3
XFILLER_131_685 VGND VGND VPWR VPWR sky130_fd_sc_hd__decap_3
XFILLER_89_588 VGND VGND VPWR VPWR sky130_fd_sc_hd__decap_3
XFILLER_103_387 VGND VGND VPWR VPWR sky130_fd_sc_hd__decap_3
XFILLER_130_195 VGND VGND VPWR VPWR sky130_fd_sc_hd__fill_1
XFILLER_39_78 VGND VGND VPWR VPWR sky130_fd_sc_hd__fill_2
XFILLER_76_227 VGND VGND VPWR VPWR sky130_fd_sc_hd__fill_1
XFILLER_76_249 VGND VGND VPWR VPWR sky130_fd_sc_hd__decap_3
XFILLER_29_165 VGND VGND VPWR VPWR sky130_fd_sc_hd__decap_3
XFILLER_45_614 VGND VGND VPWR VPWR sky130_fd_sc_hd__fill_2
XFILLER_57_474 VGND VGND VPWR VPWR sky130_fd_sc_hd__decap_3
XFILLER_84_271 VGND VGND VPWR VPWR sky130_fd_sc_hd__decap_3
XFILLER_44_135 VGND VGND VPWR VPWR sky130_fd_sc_hd__decap_3
XFILLER_45_669 VGND VGND VPWR VPWR sky130_fd_sc_hd__decap_3
XFILLER_44_168 VGND VGND VPWR VPWR sky130_fd_sc_hd__decap_3
XFILLER_55_88 VGND VGND VPWR VPWR sky130_fd_sc_hd__fill_1
XFILLER_72_477 VGND VGND VPWR VPWR sky130_fd_sc_hd__fill_2
XTAP_TAPCELL_ROW_15_506 VGND VPWR sky130_fd_sc_hd__tapvpwrvgnd_1
XFILLER_111_72 VGND VGND VPWR VPWR sky130_fd_sc_hd__fill_1
XFILLER_13_544 VGND VGND VPWR VPWR sky130_fd_sc_hd__decap_3
XFILLER_71_98 VGND VGND VPWR VPWR sky130_fd_sc_hd__decap_3
XFILLER_126_402 VGND VGND VPWR VPWR sky130_fd_sc_hd__decap_3
XFILLER_126_424 VGND VGND VPWR VPWR sky130_fd_sc_hd__decap_3
XFILLER_5_721 VGND VGND VPWR VPWR sky130_fd_sc_hd__decap_3
XFILLER_5_732 VGND VGND VPWR VPWR sky130_fd_sc_hd__decap_3
XTAP_TAPCELL_ROW_97_1644 VGND VPWR sky130_fd_sc_hd__tapvpwrvgnd_1
XTAP_TAPCELL_ROW_97_1655 VGND VPWR sky130_fd_sc_hd__tapvpwrvgnd_1
XFILLER_126_457 VGND VGND VPWR VPWR sky130_fd_sc_hd__decap_3
XFILLER_5_765 VGND VGND VPWR VPWR sky130_fd_sc_hd__decap_3
Xclkbuf_leaf_107_CLK clkbuf_5_20__f_CLK/X VGND VGND VPWR VPWR _8545_/CLK sky130_fd_sc_hd__clkbuf_8
XFILLER_4_253 VGND VGND VPWR VPWR sky130_fd_sc_hd__decap_3
XFILLER_20_80 VGND VGND VPWR VPWR sky130_fd_sc_hd__decap_3
XFILLER_20_91 VGND VGND VPWR VPWR sky130_fd_sc_hd__fill_1
XFILLER_95_503 VGND VGND VPWR VPWR sky130_fd_sc_hd__fill_1
XFILLER_121_195 VGND VGND VPWR VPWR sky130_fd_sc_hd__decap_3
XFILLER_35_113 VGND VGND VPWR VPWR sky130_fd_sc_hd__decap_3
XTAP_TAPCELL_ROW_124_2029 VGND VPWR sky130_fd_sc_hd__tapvpwrvgnd_1
XFILLER_63_455 VGND VGND VPWR VPWR sky130_fd_sc_hd__decap_3
XFILLER_90_230 VGND VGND VPWR VPWR sky130_fd_sc_hd__decap_3
XTAP_TAPCELL_ROW_106_1773 VGND VPWR sky130_fd_sc_hd__tapvpwrvgnd_1
X_3951_ _8311_/Q _3762_/A _3880_/A _8230_/Q _3758_/A VGND VGND VPWR VPWR _3951_/X
+ sky130_fd_sc_hd__o221a_2
XFILLER_16_371 VGND VGND VPWR VPWR sky130_fd_sc_hd__decap_3
XFILLER_44_680 VGND VGND VPWR VPWR sky130_fd_sc_hd__decap_3
XFILLER_91_3 VGND VGND VPWR VPWR sky130_fd_sc_hd__fill_2
X_3882_ _8225_/Q _3916_/B _3881_/X _4330_/A _3791_/A VGND VGND VPWR VPWR _3882_/X
+ sky130_fd_sc_hd__o221a_2
Xclkbuf_5_25__f_CLK clkbuf_4_12_0_CLK/X VGND VGND VPWR VPWR clkbuf_leaf_88_CLK/A sky130_fd_sc_hd__clkbuf_16
X_6670_ _6670_/A VGND VGND VPWR VPWR _8381_/D sky130_fd_sc_hd__buf_2
XFILLER_31_396 VGND VGND VPWR VPWR sky130_fd_sc_hd__decap_3
XTAP_TAPCELL_ROW_42_881 VGND VPWR sky130_fd_sc_hd__tapvpwrvgnd_1
X_5621_ _7854_/Q _4829_/A _5633_/S VGND VGND VPWR VPWR _5622_/A sky130_fd_sc_hd__mux2_2
XFILLER_117_402 VGND VGND VPWR VPWR sky130_fd_sc_hd__fill_2
XFILLER_129_240 VGND VGND VPWR VPWR sky130_fd_sc_hd__decap_3
X_8340_ _8583_/CLK _8340_/D fanout619/X VGND VGND VPWR VPWR _8340_/Q sky130_fd_sc_hd__dfrtp_2
X_5552_ _7821_/Q _5031_/A _5570_/S VGND VGND VPWR VPWR _5553_/A sky130_fd_sc_hd__mux2_2
XFILLER_117_424 VGND VGND VPWR VPWR sky130_fd_sc_hd__decap_3
XFILLER_129_273 VGND VGND VPWR VPWR sky130_fd_sc_hd__decap_3
XFILLER_129_284 VGND VGND VPWR VPWR sky130_fd_sc_hd__decap_3
XFILLER_8_592 VGND VGND VPWR VPWR sky130_fd_sc_hd__decap_3
X_8271_ _8773_/CLK _8271_/D load_slew712/X VGND VGND VPWR VPWR _8271_/Q sky130_fd_sc_hd__dfrtp_2
X_4503_ _4503_/A _4503_/B VGND VGND VPWR VPWR _4503_/X sky130_fd_sc_hd__or2_2
X_5483_ _5483_/A VGND VGND VPWR VPWR _7789_/D sky130_fd_sc_hd__buf_1
XFILLER_132_427 VGND VGND VPWR VPWR sky130_fd_sc_hd__decap_3
XFILLER_6_71 VGND VGND VPWR VPWR sky130_fd_sc_hd__decap_3
X_7222_ wire234/X _4745_/X _7217_/X _7218_/X hold771/X VGND VGND VPWR VPWR _8654_/D
+ sky130_fd_sc_hd__a32o_2
X_4434_ _8598_/Q _4660_/A2 _4433_/X VGND VGND VPWR VPWR _4434_/X sky130_fd_sc_hd__o21a_2
X_7153_ _7174_/S VGND VGND VPWR VPWR _7172_/S sky130_fd_sc_hd__buf_6
X_4365_ _3955_/A _4361_/X _4363_/X _4364_/X VGND VGND VPWR VPWR _4365_/X sky130_fd_sc_hd__a22o_2
XFILLER_98_374 VGND VGND VPWR VPWR sky130_fd_sc_hd__decap_3
Xfanout516 fanout517/X VGND VGND VPWR VPWR fanout516/X sky130_fd_sc_hd__clkdlybuf4s25_1
Xfanout527 fanout614/X VGND VGND VPWR VPWR fanout527/X sky130_fd_sc_hd__clkdlybuf4s25_1
X_7084_ _4761_/X hold951/X _7088_/S VGND VGND VPWR VPWR _7085_/A sky130_fd_sc_hd__mux2_1
X_6104_ _8117_/Q _4870_/A _6116_/S VGND VGND VPWR VPWR _6105_/A sky130_fd_sc_hd__mux2_2
XFILLER_112_195 VGND VGND VPWR VPWR sky130_fd_sc_hd__fill_1
XFILLER_58_216 VGND VGND VPWR VPWR sky130_fd_sc_hd__decap_3
XFILLER_58_238 VGND VGND VPWR VPWR sky130_fd_sc_hd__decap_3
XFILLER_86_536 VGND VGND VPWR VPWR sky130_fd_sc_hd__fill_2
XFILLER_86_558 VGND VGND VPWR VPWR sky130_fd_sc_hd__decap_3
Xfanout549 fanout553/X VGND VGND VPWR VPWR fanout549/X sky130_fd_sc_hd__clkdlybuf4s25_1
X_6035_ _8084_/Q _4730_/A _6053_/S VGND VGND VPWR VPWR _6036_/A sky130_fd_sc_hd__mux2_2
X_4296_ _8748_/Q _7523_/Q _7604_/Q _7685_/Q _4209_/S _4151_/A VGND VGND VPWR VPWR
+ _4296_/X sky130_fd_sc_hd__mux4_2
XFILLER_100_368 VGND VGND VPWR VPWR sky130_fd_sc_hd__fill_1
XFILLER_132_27 VGND VGND VPWR VPWR sky130_fd_sc_hd__fill_1
XFILLER_132_38 VGND VGND VPWR VPWR sky130_fd_sc_hd__decap_3
XFILLER_54_411 VGND VGND VPWR VPWR sky130_fd_sc_hd__decap_3
XFILLER_54_433 VGND VGND VPWR VPWR sky130_fd_sc_hd__fill_2
XFILLER_54_444 VGND VGND VPWR VPWR sky130_fd_sc_hd__decap_3
XFILLER_66_282 VGND VGND VPWR VPWR sky130_fd_sc_hd__decap_3
XFILLER_82_753 VGND VGND VPWR VPWR sky130_fd_sc_hd__decap_3
XTAP_TAPCELL_ROW_68_1245 VGND VPWR sky130_fd_sc_hd__tapvpwrvgnd_1
XFILLER_25_36 VGND VGND VPWR VPWR sky130_fd_sc_hd__decap_3
XFILLER_42_628 VGND VGND VPWR VPWR sky130_fd_sc_hd__decap_3
XFILLER_54_477 VGND VGND VPWR VPWR sky130_fd_sc_hd__decap_3
X_7986_ _8731_/CLK _7986_/D fanout495/X VGND VGND VPWR VPWR _7986_/Q sky130_fd_sc_hd__dfrtp_2
XFILLER_25_69 VGND VGND VPWR VPWR sky130_fd_sc_hd__decap_3
XFILLER_41_116 VGND VGND VPWR VPWR sky130_fd_sc_hd__decap_3
XTAP_TAPCELL_ROW_81_1423 VGND VPWR sky130_fd_sc_hd__tapvpwrvgnd_1
X_6937_ _4811_/X _8508_/Q _6937_/S VGND VGND VPWR VPWR _6938_/A sky130_fd_sc_hd__mux2_4
X_6868_ _5015_/X _8475_/Q _6874_/S VGND VGND VPWR VPWR _6869_/A sky130_fd_sc_hd__mux2_4
XFILLER_22_374 VGND VGND VPWR VPWR sky130_fd_sc_hd__fill_1
XFILLER_50_672 VGND VGND VPWR VPWR sky130_fd_sc_hd__decap_3
XFILLER_50_694 VGND VGND VPWR VPWR sky130_fd_sc_hd__decap_3
X_8607_ _8688_/CLK _8607_/D load_slew572/X VGND VGND VPWR VPWR _8607_/Q sky130_fd_sc_hd__dfrtp_2
X_5819_ _5819_/A VGND VGND VPWR VPWR _7947_/D sky130_fd_sc_hd__buf_1
XFILLER_41_57 VGND VGND VPWR VPWR sky130_fd_sc_hd__decap_3
X_8538_ _8781_/CLK _8538_/D fanout749/A VGND VGND VPWR VPWR _8538_/Q sky130_fd_sc_hd__dfrtp_2
X_6799_ _8443_/Q _4878_/A _6807_/S VGND VGND VPWR VPWR _6800_/A sky130_fd_sc_hd__mux2_2
XFILLER_108_424 VGND VGND VPWR VPWR sky130_fd_sc_hd__decap_3
XTAP_TAPCELL_ROW_20_575 VGND VPWR sky130_fd_sc_hd__tapvpwrvgnd_1
XFILLER_135_221 VGND VGND VPWR VPWR sky130_fd_sc_hd__decap_3
XFILLER_135_243 VGND VGND VPWR VPWR sky130_fd_sc_hd__decap_3
X_8469_ _8721_/CLK _8469_/D fanout588/X VGND VGND VPWR VPWR _8469_/Q sky130_fd_sc_hd__dfrtp_2
XFILLER_135_265 VGND VGND VPWR VPWR sky130_fd_sc_hd__decap_3
XFILLER_2_713 VGND VGND VPWR VPWR sky130_fd_sc_hd__decap_3
XTAP_TAPCELL_ROW_79_1396 VGND VPWR sky130_fd_sc_hd__tapvpwrvgnd_1
XFILLER_2_746 VGND VGND VPWR VPWR sky130_fd_sc_hd__decap_3
XFILLER_2_757 VGND VGND VPWR VPWR sky130_fd_sc_hd__decap_3
XFILLER_89_330 VGND VGND VPWR VPWR sky130_fd_sc_hd__decap_3
XTAP_TAPCELL_ROW_92_1574 VGND VPWR sky130_fd_sc_hd__tapvpwrvgnd_1
XTAP_TAPCELL_ROW_92_1585 VGND VPWR sky130_fd_sc_hd__tapvpwrvgnd_1
XFILLER_104_696 VGND VGND VPWR VPWR sky130_fd_sc_hd__fill_1
XFILLER_131_482 VGND VGND VPWR VPWR sky130_fd_sc_hd__decap_3
XFILLER_1_278 VGND VGND VPWR VPWR sky130_fd_sc_hd__fill_2
XFILLER_2_18 VGND VGND VPWR VPWR sky130_fd_sc_hd__decap_3
XFILLER_2_29 VGND VGND VPWR VPWR sky130_fd_sc_hd__decap_3
XFILLER_89_396 VGND VGND VPWR VPWR sky130_fd_sc_hd__fill_1
XFILLER_103_195 VGND VGND VPWR VPWR sky130_fd_sc_hd__decap_3
XFILLER_66_32 VGND VGND VPWR VPWR sky130_fd_sc_hd__fill_1
XFILLER_66_54 VGND VGND VPWR VPWR sky130_fd_sc_hd__decap_3
XFILLER_17_146 VGND VGND VPWR VPWR sky130_fd_sc_hd__fill_1
XFILLER_45_455 VGND VGND VPWR VPWR sky130_fd_sc_hd__decap_3
XFILLER_73_753 VGND VGND VPWR VPWR sky130_fd_sc_hd__decap_3
XFILLER_32_105 VGND VGND VPWR VPWR sky130_fd_sc_hd__decap_3
XFILLER_33_617 VGND VGND VPWR VPWR sky130_fd_sc_hd__decap_3
XFILLER_60_414 VGND VGND VPWR VPWR sky130_fd_sc_hd__fill_2
XPHY_EDGE_ROW_72_Left_208 VGND VGND VPWR VPWR sky130_fd_sc_hd__decap_3
XTAP_TAPCELL_ROW_28_686 VGND VPWR sky130_fd_sc_hd__tapvpwrvgnd_1
XFILLER_41_661 VGND VGND VPWR VPWR sky130_fd_sc_hd__decap_3
XFILLER_41_694 VGND VGND VPWR VPWR sky130_fd_sc_hd__decap_3
XFILLER_9_323 VGND VGND VPWR VPWR sky130_fd_sc_hd__fill_1
XFILLER_127_700 VGND VGND VPWR VPWR sky130_fd_sc_hd__decap_3
XFILLER_127_744 VGND VGND VPWR VPWR sky130_fd_sc_hd__decap_3
XFILLER_127_777 VGND VGND VPWR VPWR sky130_fd_sc_hd__decap_3
XFILLER_114_427 VGND VGND VPWR VPWR sky130_fd_sc_hd__decap_3
XFILLER_126_276 VGND VGND VPWR VPWR sky130_fd_sc_hd__decap_3
XFILLER_127_788 VGND VGND VPWR VPWR sky130_fd_sc_hd__decap_3
XPHY_EDGE_ROW_81_Left_217 VGND VGND VPWR VPWR sky130_fd_sc_hd__decap_3
Xoutput119 _4224_/X VGND VGND VPWR VPWR rdata[39] sky130_fd_sc_hd__clkdlybuf4s25_1
Xoutput108 _4113_/X VGND VGND VPWR VPWR rdata[29] sky130_fd_sc_hd__clkdlybuf4s25_1
XFILLER_114_449 VGND VGND VPWR VPWR sky130_fd_sc_hd__decap_3
XFILLER_96_801 VGND VGND VPWR VPWR sky130_fd_sc_hd__decap_3
XTAP_TAPCELL_ROW_52_1024 VGND VPWR sky130_fd_sc_hd__tapvpwrvgnd_1
X_4150_ _8087_/Q _8168_/Q _4150_/S VGND VGND VPWR VPWR _4151_/B sky130_fd_sc_hd__mux2_2
XFILLER_110_611 VGND VGND VPWR VPWR sky130_fd_sc_hd__decap_3
XFILLER_122_471 VGND VGND VPWR VPWR sky130_fd_sc_hd__decap_3
XFILLER_95_333 VGND VGND VPWR VPWR sky130_fd_sc_hd__decap_3
Xoutput90 _3928_/X VGND VGND VPWR VPWR rdata[12] sky130_fd_sc_hd__clkdlybuf4s25_1
XFILLER_110_666 VGND VGND VPWR VPWR sky130_fd_sc_hd__decap_3
XFILLER_95_344 VGND VGND VPWR VPWR sky130_fd_sc_hd__decap_3
X_4081_ _8728_/Q _7503_/Q _4494_/S VGND VGND VPWR VPWR _4082_/B sky130_fd_sc_hd__mux2_2
XFILLER_55_219 VGND VGND VPWR VPWR sky130_fd_sc_hd__decap_3
XTAP_TAPCELL_ROW_108_1802 VGND VPWR sky130_fd_sc_hd__tapvpwrvgnd_1
XFILLER_48_282 VGND VGND VPWR VPWR sky130_fd_sc_hd__fill_2
XPHY_EDGE_ROW_90_Left_226 VGND VGND VPWR VPWR sky130_fd_sc_hd__decap_3
X_7840_ _8734_/CLK _7840_/D load_slew521/X VGND VGND VPWR VPWR _7840_/Q sky130_fd_sc_hd__dfrtp_2
XFILLER_36_477 VGND VGND VPWR VPWR sky130_fd_sc_hd__decap_3
XFILLER_91_561 VGND VGND VPWR VPWR sky130_fd_sc_hd__decap_3
XTAP_TAPCELL_ROW_47_951 VGND VPWR sky130_fd_sc_hd__tapvpwrvgnd_1
XFILLER_23_127 VGND VGND VPWR VPWR sky130_fd_sc_hd__decap_3
X_7771_ _8274_/CLK _7771_/D load_slew696/X VGND VGND VPWR VPWR _7771_/Q sky130_fd_sc_hd__dfrtp_2
X_4983_ _4983_/A VGND VGND VPWR VPWR _7566_/D sky130_fd_sc_hd__buf_1
X_3934_ _7652_/Q _3995_/B _4652_/B1 _7571_/Q VGND VGND VPWR VPWR _3934_/X sky130_fd_sc_hd__o22a_2
X_6722_ _6722_/A VGND VGND VPWR VPWR _8406_/D sky130_fd_sc_hd__buf_2
XFILLER_32_661 VGND VGND VPWR VPWR sky130_fd_sc_hd__fill_2
XTAP_TAPCELL_ROW_63_1175 VGND VPWR sky130_fd_sc_hd__tapvpwrvgnd_1
X_3865_ _3859_/X _3864_/X _3865_/S VGND VGND VPWR VPWR _3866_/A sky130_fd_sc_hd__mux2_2
X_6653_ _6653_/A VGND VGND VPWR VPWR _8375_/D sky130_fd_sc_hd__buf_2
X_5604_ _7846_/Q _4795_/A _5612_/S VGND VGND VPWR VPWR _5605_/A sky130_fd_sc_hd__mux2_2
XFILLER_118_733 VGND VGND VPWR VPWR sky130_fd_sc_hd__decap_3
XTAP_TAPCELL_ROW_119_1953 VGND VPWR sky130_fd_sc_hd__tapvpwrvgnd_1
X_3796_ _3827_/A1 _3794_/X _4666_/A1 VGND VGND VPWR VPWR _3796_/X sky130_fd_sc_hd__o21a_2
X_6584_ _6584_/A VGND VGND VPWR VPWR _8342_/D sky130_fd_sc_hd__buf_2
XFILLER_118_766 VGND VGND VPWR VPWR sky130_fd_sc_hd__decap_3
XFILLER_11_27 VGND VGND VPWR VPWR sky130_fd_sc_hd__decap_3
XTAP_TAPCELL_ROW_119_1964 VGND VPWR sky130_fd_sc_hd__tapvpwrvgnd_1
X_8323_ _8728_/CLK _8323_/D fanout580/X VGND VGND VPWR VPWR _8323_/Q sky130_fd_sc_hd__dfrtp_2
X_5535_ _7813_/Q _4999_/A _5549_/S VGND VGND VPWR VPWR _5536_/A sky130_fd_sc_hd__mux2_2
XFILLER_127_27 VGND VGND VPWR VPWR sky130_fd_sc_hd__decap_3
XFILLER_133_703 VGND VGND VPWR VPWR sky130_fd_sc_hd__decap_3
X_8254_ _8335_/CLK _8254_/D fanout540/X VGND VGND VPWR VPWR _8254_/Q sky130_fd_sc_hd__dfrtp_2
X_5466_ _7781_/Q _4860_/A _5482_/S VGND VGND VPWR VPWR _5467_/A sky130_fd_sc_hd__mux2_2
XFILLER_132_224 VGND VGND VPWR VPWR sky130_fd_sc_hd__decap_3
XFILLER_133_747 VGND VGND VPWR VPWR sky130_fd_sc_hd__decap_3
X_7205_ _7270_/A VGND VGND VPWR VPWR _7205_/X sky130_fd_sc_hd__clkbuf_1
X_4417_ _7776_/Q _7857_/Q _7938_/Q _8019_/Q _4449_/S _4450_/A VGND VGND VPWR VPWR
+ _4417_/X sky130_fd_sc_hd__mux4_2
XFILLER_132_268 VGND VGND VPWR VPWR sky130_fd_sc_hd__decap_3
XFILLER_99_650 VGND VGND VPWR VPWR sky130_fd_sc_hd__fill_1
Xfanout313 fanout314/X VGND VGND VPWR VPWR _4467_/A1 sky130_fd_sc_hd__clkdlybuf4s25_1
X_8185_ _8753_/CLK _8185_/D load_slew640/X VGND VGND VPWR VPWR _8185_/Q sky130_fd_sc_hd__dfrtp_2
X_5397_ _5397_/A VGND VGND VPWR VPWR _7748_/D sky130_fd_sc_hd__buf_1
Xfanout324 wire330/A VGND VGND VPWR VPWR _4456_/C1 sky130_fd_sc_hd__clkdlybuf4s25_1
Xfanout335 _4110_/S1 VGND VGND VPWR VPWR wire336/A sky130_fd_sc_hd__clkdlybuf4s25_1
Xfanout346 _4039_/S1 VGND VGND VPWR VPWR _4017_/S1 sky130_fd_sc_hd__clkdlybuf4s25_1
Xfanout357 _4013_/A1 VGND VGND VPWR VPWR _4496_/A1 sky130_fd_sc_hd__clkdlybuf4s25_1
X_7136_ _7136_/A VGND VGND VPWR VPWR _8601_/D sky130_fd_sc_hd__buf_2
X_4348_ _4364_/C1 _4342_/X _4347_/X VGND VGND VPWR VPWR _4348_/X sky130_fd_sc_hd__o21a_2
Xfanout368 fanout371/X VGND VGND VPWR VPWR _3742_/B_N sky130_fd_sc_hd__clkdlybuf4s25_1
Xfanout379 _8045_/Q VGND VGND VPWR VPWR _3849_/S1 sky130_fd_sc_hd__clkdlybuf4s25_1
X_7067_ _4727_/X hold971/X _7067_/S VGND VGND VPWR VPWR _7068_/A sky130_fd_sc_hd__mux2_1
X_4279_ _7684_/Q _4350_/A2 _4388_/B _7603_/Q _3791_/A VGND VGND VPWR VPWR _4279_/X
+ sky130_fd_sc_hd__o221a_2
XFILLER_100_176 VGND VGND VPWR VPWR sky130_fd_sc_hd__decap_3
XFILLER_46_208 VGND VGND VPWR VPWR sky130_fd_sc_hd__decap_3
XFILLER_86_377 VGND VGND VPWR VPWR sky130_fd_sc_hd__decap_3
XFILLER_86_399 VGND VGND VPWR VPWR sky130_fd_sc_hd__fill_1
XPHY_EDGE_ROW_129_Left_265 VGND VGND VPWR VPWR sky130_fd_sc_hd__decap_3
X_6018_ _8076_/Q _4690_/A _6032_/S VGND VGND VPWR VPWR _6019_/A sky130_fd_sc_hd__mux2_2
XFILLER_36_24 VGND VGND VPWR VPWR sky130_fd_sc_hd__decap_3
XFILLER_36_35 VGND VGND VPWR VPWR sky130_fd_sc_hd__decap_3
XFILLER_67_591 VGND VGND VPWR VPWR sky130_fd_sc_hd__decap_3
XFILLER_15_606 VGND VGND VPWR VPWR sky130_fd_sc_hd__fill_2
XFILLER_15_617 VGND VGND VPWR VPWR sky130_fd_sc_hd__fill_2
XFILLER_36_68 VGND VGND VPWR VPWR sky130_fd_sc_hd__fill_1
XFILLER_70_701 VGND VGND VPWR VPWR sky130_fd_sc_hd__fill_1
XFILLER_27_499 VGND VGND VPWR VPWR sky130_fd_sc_hd__fill_1
XFILLER_42_414 VGND VGND VPWR VPWR sky130_fd_sc_hd__decap_3
XFILLER_54_274 VGND VGND VPWR VPWR sky130_fd_sc_hd__decap_3
XFILLER_70_745 VGND VGND VPWR VPWR sky130_fd_sc_hd__fill_2
X_7969_ _8627_/CLK _7969_/D load_slew671/X VGND VGND VPWR VPWR _7969_/Q sky130_fd_sc_hd__dfrtp_2
XTAP_TAPCELL_ROW_25_645 VGND VPWR sky130_fd_sc_hd__tapvpwrvgnd_1
XFILLER_109_700 VGND VGND VPWR VPWR sky130_fd_sc_hd__decap_3
XFILLER_128_519 VGND VGND VPWR VPWR sky130_fd_sc_hd__decap_3
XFILLER_50_480 VGND VGND VPWR VPWR sky130_fd_sc_hd__fill_1
XFILLER_10_355 VGND VGND VPWR VPWR sky130_fd_sc_hd__fill_2
XFILLER_10_377 VGND VGND VPWR VPWR sky130_fd_sc_hd__decap_3
XFILLER_6_315 VGND VGND VPWR VPWR sky130_fd_sc_hd__decap_3
XFILLER_108_232 VGND VGND VPWR VPWR sky130_fd_sc_hd__decap_3
XFILLER_6_348 VGND VGND VPWR VPWR sky130_fd_sc_hd__decap_3
XTAP_TAPCELL_ROW_94_1603 VGND VPWR sky130_fd_sc_hd__tapvpwrvgnd_1
XTAP_TAPCELL_ROW_94_1614 VGND VPWR sky130_fd_sc_hd__tapvpwrvgnd_1
XFILLER_108_276 VGND VGND VPWR VPWR sky130_fd_sc_hd__decap_3
XFILLER_109_788 VGND VGND VPWR VPWR sky130_fd_sc_hd__fill_2
XFILLER_123_235 VGND VGND VPWR VPWR sky130_fd_sc_hd__fill_2
XFILLER_124_769 VGND VGND VPWR VPWR sky130_fd_sc_hd__fill_1
XFILLER_111_419 VGND VGND VPWR VPWR sky130_fd_sc_hd__decap_3
XFILLER_117_60 VGND VGND VPWR VPWR sky130_fd_sc_hd__decap_3
XFILLER_104_471 VGND VGND VPWR VPWR sky130_fd_sc_hd__decap_3
XFILLER_2_598 VGND VGND VPWR VPWR sky130_fd_sc_hd__decap_3
XFILLER_77_311 VGND VGND VPWR VPWR sky130_fd_sc_hd__decap_3
XFILLER_131_290 VGND VGND VPWR VPWR sky130_fd_sc_hd__decap_3
XFILLER_38_709 VGND VGND VPWR VPWR sky130_fd_sc_hd__fill_1
XFILLER_133_81 VGND VGND VPWR VPWR sky130_fd_sc_hd__decap_3
XFILLER_18_477 VGND VGND VPWR VPWR sky130_fd_sc_hd__decap_3
XFILLER_46_764 VGND VGND VPWR VPWR sky130_fd_sc_hd__fill_1
XFILLER_61_712 VGND VGND VPWR VPWR sky130_fd_sc_hd__decap_3
XFILLER_73_561 VGND VGND VPWR VPWR sky130_fd_sc_hd__decap_3
XFILLER_93_63 VGND VGND VPWR VPWR sky130_fd_sc_hd__fill_1
XFILLER_33_436 VGND VGND VPWR VPWR sky130_fd_sc_hd__decap_3
XFILLER_73_583 VGND VGND VPWR VPWR sky130_fd_sc_hd__decap_3
XFILLER_93_85 VGND VGND VPWR VPWR sky130_fd_sc_hd__fill_1
XTAP_TAPCELL_ROW_44_910 VGND VPWR sky130_fd_sc_hd__tapvpwrvgnd_1
XFILLER_33_458 VGND VGND VPWR VPWR sky130_fd_sc_hd__fill_1
XFILLER_61_756 VGND VGND VPWR VPWR sky130_fd_sc_hd__fill_2
XTAP_TAPCELL_ROW_103_1732 VGND VPWR sky130_fd_sc_hd__tapvpwrvgnd_1
XFILLER_119_508 VGND VGND VPWR VPWR sky130_fd_sc_hd__fill_2
XFILLER_13_193 VGND VGND VPWR VPWR sky130_fd_sc_hd__decap_3
XFILLER_9_175 VGND VGND VPWR VPWR sky130_fd_sc_hd__decap_3
XFILLER_127_541 VGND VGND VPWR VPWR sky130_fd_sc_hd__decap_3
XFILLER_127_585 VGND VGND VPWR VPWR sky130_fd_sc_hd__decap_3
XFILLER_54_3 VGND VGND VPWR VPWR sky130_fd_sc_hd__fill_1
XTAP_TAPCELL_ROW_132_2139 VGND VPWR sky130_fd_sc_hd__tapvpwrvgnd_1
X_5320_ _5320_/A VGND VGND VPWR VPWR _7712_/D sky130_fd_sc_hd__buf_1
XFILLER_114_213 VGND VGND VPWR VPWR sky130_fd_sc_hd__fill_1
X_5251_ _5251_/A VGND VGND VPWR VPWR _7679_/D sky130_fd_sc_hd__buf_1
XFILLER_114_257 VGND VGND VPWR VPWR sky130_fd_sc_hd__fill_2
XFILLER_114_268 VGND VGND VPWR VPWR sky130_fd_sc_hd__fill_1
XFILLER_130_728 VGND VGND VPWR VPWR sky130_fd_sc_hd__decap_3
XTAP_TAPCELL_ROW_114_1883 VGND VPWR sky130_fd_sc_hd__tapvpwrvgnd_1
X_4202_ _4313_/A1 _4196_/X _4201_/X VGND VGND VPWR VPWR _4202_/X sky130_fd_sc_hd__o21a_2
XFILLER_123_780 VGND VGND VPWR VPWR sky130_fd_sc_hd__decap_3
XFILLER_123_791 VGND VGND VPWR VPWR sky130_fd_sc_hd__fill_2
XTAP_TAPCELL_ROW_114_1894 VGND VPWR sky130_fd_sc_hd__tapvpwrvgnd_1
X_5182_ _7647_/Q _4981_/X _5184_/S VGND VGND VPWR VPWR _5183_/A sky130_fd_sc_hd__mux2_2
XFILLER_3_72 VGND VGND VPWR VPWR sky130_fd_sc_hd__decap_3
X_4133_ _8086_/Q _8167_/Q _4209_/S VGND VGND VPWR VPWR _4133_/X sky130_fd_sc_hd__mux2_2
XFILLER_56_528 VGND VGND VPWR VPWR sky130_fd_sc_hd__decap_3
XFILLER_68_377 VGND VGND VPWR VPWR sky130_fd_sc_hd__decap_3
XTAP_TAPCELL_ROW_3_329 VGND VPWR sky130_fd_sc_hd__tapvpwrvgnd_1
X_4064_ _8646_/Q _4326_/B VGND VGND VPWR VPWR _4064_/X sky130_fd_sc_hd__or2_2
XFILLER_113_29 VGND VGND VPWR VPWR sky130_fd_sc_hd__decap_3
XFILLER_83_347 VGND VGND VPWR VPWR sky130_fd_sc_hd__fill_1
XFILLER_95_196 VGND VGND VPWR VPWR sky130_fd_sc_hd__decap_3
XFILLER_37_753 VGND VGND VPWR VPWR sky130_fd_sc_hd__fill_2
XFILLER_64_550 VGND VGND VPWR VPWR sky130_fd_sc_hd__decap_3
XFILLER_64_561 VGND VGND VPWR VPWR sky130_fd_sc_hd__decap_3
XTAP_TAPCELL_ROW_65_1204 VGND VPWR sky130_fd_sc_hd__tapvpwrvgnd_1
XFILLER_36_263 VGND VGND VPWR VPWR sky130_fd_sc_hd__fill_1
XFILLER_51_200 VGND VGND VPWR VPWR sky130_fd_sc_hd__decap_3
X_7823_ _8724_/CLK _7823_/D load_slew503/X VGND VGND VPWR VPWR _7823_/Q sky130_fd_sc_hd__dfrtp_2
Xclkbuf_leaf_96_CLK clkbuf_leaf_99_CLK/A VGND VGND VPWR VPWR _8627_/CLK sky130_fd_sc_hd__clkbuf_8
X_7754_ _8732_/CLK _7754_/D fanout479/A VGND VGND VPWR VPWR _7754_/Q sky130_fd_sc_hd__dfrtp_2
XFILLER_11_119 VGND VGND VPWR VPWR sky130_fd_sc_hd__decap_3
XFILLER_51_277 VGND VGND VPWR VPWR sky130_fd_sc_hd__decap_3
XTAP_TAPCELL_ROW_22_604 VGND VPWR sky130_fd_sc_hd__tapvpwrvgnd_1
X_6705_ _8398_/Q _5030_/A _6723_/S VGND VGND VPWR VPWR _6706_/A sky130_fd_sc_hd__mux2_2
X_4966_ _4965_/X _7562_/Q _4986_/S VGND VGND VPWR VPWR _4967_/A sky130_fd_sc_hd__mux2_2
XFILLER_20_631 VGND VGND VPWR VPWR sky130_fd_sc_hd__decap_3
XFILLER_32_480 VGND VGND VPWR VPWR sky130_fd_sc_hd__decap_3
X_3917_ _7732_/Q _7813_/Q _3973_/S VGND VGND VPWR VPWR _3917_/X sky130_fd_sc_hd__mux2_2
X_7685_ _8586_/CLK _7685_/D fanout537/X VGND VGND VPWR VPWR _7685_/Q sky130_fd_sc_hd__dfrtp_2
X_4897_ _4897_/A VGND VGND VPWR VPWR _7546_/D sky130_fd_sc_hd__buf_1
XFILLER_125_9 VGND VGND VPWR VPWR sky130_fd_sc_hd__decap_3
XFILLER_22_26 VGND VGND VPWR VPWR sky130_fd_sc_hd__fill_2
X_3848_ _4117_/A VGND VGND VPWR VPWR _3848_/X sky130_fd_sc_hd__clkbuf_2
X_6636_ _4899_/X _8367_/Q _6654_/S VGND VGND VPWR VPWR _6637_/A sky130_fd_sc_hd__mux2_2
XFILLER_22_59 VGND VGND VPWR VPWR sky130_fd_sc_hd__decap_3
X_3779_ _3888_/A _3779_/B VGND VGND VPWR VPWR _3779_/X sky130_fd_sc_hd__or2_2
X_6567_ _6567_/A VGND VGND VPWR VPWR _8334_/D sky130_fd_sc_hd__buf_2
XFILLER_118_563 VGND VGND VPWR VPWR sky130_fd_sc_hd__decap_3
XFILLER_133_500 VGND VGND VPWR VPWR sky130_fd_sc_hd__decap_3
XFILLER_133_511 VGND VGND VPWR VPWR sky130_fd_sc_hd__decap_3
X_8306_ _8387_/CLK _8306_/D wire631/X VGND VGND VPWR VPWR _8306_/Q sky130_fd_sc_hd__dfrtp_2
X_5518_ _7805_/Q _4965_/A _5528_/S VGND VGND VPWR VPWR _5519_/A sky130_fd_sc_hd__mux2_2
XFILLER_106_747 VGND VGND VPWR VPWR sky130_fd_sc_hd__decap_3
XFILLER_133_544 VGND VGND VPWR VPWR sky130_fd_sc_hd__decap_3
XTAP_TAPCELL_ROW_76_1355 VGND VPWR sky130_fd_sc_hd__tapvpwrvgnd_1
X_6498_ _6498_/A VGND VGND VPWR VPWR _8301_/D sky130_fd_sc_hd__buf_2
X_8237_ _8729_/CLK _8237_/D wire476/X VGND VGND VPWR VPWR _8237_/Q sky130_fd_sc_hd__dfrtp_2
X_5449_ _7773_/Q _4828_/A _5461_/S VGND VGND VPWR VPWR _5450_/A sky130_fd_sc_hd__mux2_2
XFILLER_120_227 VGND VGND VPWR VPWR sky130_fd_sc_hd__decap_3
XFILLER_133_588 VGND VGND VPWR VPWR sky130_fd_sc_hd__decap_3
XFILLER_59_311 VGND VGND VPWR VPWR sky130_fd_sc_hd__fill_1
Xclkbuf_leaf_20_CLK clkbuf_5_9__f_CLK/X VGND VGND VPWR VPWR _8765_/CLK sky130_fd_sc_hd__clkbuf_8
X_8168_ _8335_/CLK _8168_/D fanout540/X VGND VGND VPWR VPWR _8168_/Q sky130_fd_sc_hd__dfrtp_2
XFILLER_113_290 VGND VGND VPWR VPWR sky130_fd_sc_hd__fill_2
XFILLER_59_333 VGND VGND VPWR VPWR sky130_fd_sc_hd__decap_3
XFILLER_86_141 VGND VGND VPWR VPWR sky130_fd_sc_hd__fill_1
X_7119_ _7119_/A VGND VGND VPWR VPWR _8593_/D sky130_fd_sc_hd__buf_2
XFILLER_101_452 VGND VGND VPWR VPWR sky130_fd_sc_hd__fill_2
XFILLER_47_23 VGND VGND VPWR VPWR sky130_fd_sc_hd__fill_1
XFILLER_59_388 VGND VGND VPWR VPWR sky130_fd_sc_hd__decap_3
XFILLER_86_174 VGND VGND VPWR VPWR sky130_fd_sc_hd__decap_3
X_8099_ _8747_/CLK _8099_/D wire631/X VGND VGND VPWR VPWR _8099_/Q sky130_fd_sc_hd__dfrtp_2
XFILLER_28_753 VGND VGND VPWR VPWR sky130_fd_sc_hd__decap_3
XFILLER_55_561 VGND VGND VPWR VPWR sky130_fd_sc_hd__decap_3
XFILLER_103_84 VGND VGND VPWR VPWR sky130_fd_sc_hd__fill_2
XFILLER_27_274 VGND VGND VPWR VPWR sky130_fd_sc_hd__decap_3
XFILLER_42_200 VGND VGND VPWR VPWR sky130_fd_sc_hd__fill_2
XFILLER_42_211 VGND VGND VPWR VPWR sky130_fd_sc_hd__decap_3
XFILLER_82_380 VGND VGND VPWR VPWR sky130_fd_sc_hd__decap_3
XFILLER_15_458 VGND VGND VPWR VPWR sky130_fd_sc_hd__decap_3
Xclkbuf_leaf_87_CLK clkbuf_leaf_88_CLK/A VGND VGND VPWR VPWR _8760_/CLK sky130_fd_sc_hd__clkbuf_8
XFILLER_11_620 VGND VGND VPWR VPWR sky130_fd_sc_hd__decap_3
XFILLER_23_491 VGND VGND VPWR VPWR sky130_fd_sc_hd__decap_3
XFILLER_7_602 VGND VGND VPWR VPWR sky130_fd_sc_hd__decap_3
XFILLER_109_530 VGND VGND VPWR VPWR sky130_fd_sc_hd__fill_1
XFILLER_10_185 VGND VGND VPWR VPWR sky130_fd_sc_hd__fill_1
XFILLER_11_697 VGND VGND VPWR VPWR sky130_fd_sc_hd__decap_3
XFILLER_7_635 VGND VGND VPWR VPWR sky130_fd_sc_hd__decap_3
Xwire555 wire555/A VGND VGND VPWR VPWR wire555/X sky130_fd_sc_hd__clkbuf_4
XFILLER_124_500 VGND VGND VPWR VPWR sky130_fd_sc_hd__decap_3
XFILLER_7_668 VGND VGND VPWR VPWR sky130_fd_sc_hd__decap_3
XFILLER_7_679 VGND VGND VPWR VPWR sky130_fd_sc_hd__decap_3
XFILLER_124_566 VGND VGND VPWR VPWR sky130_fd_sc_hd__decap_3
Xload_slew505 fanout504/X VGND VGND VPWR VPWR fanout502/A sky130_fd_sc_hd__buf_2
XFILLER_111_205 VGND VGND VPWR VPWR sky130_fd_sc_hd__decap_3
XFILLER_111_216 VGND VGND VPWR VPWR sky130_fd_sc_hd__fill_1
XFILLER_88_85 VGND VGND VPWR VPWR sky130_fd_sc_hd__decap_3
Xclkbuf_leaf_11_CLK clkload0/A VGND VGND VPWR VPWR _8649_/CLK sky130_fd_sc_hd__clkbuf_8
Xload_slew538 fanout537/X VGND VGND VPWR VPWR load_slew538/X sky130_fd_sc_hd__buf_2
XFILLER_111_238 VGND VGND VPWR VPWR sky130_fd_sc_hd__decap_3
XFILLER_111_249 VGND VGND VPWR VPWR sky130_fd_sc_hd__decap_3
XFILLER_19_6 VGND VGND VPWR VPWR sky130_fd_sc_hd__decap_3
XFILLER_78_675 VGND VGND VPWR VPWR sky130_fd_sc_hd__decap_3
XFILLER_78_697 VGND VGND VPWR VPWR sky130_fd_sc_hd__decap_3
XFILLER_38_539 VGND VGND VPWR VPWR sky130_fd_sc_hd__decap_3
XFILLER_77_196 VGND VGND VPWR VPWR sky130_fd_sc_hd__fill_1
XFILLER_34_701 VGND VGND VPWR VPWR sky130_fd_sc_hd__decap_3
XFILLER_92_144 VGND VGND VPWR VPWR sky130_fd_sc_hd__decap_3
XFILLER_18_296 VGND VGND VPWR VPWR sky130_fd_sc_hd__decap_3
XFILLER_33_222 VGND VGND VPWR VPWR sky130_fd_sc_hd__fill_2
XFILLER_61_542 VGND VGND VPWR VPWR sky130_fd_sc_hd__decap_3
X_4820_ _4819_/X _7528_/Q _4820_/S VGND VGND VPWR VPWR _4821_/A sky130_fd_sc_hd__mux2_2
XFILLER_21_417 VGND VGND VPWR VPWR sky130_fd_sc_hd__fill_1
XFILLER_33_277 VGND VGND VPWR VPWR sky130_fd_sc_hd__decap_3
Xclkbuf_leaf_78_CLK clkload10/A VGND VGND VPWR VPWR _8776_/CLK sky130_fd_sc_hd__clkbuf_8
XTAP_TAPCELL_ROW_60_1134 VGND VPWR sky130_fd_sc_hd__tapvpwrvgnd_1
X_4751_ _4751_/A VGND VGND VPWR VPWR _7511_/D sky130_fd_sc_hd__buf_1
X_7470_ _4981_/X _8791_/Q _7474_/S VGND VGND VPWR VPWR _7471_/A sky130_fd_sc_hd__mux2_2
X_4682_ _8377_/Q _4682_/A2 _3752_/X _8296_/Q _4682_/C1 VGND VGND VPWR VPWR _4682_/X
+ sky130_fd_sc_hd__o221a_2
X_6421_ _6484_/S VGND VGND VPWR VPWR _6440_/S sky130_fd_sc_hd__buf_6
XTAP_TAPCELL_ROW_116_1912 VGND VPWR sky130_fd_sc_hd__tapvpwrvgnd_1
XTAP_TAPCELL_ROW_116_1923 VGND VPWR sky130_fd_sc_hd__tapvpwrvgnd_1
XFILLER_108_29 VGND VGND VPWR VPWR sky130_fd_sc_hd__decap_3
XFILLER_127_393 VGND VGND VPWR VPWR sky130_fd_sc_hd__decap_3
XFILLER_6_690 VGND VGND VPWR VPWR sky130_fd_sc_hd__decap_3
X_6352_ _5019_/X _8233_/Q _6356_/S VGND VGND VPWR VPWR _6353_/A sky130_fd_sc_hd__mux2_2
X_6283_ _4883_/X _8201_/Q _6289_/S VGND VGND VPWR VPWR _6284_/A sky130_fd_sc_hd__mux2_4
X_5303_ _5303_/A VGND VGND VPWR VPWR _7704_/D sky130_fd_sc_hd__buf_1
XFILLER_115_588 VGND VGND VPWR VPWR sky130_fd_sc_hd__decap_3
XFILLER_130_525 VGND VGND VPWR VPWR sky130_fd_sc_hd__decap_3
XFILLER_130_536 VGND VGND VPWR VPWR sky130_fd_sc_hd__decap_3
XFILLER_88_417 VGND VGND VPWR VPWR sky130_fd_sc_hd__decap_3
X_8022_ _8759_/CLK _8022_/D fanout705/X VGND VGND VPWR VPWR _8022_/Q sky130_fd_sc_hd__dfrtp_2
X_5234_ _5234_/A VGND VGND VPWR VPWR _7671_/D sky130_fd_sc_hd__buf_1
XFILLER_130_569 VGND VGND VPWR VPWR sky130_fd_sc_hd__decap_3
X_5165_ _5333_/S VGND VGND VPWR VPWR _5184_/S sky130_fd_sc_hd__buf_2
XFILLER_29_517 VGND VGND VPWR VPWR sky130_fd_sc_hd__decap_3
XTAP_TAPCELL_ROW_71_1285 VGND VPWR sky130_fd_sc_hd__tapvpwrvgnd_1
X_4116_ _7750_/Q _7831_/Q _7912_/Q _7993_/Q _4124_/S _4125_/A VGND VGND VPWR VPWR
+ _4117_/B sky130_fd_sc_hd__mux4_2
XFILLER_111_794 VGND VGND VPWR VPWR sky130_fd_sc_hd__fill_2
XFILLER_56_347 VGND VGND VPWR VPWR sky130_fd_sc_hd__fill_2
XFILLER_68_174 VGND VGND VPWR VPWR sky130_fd_sc_hd__decap_3
XFILLER_83_122 VGND VGND VPWR VPWR sky130_fd_sc_hd__fill_1
XFILLER_84_645 VGND VGND VPWR VPWR sky130_fd_sc_hd__fill_2
X_5096_ _5096_/A VGND VGND VPWR VPWR _7607_/D sky130_fd_sc_hd__buf_1
XFILLER_17_15 VGND VGND VPWR VPWR sky130_fd_sc_hd__decap_3
XFILLER_25_701 VGND VGND VPWR VPWR sky130_fd_sc_hd__decap_3
XFILLER_37_561 VGND VGND VPWR VPWR sky130_fd_sc_hd__fill_2
XFILLER_56_358 VGND VGND VPWR VPWR sky130_fd_sc_hd__decap_3
X_4047_ _8401_/Q _8482_/Q _8563_/Q _8644_/Q _4091_/S0 _4091_/S1 VGND VGND VPWR VPWR
+ _4047_/X sky130_fd_sc_hd__mux4_2
XFILLER_17_48 VGND VGND VPWR VPWR sky130_fd_sc_hd__decap_3
XFILLER_24_200 VGND VGND VPWR VPWR sky130_fd_sc_hd__decap_3
XFILLER_52_520 VGND VGND VPWR VPWR sky130_fd_sc_hd__decap_3
XFILLER_83_177 VGND VGND VPWR VPWR sky130_fd_sc_hd__decap_3
X_7806_ _8710_/CLK _7806_/D load_slew663/X VGND VGND VPWR VPWR _7806_/Q sky130_fd_sc_hd__dfrtp_2
XFILLER_52_575 VGND VGND VPWR VPWR sky130_fd_sc_hd__fill_1
XTAP_TAPCELL_ROW_35_784 VGND VPWR sky130_fd_sc_hd__tapvpwrvgnd_1
X_8786_ _8786_/CLK _8786_/D wire669/X VGND VGND VPWR VPWR _8786_/Q sky130_fd_sc_hd__dfrtp_2
Xclkbuf_leaf_69_CLK clkbuf_leaf_75_CLK/A VGND VGND VPWR VPWR _8450_/CLK sky130_fd_sc_hd__clkbuf_8
X_5998_ _5998_/A VGND VGND VPWR VPWR _8066_/D sky130_fd_sc_hd__buf_1
X_7737_ _8639_/CLK _7737_/D fanout604/X VGND VGND VPWR VPWR _7737_/Q sky130_fd_sc_hd__dfrtp_2
X_4949_ _4945_/X _7558_/Q _4986_/S VGND VGND VPWR VPWR _4950_/A sky130_fd_sc_hd__mux2_2
XFILLER_33_69 VGND VGND VPWR VPWR sky130_fd_sc_hd__decap_3
X_7668_ _8569_/CLK _7668_/D fanout495/X VGND VGND VPWR VPWR _7668_/Q sky130_fd_sc_hd__dfrtp_2
X_6619_ _4866_/X _8359_/Q _6633_/S VGND VGND VPWR VPWR _6620_/A sky130_fd_sc_hd__mux2_2
XFILLER_4_616 VGND VGND VPWR VPWR sky130_fd_sc_hd__decap_3
X_7599_ _8743_/CLK _7599_/D fanout520/X VGND VGND VPWR VPWR _7599_/Q sky130_fd_sc_hd__dfrtp_2
XFILLER_106_533 VGND VGND VPWR VPWR sky130_fd_sc_hd__decap_3
XFILLER_118_371 VGND VGND VPWR VPWR sky130_fd_sc_hd__fill_2
XFILLER_106_566 VGND VGND VPWR VPWR sky130_fd_sc_hd__decap_3
XFILLER_133_352 VGND VGND VPWR VPWR sky130_fd_sc_hd__decap_3
XFILLER_0_800 VGND VGND VPWR VPWR sky130_fd_sc_hd__decap_3
XFILLER_121_503 VGND VGND VPWR VPWR sky130_fd_sc_hd__fill_1
XFILLER_121_525 VGND VGND VPWR VPWR sky130_fd_sc_hd__decap_3
XFILLER_133_385 VGND VGND VPWR VPWR sky130_fd_sc_hd__decap_3
XFILLER_79_417 VGND VGND VPWR VPWR sky130_fd_sc_hd__decap_3
XFILLER_133_396 VGND VGND VPWR VPWR sky130_fd_sc_hd__decap_3
XFILLER_59_130 VGND VGND VPWR VPWR sky130_fd_sc_hd__fill_2
XFILLER_58_77 VGND VGND VPWR VPWR sky130_fd_sc_hd__decap_3
XFILLER_58_88 VGND VGND VPWR VPWR sky130_fd_sc_hd__fill_2
XFILLER_74_122 VGND VGND VPWR VPWR sky130_fd_sc_hd__decap_3
XFILLER_75_623 VGND VGND VPWR VPWR sky130_fd_sc_hd__decap_3
XTAP_TAPCELL_ROW_89_1535 VGND VPWR sky130_fd_sc_hd__tapvpwrvgnd_1
XFILLER_16_701 VGND VGND VPWR VPWR sky130_fd_sc_hd__decap_3
XFILLER_74_32 VGND VGND VPWR VPWR sky130_fd_sc_hd__decap_3
XFILLER_90_604 VGND VGND VPWR VPWR sky130_fd_sc_hd__decap_3
XFILLER_15_222 VGND VGND VPWR VPWR sky130_fd_sc_hd__fill_2
XFILLER_15_233 VGND VGND VPWR VPWR sky130_fd_sc_hd__fill_1
XFILLER_130_71 VGND VGND VPWR VPWR sky130_fd_sc_hd__decap_3
XFILLER_30_203 VGND VGND VPWR VPWR sky130_fd_sc_hd__decap_3
XFILLER_43_564 VGND VGND VPWR VPWR sky130_fd_sc_hd__decap_3
Xclkbuf_5_6__f_CLK clkbuf_4_3_0_CLK/X VGND VGND VPWR VPWR clkbuf_5_6__f_CLK/X sky130_fd_sc_hd__clkbuf_16
XFILLER_30_225 VGND VGND VPWR VPWR sky130_fd_sc_hd__decap_3
XFILLER_90_53 VGND VGND VPWR VPWR sky130_fd_sc_hd__decap_3
Xclkbuf_leaf_0_CLK clkbuf_leaf_1_CLK/A VGND VGND VPWR VPWR _8733_/CLK sky130_fd_sc_hd__clkbuf_8
XFILLER_129_603 VGND VGND VPWR VPWR sky130_fd_sc_hd__decap_3
XFILLER_128_124 VGND VGND VPWR VPWR sky130_fd_sc_hd__decap_3
XFILLER_129_647 VGND VGND VPWR VPWR sky130_fd_sc_hd__decap_3
XFILLER_23_91 VGND VGND VPWR VPWR sky130_fd_sc_hd__decap_3
XFILLER_7_421 VGND VGND VPWR VPWR sky130_fd_sc_hd__decap_3
XTAP_TAPCELL_ROW_13_478 VGND VPWR sky130_fd_sc_hd__tapvpwrvgnd_1
Xwire330 wire330/A VGND VGND VPWR VPWR _4672_/S sky130_fd_sc_hd__clkbuf_4
XFILLER_128_168 VGND VGND VPWR VPWR sky130_fd_sc_hd__decap_3
XFILLER_109_382 VGND VGND VPWR VPWR sky130_fd_sc_hd__decap_3
XFILLER_109_393 VGND VGND VPWR VPWR sky130_fd_sc_hd__decap_3
XFILLER_7_487 VGND VGND VPWR VPWR sky130_fd_sc_hd__decap_3
XFILLER_124_374 VGND VGND VPWR VPWR sky130_fd_sc_hd__fill_1
XFILLER_3_671 VGND VGND VPWR VPWR sky130_fd_sc_hd__fill_1
XFILLER_3_682 VGND VGND VPWR VPWR sky130_fd_sc_hd__decap_3
XFILLER_97_225 VGND VGND VPWR VPWR sky130_fd_sc_hd__decap_3
XFILLER_98_737 VGND VGND VPWR VPWR sky130_fd_sc_hd__fill_2
XFILLER_98_748 VGND VGND VPWR VPWR sky130_fd_sc_hd__decap_3
XFILLER_112_536 VGND VGND VPWR VPWR sky130_fd_sc_hd__fill_1
XTAP_TAPCELL_ROW_111_1842 VGND VPWR sky130_fd_sc_hd__tapvpwrvgnd_1
XTAP_TAPCELL_ROW_111_1853 VGND VPWR sky130_fd_sc_hd__tapvpwrvgnd_1
XFILLER_17_3 VGND VGND VPWR VPWR sky130_fd_sc_hd__decap_3
XFILLER_66_645 VGND VGND VPWR VPWR sky130_fd_sc_hd__decap_3
XFILLER_66_678 VGND VGND VPWR VPWR sky130_fd_sc_hd__decap_3
X_6970_ _6970_/A VGND VGND VPWR VPWR _8523_/D sky130_fd_sc_hd__buf_6
XFILLER_19_561 VGND VGND VPWR VPWR sky130_fd_sc_hd__decap_3
XFILLER_53_328 VGND VGND VPWR VPWR sky130_fd_sc_hd__decap_3
XFILLER_81_626 VGND VGND VPWR VPWR sky130_fd_sc_hd__fill_2
X_5921_ _5947_/A VGND VGND VPWR VPWR _5921_/X sky130_fd_sc_hd__clkbuf_1
XFILLER_34_542 VGND VGND VPWR VPWR sky130_fd_sc_hd__fill_2
XFILLER_80_147 VGND VGND VPWR VPWR sky130_fd_sc_hd__fill_2
XFILLER_81_659 VGND VGND VPWR VPWR sky130_fd_sc_hd__decap_3
XFILLER_22_704 VGND VGND VPWR VPWR sky130_fd_sc_hd__decap_3
XFILLER_34_564 VGND VGND VPWR VPWR sky130_fd_sc_hd__fill_2
X_8640_ _8802_/CLK _8640_/D fanout578/X VGND VGND VPWR VPWR _8640_/Q sky130_fd_sc_hd__dfrtp_2
X_5852_ _5907_/A VGND VGND VPWR VPWR _5852_/X sky130_fd_sc_hd__clkbuf_1
XFILLER_21_225 VGND VGND VPWR VPWR sky130_fd_sc_hd__decap_3
X_8571_ _8733_/CLK _8571_/D fanout485/X VGND VGND VPWR VPWR _8571_/Q sky130_fd_sc_hd__dfrtp_2
X_5783_ _5783_/A VGND VGND VPWR VPWR _7930_/D sky130_fd_sc_hd__buf_1
X_4803_ _4803_/A VGND VGND VPWR VPWR _4803_/X sky130_fd_sc_hd__buf_1
XFILLER_9_60 VGND VGND VPWR VPWR sky130_fd_sc_hd__decap_3
XTAP_TAPCELL_ROW_32_743 VGND VPWR sky130_fd_sc_hd__tapvpwrvgnd_1
X_7522_ _8624_/CLK _7522_/D load_slew647/X VGND VGND VPWR VPWR _7522_/Q sky130_fd_sc_hd__dfrtp_2
X_4734_ _4734_/A _4734_/B VGND VGND VPWR VPWR _4735_/A sky130_fd_sc_hd__and2_2
XFILLER_30_781 VGND VGND VPWR VPWR sky130_fd_sc_hd__fill_2
XFILLER_9_93 VGND VGND VPWR VPWR sky130_fd_sc_hd__decap_3
XFILLER_119_39 VGND VGND VPWR VPWR sky130_fd_sc_hd__decap_3
XFILLER_135_628 VGND VGND VPWR VPWR sky130_fd_sc_hd__decap_3
X_7453_ _4945_/X _8783_/Q _7453_/S VGND VGND VPWR VPWR _7454_/A sky130_fd_sc_hd__mux2_2
X_4665_ wire326/X _4661_/X _4664_/X _4665_/C1 VGND VGND VPWR VPWR _4665_/X sky130_fd_sc_hd__a211o_2
XFILLER_134_127 VGND VGND VPWR VPWR sky130_fd_sc_hd__decap_3
Xhold900 _8650_/Q VGND VGND VPWR VPWR hold900/X sky130_fd_sc_hd__dlygate4sd3_1
Xhold911 _8682_/Q VGND VGND VPWR VPWR hold911/X sky130_fd_sc_hd__dlygate4sd3_1
Xhold922 _8585_/Q VGND VGND VPWR VPWR hold922/X sky130_fd_sc_hd__dlygate4sd3_1
X_7384_ _8750_/Q _4806_/A _7386_/S VGND VGND VPWR VPWR _7385_/A sky130_fd_sc_hd__mux2_2
X_6404_ _6404_/A VGND VGND VPWR VPWR _8257_/D sky130_fd_sc_hd__buf_2
X_4596_ _8775_/Q _7550_/Q _4630_/S VGND VGND VPWR VPWR _4596_/X sky130_fd_sc_hd__mux2_2
XFILLER_115_352 VGND VGND VPWR VPWR sky130_fd_sc_hd__fill_1
XFILLER_127_190 VGND VGND VPWR VPWR sky130_fd_sc_hd__decap_3
XTAP_TAPCELL_ROW_73_1314 VGND VPWR sky130_fd_sc_hd__tapvpwrvgnd_1
Xhold933 _8258_/Q VGND VGND VPWR VPWR hold933/X sky130_fd_sc_hd__dlygate4sd3_1
Xhold944 _8227_/Q VGND VGND VPWR VPWR hold944/X sky130_fd_sc_hd__dlygate4sd3_1
Xhold955 _8790_/Q VGND VGND VPWR VPWR hold955/X sky130_fd_sc_hd__dlygate4sd3_1
X_6335_ _4985_/X _8225_/Q _6335_/S VGND VGND VPWR VPWR _6336_/A sky130_fd_sc_hd__mux2_2
XFILLER_103_503 VGND VGND VPWR VPWR sky130_fd_sc_hd__fill_1
XFILLER_115_385 VGND VGND VPWR VPWR sky130_fd_sc_hd__decap_3
XFILLER_135_27 VGND VGND VPWR VPWR sky130_fd_sc_hd__fill_1
XFILLER_135_38 VGND VGND VPWR VPWR sky130_fd_sc_hd__decap_3
Xhold966 _8553_/Q VGND VGND VPWR VPWR hold966/X sky130_fd_sc_hd__dlygate4sd3_1
Xhold977 _7576_/Q VGND VGND VPWR VPWR hold977/X sky130_fd_sc_hd__dlygate4sd3_1
Xhold988 _8796_/Q VGND VGND VPWR VPWR hold988/X sky130_fd_sc_hd__dlygate4sd3_1
Xhold999 _7962_/Q VGND VGND VPWR VPWR hold999/X sky130_fd_sc_hd__dlygate4sd3_1
X_8005_ _8744_/CLK _8005_/D load_slew626/X VGND VGND VPWR VPWR _8005_/Q sky130_fd_sc_hd__dfrtp_2
X_6266_ _4849_/X _8193_/Q _6268_/S VGND VGND VPWR VPWR _6267_/A sky130_fd_sc_hd__mux2_4
XFILLER_57_601 VGND VGND VPWR VPWR sky130_fd_sc_hd__decap_3
X_6197_ _4711_/X _8160_/Q _6205_/S VGND VGND VPWR VPWR _6198_/A sky130_fd_sc_hd__mux2_4
X_5217_ _5217_/A VGND VGND VPWR VPWR _7663_/D sky130_fd_sc_hd__buf_1
XFILLER_130_388 VGND VGND VPWR VPWR sky130_fd_sc_hd__decap_3
XFILLER_28_47 VGND VGND VPWR VPWR sky130_fd_sc_hd__decap_3
XFILLER_29_314 VGND VGND VPWR VPWR sky130_fd_sc_hd__decap_3
XFILLER_29_325 VGND VGND VPWR VPWR sky130_fd_sc_hd__decap_3
X_5148_ _4917_/X _5148_/A1 _5158_/S VGND VGND VPWR VPWR _5149_/A sky130_fd_sc_hd__mux2_2
XFILLER_29_369 VGND VGND VPWR VPWR sky130_fd_sc_hd__fill_2
X_5079_ _4777_/X _7599_/Q _5095_/S VGND VGND VPWR VPWR _5080_/A sky130_fd_sc_hd__mux2_2
XFILLER_44_339 VGND VGND VPWR VPWR sky130_fd_sc_hd__fill_2
XFILLER_12_203 VGND VGND VPWR VPWR sky130_fd_sc_hd__decap_3
XFILLER_71_169 VGND VGND VPWR VPWR sky130_fd_sc_hd__fill_1
XTAP_TAPCELL_ROW_84_1465 VGND VPWR sky130_fd_sc_hd__tapvpwrvgnd_1
XFILLER_13_759 VGND VGND VPWR VPWR sky130_fd_sc_hd__decap_3
X_8769_ _8769_/CLK _8769_/D fanout553/X VGND VGND VPWR VPWR _8769_/Q sky130_fd_sc_hd__dfrtp_2
XFILLER_100_85 VGND VGND VPWR VPWR sky130_fd_sc_hd__decap_3
XFILLER_40_589 VGND VGND VPWR VPWR sky130_fd_sc_hd__fill_1
XFILLER_20_280 VGND VGND VPWR VPWR sky130_fd_sc_hd__decap_3
XTAP_TAPCELL_ROW_10_426 VGND VPWR sky130_fd_sc_hd__tapvpwrvgnd_1
XTAP_TAPCELL_ROW_10_437 VGND VPWR sky130_fd_sc_hd__tapvpwrvgnd_1
XFILLER_125_116 VGND VGND VPWR VPWR sky130_fd_sc_hd__decap_3
XFILLER_5_18 VGND VGND VPWR VPWR sky130_fd_sc_hd__decap_3
XFILLER_69_32 VGND VGND VPWR VPWR sky130_fd_sc_hd__decap_3
XFILLER_134_672 VGND VGND VPWR VPWR sky130_fd_sc_hd__decap_3
XFILLER_79_203 VGND VGND VPWR VPWR sky130_fd_sc_hd__decap_3
XFILLER_133_193 VGND VGND VPWR VPWR sky130_fd_sc_hd__decap_3
XFILLER_79_225 VGND VGND VPWR VPWR sky130_fd_sc_hd__decap_3
XFILLER_79_258 VGND VGND VPWR VPWR sky130_fd_sc_hd__fill_1
XFILLER_0_663 VGND VGND VPWR VPWR sky130_fd_sc_hd__decap_3
XFILLER_95_729 VGND VGND VPWR VPWR sky130_fd_sc_hd__decap_3
XFILLER_0_685 VGND VGND VPWR VPWR sky130_fd_sc_hd__decap_3
XFILLER_121_399 VGND VGND VPWR VPWR sky130_fd_sc_hd__decap_3
XFILLER_125_93 VGND VGND VPWR VPWR sky130_fd_sc_hd__decap_3
XFILLER_47_111 VGND VGND VPWR VPWR sky130_fd_sc_hd__fill_1
XFILLER_88_781 VGND VGND VPWR VPWR sky130_fd_sc_hd__fill_2
XFILLER_18_80 VGND VGND VPWR VPWR sky130_fd_sc_hd__decap_3
XTAP_TAPCELL_ROW_126_2060 VGND VPWR sky130_fd_sc_hd__tapvpwrvgnd_1
XFILLER_90_456 VGND VGND VPWR VPWR sky130_fd_sc_hd__decap_3
XTAP_TAPCELL_ROW_18_548 VGND VPWR sky130_fd_sc_hd__tapvpwrvgnd_1
XFILLER_31_501 VGND VGND VPWR VPWR sky130_fd_sc_hd__decap_3
XFILLER_50_309 VGND VGND VPWR VPWR sky130_fd_sc_hd__decap_3
XFILLER_16_586 VGND VGND VPWR VPWR sky130_fd_sc_hd__fill_2
XFILLER_43_383 VGND VGND VPWR VPWR sky130_fd_sc_hd__decap_3
XFILLER_129_411 VGND VGND VPWR VPWR sky130_fd_sc_hd__decap_3
XFILLER_31_567 VGND VGND VPWR VPWR sky130_fd_sc_hd__decap_3
XFILLER_129_444 VGND VGND VPWR VPWR sky130_fd_sc_hd__decap_3
XFILLER_12_781 VGND VGND VPWR VPWR sky130_fd_sc_hd__decap_3
XFILLER_117_617 VGND VGND VPWR VPWR sky130_fd_sc_hd__decap_3
XFILLER_129_455 VGND VGND VPWR VPWR sky130_fd_sc_hd__decap_3
XFILLER_8_752 VGND VGND VPWR VPWR sky130_fd_sc_hd__decap_3
XFILLER_8_763 VGND VGND VPWR VPWR sky130_fd_sc_hd__decap_3
XFILLER_116_127 VGND VGND VPWR VPWR sky130_fd_sc_hd__fill_1
XFILLER_129_488 VGND VGND VPWR VPWR sky130_fd_sc_hd__decap_3
XFILLER_7_251 VGND VGND VPWR VPWR sky130_fd_sc_hd__decap_3
XFILLER_8_796 VGND VGND VPWR VPWR sky130_fd_sc_hd__decap_3
X_4450_ _4450_/A _4450_/B VGND VGND VPWR VPWR _4450_/X sky130_fd_sc_hd__or2_2
XFILLER_116_149 VGND VGND VPWR VPWR sky130_fd_sc_hd__decap_3
X_4381_ _8350_/Q _3767_/A _3817_/A _8269_/Q _4590_/S VGND VGND VPWR VPWR _4381_/X
+ sky130_fd_sc_hd__o221a_2
XFILLER_112_300 VGND VGND VPWR VPWR sky130_fd_sc_hd__decap_3
XFILLER_131_108 VGND VGND VPWR VPWR sky130_fd_sc_hd__decap_3
XFILLER_131_119 VGND VGND VPWR VPWR sky130_fd_sc_hd__decap_3
X_6120_ _6120_/A VGND VGND VPWR VPWR _8124_/D sky130_fd_sc_hd__buf_1
XFILLER_112_333 VGND VGND VPWR VPWR sky130_fd_sc_hd__fill_2
XFILLER_112_344 VGND VGND VPWR VPWR sky130_fd_sc_hd__decap_3
XFILLER_3_490 VGND VGND VPWR VPWR sky130_fd_sc_hd__fill_2
XFILLER_86_707 VGND VGND VPWR VPWR sky130_fd_sc_hd__decap_3
XTAP_TAPCELL_ROW_55_1066 VGND VPWR sky130_fd_sc_hd__tapvpwrvgnd_1
Xfanout709 fanout716/X VGND VGND VPWR VPWR fanout709/X sky130_fd_sc_hd__clkdlybuf4s25_1
XFILLER_112_377 VGND VGND VPWR VPWR sky130_fd_sc_hd__decap_3
XFILLER_86_729 VGND VGND VPWR VPWR sky130_fd_sc_hd__fill_1
XFILLER_98_567 VGND VGND VPWR VPWR sky130_fd_sc_hd__decap_3
X_6051_ _8092_/Q _4764_/A _6053_/S VGND VGND VPWR VPWR _6052_/A sky130_fd_sc_hd__mux2_2
XFILLER_100_539 VGND VGND VPWR VPWR sky130_fd_sc_hd__fill_1
XFILLER_85_228 VGND VGND VPWR VPWR sky130_fd_sc_hd__decap_3
XFILLER_85_239 VGND VGND VPWR VPWR sky130_fd_sc_hd__decap_3
X_5002_ input7/X _5026_/B VGND VGND VPWR VPWR _5003_/A sky130_fd_sc_hd__and2_2
XFILLER_38_144 VGND VGND VPWR VPWR sky130_fd_sc_hd__fill_1
XFILLER_66_464 VGND VGND VPWR VPWR sky130_fd_sc_hd__decap_3
XFILLER_94_773 VGND VGND VPWR VPWR sky130_fd_sc_hd__decap_3
XFILLER_66_497 VGND VGND VPWR VPWR sky130_fd_sc_hd__fill_1
XFILLER_93_261 VGND VGND VPWR VPWR sky130_fd_sc_hd__decap_3
XTAP_TAPCELL_ROW_37_813 VGND VPWR sky130_fd_sc_hd__tapvpwrvgnd_1
XFILLER_19_391 VGND VGND VPWR VPWR sky130_fd_sc_hd__fill_1
XFILLER_54_648 VGND VGND VPWR VPWR sky130_fd_sc_hd__decap_3
X_6953_ _6953_/A VGND VGND VPWR VPWR _8515_/D sky130_fd_sc_hd__buf_6
XFILLER_34_361 VGND VGND VPWR VPWR sky130_fd_sc_hd__decap_3
XFILLER_53_169 VGND VGND VPWR VPWR sky130_fd_sc_hd__decap_3
XFILLER_62_670 VGND VGND VPWR VPWR sky130_fd_sc_hd__decap_3
XFILLER_81_489 VGND VGND VPWR VPWR sky130_fd_sc_hd__decap_3
X_6884_ _6884_/A VGND VGND VPWR VPWR _8482_/D sky130_fd_sc_hd__buf_6
X_5904_ _5906_/A1 _5906_/A2 _4761_/X _5906_/B1 hold828/X VGND VGND VPWR VPWR _8000_/D
+ sky130_fd_sc_hd__a32o_2
XFILLER_14_27 VGND VGND VPWR VPWR sky130_fd_sc_hd__fill_1
X_8623_ _8623_/CLK _8623_/D load_slew678/X VGND VGND VPWR VPWR _8623_/Q sky130_fd_sc_hd__dfrtp_2
X_5835_ _7955_/Q _4913_/A _5847_/S VGND VGND VPWR VPWR _5836_/A sky130_fd_sc_hd__mux2_2
XFILLER_10_707 VGND VGND VPWR VPWR sky130_fd_sc_hd__decap_3
XFILLER_14_38 VGND VGND VPWR VPWR sky130_fd_sc_hd__decap_3
XFILLER_61_191 VGND VGND VPWR VPWR sky130_fd_sc_hd__decap_3
XFILLER_22_589 VGND VGND VPWR VPWR sky130_fd_sc_hd__decap_3
XPHY_EDGE_ROW_101_Left_237 VGND VGND VPWR VPWR sky130_fd_sc_hd__decap_3
X_8554_ _8634_/CLK _8554_/D fanout604/X VGND VGND VPWR VPWR _8554_/Q sky130_fd_sc_hd__dfrtp_2
X_5766_ _7922_/Q _4773_/A _5784_/S VGND VGND VPWR VPWR _5767_/A sky130_fd_sc_hd__mux2_2
X_8485_ _8647_/CLK _8485_/D fanout534/X VGND VGND VPWR VPWR _8485_/Q sky130_fd_sc_hd__dfrtp_2
X_7505_ _8657_/CLK _7505_/D load_slew513/X VGND VGND VPWR VPWR _7505_/Q sky130_fd_sc_hd__dfrtp_2
X_5697_ _5697_/A VGND VGND VPWR VPWR _7889_/D sky130_fd_sc_hd__buf_1
X_4717_ _4717_/A VGND VGND VPWR VPWR _7503_/D sky130_fd_sc_hd__buf_1
XFILLER_107_116 VGND VGND VPWR VPWR sky130_fd_sc_hd__fill_1
XFILLER_30_15 VGND VGND VPWR VPWR sky130_fd_sc_hd__decap_3
X_7436_ _7436_/A VGND VGND VPWR VPWR _8774_/D sky130_fd_sc_hd__buf_1
X_4648_ _7716_/Q _3995_/B _4648_/B1 _7635_/Q _3819_/X VGND VGND VPWR VPWR _4648_/X
+ sky130_fd_sc_hd__o221a_2
XFILLER_107_138 VGND VGND VPWR VPWR sky130_fd_sc_hd__decap_3
XFILLER_135_447 VGND VGND VPWR VPWR sky130_fd_sc_hd__fill_1
XFILLER_89_523 VGND VGND VPWR VPWR sky130_fd_sc_hd__fill_2
Xhold763 _7981_/Q VGND VGND VPWR VPWR hold763/X sky130_fd_sc_hd__dlygate4sd3_1
X_7367_ _7451_/S VGND VGND VPWR VPWR _7386_/S sky130_fd_sc_hd__clkbuf_2
X_4579_ _7791_/Q _7872_/Q _4579_/S VGND VGND VPWR VPWR _4579_/X sky130_fd_sc_hd__mux2_2
XFILLER_131_620 VGND VGND VPWR VPWR sky130_fd_sc_hd__decap_3
XFILLER_1_449 VGND VGND VPWR VPWR sky130_fd_sc_hd__fill_1
XFILLER_89_556 VGND VGND VPWR VPWR sky130_fd_sc_hd__decap_3
Xhold774 _7987_/Q VGND VGND VPWR VPWR hold774/X sky130_fd_sc_hd__dlygate4sd3_1
Xhold785 _8635_/Q VGND VGND VPWR VPWR hold785/X sky130_fd_sc_hd__dlygate4sd3_1
Xhold796 _8690_/Q VGND VGND VPWR VPWR hold796/X sky130_fd_sc_hd__dlygate4sd3_1
X_7298_ _8709_/Q _4976_/A _7302_/S VGND VGND VPWR VPWR _7299_/A sky130_fd_sc_hd__mux2_2
X_6318_ _6318_/A VGND VGND VPWR VPWR _8216_/D sky130_fd_sc_hd__buf_2
XFILLER_130_130 VGND VGND VPWR VPWR sky130_fd_sc_hd__decap_3
XFILLER_130_141 VGND VGND VPWR VPWR sky130_fd_sc_hd__decap_3
XFILLER_131_653 VGND VGND VPWR VPWR sky130_fd_sc_hd__decap_3
XFILLER_39_57 VGND VGND VPWR VPWR sky130_fd_sc_hd__decap_3
XFILLER_76_206 VGND VGND VPWR VPWR sky130_fd_sc_hd__decap_3
XFILLER_77_729 VGND VGND VPWR VPWR sky130_fd_sc_hd__decap_3
XFILLER_89_567 VGND VGND VPWR VPWR sky130_fd_sc_hd__decap_3
X_6249_ _6312_/S VGND VGND VPWR VPWR _6268_/S sky130_fd_sc_hd__buf_6
XFILLER_130_174 VGND VGND VPWR VPWR sky130_fd_sc_hd__decap_3
XFILLER_131_697 VGND VGND VPWR VPWR sky130_fd_sc_hd__decap_3
XPHY_EDGE_ROW_110_Left_246 VGND VGND VPWR VPWR sky130_fd_sc_hd__decap_3
XFILLER_45_604 VGND VGND VPWR VPWR sky130_fd_sc_hd__decap_3
XFILLER_45_626 VGND VGND VPWR VPWR sky130_fd_sc_hd__decap_3
XFILLER_57_486 VGND VGND VPWR VPWR sky130_fd_sc_hd__fill_2
XFILLER_57_497 VGND VGND VPWR VPWR sky130_fd_sc_hd__decap_3
XFILLER_84_250 VGND VGND VPWR VPWR sky130_fd_sc_hd__fill_2
XFILLER_85_773 VGND VGND VPWR VPWR sky130_fd_sc_hd__decap_3
XFILLER_55_45 VGND VGND VPWR VPWR sky130_fd_sc_hd__decap_3
XFILLER_84_283 VGND VGND VPWR VPWR sky130_fd_sc_hd__decap_3
XTAP_TAPCELL_ROW_15_507 VGND VPWR sky130_fd_sc_hd__tapvpwrvgnd_1
XFILLER_13_523 VGND VGND VPWR VPWR sky130_fd_sc_hd__decap_3
XFILLER_25_383 VGND VGND VPWR VPWR sky130_fd_sc_hd__fill_2
XFILLER_53_681 VGND VGND VPWR VPWR sky130_fd_sc_hd__decap_3
XFILLER_13_567 VGND VGND VPWR VPWR sky130_fd_sc_hd__decap_3
XFILLER_52_191 VGND VGND VPWR VPWR sky130_fd_sc_hd__decap_3
XFILLER_9_505 VGND VGND VPWR VPWR sky130_fd_sc_hd__decap_3
XFILLER_9_549 VGND VGND VPWR VPWR sky130_fd_sc_hd__fill_2
XFILLER_126_436 VGND VGND VPWR VPWR sky130_fd_sc_hd__decap_3
XFILLER_5_700 VGND VGND VPWR VPWR sky130_fd_sc_hd__decap_3
XTAP_TAPCELL_ROW_97_1645 VGND VPWR sky130_fd_sc_hd__tapvpwrvgnd_1
XTAP_TAPCELL_ROW_97_1656 VGND VPWR sky130_fd_sc_hd__tapvpwrvgnd_1
XFILLER_5_744 VGND VGND VPWR VPWR sky130_fd_sc_hd__decap_3
XFILLER_113_108 VGND VGND VPWR VPWR sky130_fd_sc_hd__decap_3
XFILLER_5_777 VGND VGND VPWR VPWR sky130_fd_sc_hd__decap_3
XFILLER_5_788 VGND VGND VPWR VPWR sky130_fd_sc_hd__decap_3
XFILLER_106_193 VGND VGND VPWR VPWR sky130_fd_sc_hd__decap_3
XFILLER_122_631 VGND VGND VPWR VPWR sky130_fd_sc_hd__fill_2
XFILLER_134_480 VGND VGND VPWR VPWR sky130_fd_sc_hd__decap_3
XFILLER_121_152 VGND VGND VPWR VPWR sky130_fd_sc_hd__decap_3
XFILLER_122_697 VGND VGND VPWR VPWR sky130_fd_sc_hd__decap_3
XFILLER_67_217 VGND VGND VPWR VPWR sky130_fd_sc_hd__decap_3
XFILLER_67_228 VGND VGND VPWR VPWR sky130_fd_sc_hd__decap_3
XFILLER_96_96 VGND VGND VPWR VPWR sky130_fd_sc_hd__decap_3
XFILLER_48_475 VGND VGND VPWR VPWR sky130_fd_sc_hd__fill_1
XFILLER_48_486 VGND VGND VPWR VPWR sky130_fd_sc_hd__decap_3
XFILLER_36_648 VGND VGND VPWR VPWR sky130_fd_sc_hd__decap_3
XFILLER_35_169 VGND VGND VPWR VPWR sky130_fd_sc_hd__fill_2
XFILLER_63_489 VGND VGND VPWR VPWR sky130_fd_sc_hd__decap_3
XFILLER_90_253 VGND VGND VPWR VPWR sky130_fd_sc_hd__decap_3
X_3950_ _4368_/A _3950_/B VGND VGND VPWR VPWR _3950_/X sky130_fd_sc_hd__or2_2
XFILLER_16_394 VGND VGND VPWR VPWR sky130_fd_sc_hd__decap_3
XTAP_TAPCELL_ROW_106_1774 VGND VPWR sky130_fd_sc_hd__tapvpwrvgnd_1
XFILLER_31_342 VGND VGND VPWR VPWR sky130_fd_sc_hd__decap_3
X_3881_ _8063_/Q _8144_/Q _4327_/S VGND VGND VPWR VPWR _3881_/X sky130_fd_sc_hd__mux2_2
XTAP_TAPCELL_ROW_42_882 VGND VPWR sky130_fd_sc_hd__tapvpwrvgnd_1
X_5620_ _5620_/A VGND VGND VPWR VPWR _7853_/D sky130_fd_sc_hd__buf_1
XFILLER_129_252 VGND VGND VPWR VPWR sky130_fd_sc_hd__decap_3
X_5551_ _5677_/S VGND VGND VPWR VPWR _5570_/S sky130_fd_sc_hd__buf_2
XFILLER_8_560 VGND VGND VPWR VPWR sky130_fd_sc_hd__decap_3
X_8270_ _8756_/CLK _8270_/D wire701/X VGND VGND VPWR VPWR _8270_/Q sky130_fd_sc_hd__dfrtp_2
X_4502_ _7784_/Q _7865_/Q _4502_/S VGND VGND VPWR VPWR _4503_/B sky130_fd_sc_hd__mux2_2
XFILLER_129_296 VGND VGND VPWR VPWR sky130_fd_sc_hd__decap_3
XFILLER_6_50 VGND VGND VPWR VPWR sky130_fd_sc_hd__decap_3
X_7221_ wire234/X _4740_/X wire175/X wire205/X hold810/X VGND VGND VPWR VPWR _8653_/D
+ sky130_fd_sc_hd__a32o_2
X_5482_ _7789_/Q _4894_/A _5482_/S VGND VGND VPWR VPWR _5483_/A sky130_fd_sc_hd__mux2_2
XFILLER_132_406 VGND VGND VPWR VPWR sky130_fd_sc_hd__decap_3
XFILLER_6_83 VGND VGND VPWR VPWR sky130_fd_sc_hd__fill_1
X_4433_ _8679_/Q _4560_/A2 _4432_/X _4442_/A _4444_/A1 VGND VGND VPWR VPWR _4433_/X
+ sky130_fd_sc_hd__o221a_2
XFILLER_113_620 VGND VGND VPWR VPWR sky130_fd_sc_hd__decap_3
XFILLER_116_18 VGND VGND VPWR VPWR sky130_fd_sc_hd__decap_3
XFILLER_125_480 VGND VGND VPWR VPWR sky130_fd_sc_hd__fill_1
XFILLER_132_439 VGND VGND VPWR VPWR sky130_fd_sc_hd__decap_3
Xfanout506 fanout507/X VGND VGND VPWR VPWR fanout506/X sky130_fd_sc_hd__clkdlybuf4s25_1
X_7152_ _7152_/A VGND VGND VPWR VPWR _8609_/D sky130_fd_sc_hd__buf_2
X_4364_ _8015_/Q _3811_/A _3880_/A _7934_/Q _4364_/C1 VGND VGND VPWR VPWR _4364_/X
+ sky130_fd_sc_hd__o221a_2
XFILLER_113_653 VGND VGND VPWR VPWR sky130_fd_sc_hd__decap_3
XFILLER_58_206 VGND VGND VPWR VPWR sky130_fd_sc_hd__decap_3
XFILLER_59_729 VGND VGND VPWR VPWR sky130_fd_sc_hd__decap_3
Xfanout517 fanout614/X VGND VGND VPWR VPWR fanout517/X sky130_fd_sc_hd__clkdlybuf4s25_1
Xfanout528 wire531/A VGND VGND VPWR VPWR fanout528/X sky130_fd_sc_hd__clkdlybuf4s25_1
Xfanout539 fanout543/X VGND VGND VPWR VPWR fanout539/X sky130_fd_sc_hd__clkdlybuf4s25_1
X_7083_ _7083_/A VGND VGND VPWR VPWR _8576_/D sky130_fd_sc_hd__buf_2
X_6103_ _6103_/A VGND VGND VPWR VPWR _8116_/D sky130_fd_sc_hd__buf_1
X_4295_ _8667_/Q _4295_/A2 _4294_/X VGND VGND VPWR VPWR _4295_/X sky130_fd_sc_hd__o21a_2
X_6034_ _6097_/A VGND VGND VPWR VPWR _6053_/S sky130_fd_sc_hd__buf_2
XFILLER_27_615 VGND VGND VPWR VPWR sky130_fd_sc_hd__fill_1
XFILLER_27_626 VGND VGND VPWR VPWR sky130_fd_sc_hd__fill_2
XFILLER_66_261 VGND VGND VPWR VPWR sky130_fd_sc_hd__fill_1
XFILLER_82_710 VGND VGND VPWR VPWR sky130_fd_sc_hd__fill_1
XFILLER_94_581 VGND VGND VPWR VPWR sky130_fd_sc_hd__decap_3
XFILLER_26_136 VGND VGND VPWR VPWR sky130_fd_sc_hd__decap_3
XFILLER_66_294 VGND VGND VPWR VPWR sky130_fd_sc_hd__fill_1
XFILLER_94_592 VGND VGND VPWR VPWR sky130_fd_sc_hd__decap_3
XTAP_TAPCELL_ROW_68_1246 VGND VPWR sky130_fd_sc_hd__tapvpwrvgnd_1
X_7985_ _8724_/CLK _7985_/D fanout506/X VGND VGND VPWR VPWR _7985_/Q sky130_fd_sc_hd__dfrtp_2
XFILLER_14_309 VGND VGND VPWR VPWR sky130_fd_sc_hd__decap_3
XFILLER_25_15 VGND VGND VPWR VPWR sky130_fd_sc_hd__decap_3
XFILLER_26_147 VGND VGND VPWR VPWR sky130_fd_sc_hd__decap_3
XFILLER_26_169 VGND VGND VPWR VPWR sky130_fd_sc_hd__decap_3
XFILLER_42_607 VGND VGND VPWR VPWR sky130_fd_sc_hd__decap_3
XFILLER_82_765 VGND VGND VPWR VPWR sky130_fd_sc_hd__fill_1
X_6936_ _6936_/A VGND VGND VPWR VPWR _8507_/D sky130_fd_sc_hd__buf_6
XFILLER_25_48 VGND VGND VPWR VPWR sky130_fd_sc_hd__decap_3
XFILLER_41_139 VGND VGND VPWR VPWR sky130_fd_sc_hd__decap_3
XTAP_TAPCELL_ROW_81_1424 VGND VPWR sky130_fd_sc_hd__tapvpwrvgnd_1
XFILLER_22_331 VGND VGND VPWR VPWR sky130_fd_sc_hd__decap_3
X_6867_ _6867_/A VGND VGND VPWR VPWR _8474_/D sky130_fd_sc_hd__buf_6
X_8606_ _8687_/CLK _8606_/D fanout577/X VGND VGND VPWR VPWR _8606_/Q sky130_fd_sc_hd__dfrtp_2
X_6798_ _6798_/A VGND VGND VPWR VPWR _8442_/D sky130_fd_sc_hd__buf_2
X_5818_ hold994/X _4879_/A _5826_/S VGND VGND VPWR VPWR _5819_/A sky130_fd_sc_hd__mux2_2
XFILLER_22_397 VGND VGND VPWR VPWR sky130_fd_sc_hd__decap_3
X_8537_ _8699_/CLK _8537_/D load_slew724/X VGND VGND VPWR VPWR _8537_/Q sky130_fd_sc_hd__dfrtp_2
X_5749_ _7914_/Q _4740_/A _5763_/S VGND VGND VPWR VPWR _5750_/A sky130_fd_sc_hd__mux2_2
XFILLER_108_436 VGND VGND VPWR VPWR sky130_fd_sc_hd__fill_2
XTAP_TAPCELL_ROW_20_576 VGND VPWR sky130_fd_sc_hd__tapvpwrvgnd_1
X_8468_ _8622_/CLK _8468_/D wire657/X VGND VGND VPWR VPWR _8468_/Q sky130_fd_sc_hd__dfrtp_2
XTAP_TAPCELL_ROW_79_1397 VGND VPWR sky130_fd_sc_hd__tapvpwrvgnd_1
X_8399_ _8804_/CLK _8399_/D fanout490/X VGND VGND VPWR VPWR _8399_/Q sky130_fd_sc_hd__dfrtp_2
X_7419_ _7419_/A VGND VGND VPWR VPWR _8766_/D sky130_fd_sc_hd__buf_1
XFILLER_2_725 VGND VGND VPWR VPWR sky130_fd_sc_hd__decap_3
XFILLER_103_130 VGND VGND VPWR VPWR sky130_fd_sc_hd__fill_2
XFILLER_2_769 VGND VGND VPWR VPWR sky130_fd_sc_hd__decap_3
XTAP_TAPCELL_ROW_92_1575 VGND VPWR sky130_fd_sc_hd__tapvpwrvgnd_1
XTAP_TAPCELL_ROW_92_1586 VGND VPWR sky130_fd_sc_hd__tapvpwrvgnd_1
XFILLER_131_461 VGND VGND VPWR VPWR sky130_fd_sc_hd__decap_3
XFILLER_131_494 VGND VGND VPWR VPWR sky130_fd_sc_hd__decap_3
XFILLER_77_537 VGND VGND VPWR VPWR sky130_fd_sc_hd__fill_2
XFILLER_77_548 VGND VGND VPWR VPWR sky130_fd_sc_hd__decap_3
Xclkbuf_5_31__f_CLK clkbuf_4_15_0_CLK/X VGND VGND VPWR VPWR clkload11/A sky130_fd_sc_hd__clkbuf_16
XFILLER_58_784 VGND VGND VPWR VPWR sky130_fd_sc_hd__decap_3
XFILLER_66_88 VGND VGND VPWR VPWR sky130_fd_sc_hd__decap_3
XFILLER_85_570 VGND VGND VPWR VPWR sky130_fd_sc_hd__decap_3
XFILLER_18_648 VGND VGND VPWR VPWR sky130_fd_sc_hd__decap_3
XFILLER_45_423 VGND VGND VPWR VPWR sky130_fd_sc_hd__decap_3
XFILLER_85_592 VGND VGND VPWR VPWR sky130_fd_sc_hd__decap_3
XFILLER_17_169 VGND VGND VPWR VPWR sky130_fd_sc_hd__decap_3
XFILLER_45_467 VGND VGND VPWR VPWR sky130_fd_sc_hd__decap_3
XFILLER_72_242 VGND VGND VPWR VPWR sky130_fd_sc_hd__decap_3
XFILLER_72_253 VGND VGND VPWR VPWR sky130_fd_sc_hd__decap_3
XFILLER_73_765 VGND VGND VPWR VPWR sky130_fd_sc_hd__decap_3
XFILLER_33_629 VGND VGND VPWR VPWR sky130_fd_sc_hd__decap_3
XFILLER_72_275 VGND VGND VPWR VPWR sky130_fd_sc_hd__decap_3
XTAP_TAPCELL_ROW_0_290 VGND VPWR sky130_fd_sc_hd__tapvpwrvgnd_1
XTAP_TAPCELL_ROW_28_687 VGND VPWR sky130_fd_sc_hd__tapvpwrvgnd_1
XFILLER_13_320 VGND VGND VPWR VPWR sky130_fd_sc_hd__decap_3
XFILLER_25_180 VGND VGND VPWR VPWR sky130_fd_sc_hd__fill_1
XFILLER_25_191 VGND VGND VPWR VPWR sky130_fd_sc_hd__fill_1
XFILLER_15_81 VGND VGND VPWR VPWR sky130_fd_sc_hd__decap_3
XFILLER_41_673 VGND VGND VPWR VPWR sky130_fd_sc_hd__decap_3
XFILLER_9_368 VGND VGND VPWR VPWR sky130_fd_sc_hd__decap_3
XFILLER_127_712 VGND VGND VPWR VPWR sky130_fd_sc_hd__decap_3
XFILLER_127_756 VGND VGND VPWR VPWR sky130_fd_sc_hd__decap_3
XTAP_TAPCELL_ROW_134_2170 VGND VPWR sky130_fd_sc_hd__tapvpwrvgnd_1
XFILLER_99_117 VGND VGND VPWR VPWR sky130_fd_sc_hd__decap_3
Xoutput109 _3797_/X VGND VGND VPWR VPWR rdata[2] sky130_fd_sc_hd__clkdlybuf4s25_1
XFILLER_114_439 VGND VGND VPWR VPWR sky130_fd_sc_hd__decap_3
XFILLER_5_596 VGND VGND VPWR VPWR sky130_fd_sc_hd__decap_3
XTAP_TAPCELL_ROW_52_1014 VGND VPWR sky130_fd_sc_hd__tapvpwrvgnd_1
XFILLER_1_780 VGND VGND VPWR VPWR sky130_fd_sc_hd__decap_3
XTAP_TAPCELL_ROW_52_1025 VGND VPWR sky130_fd_sc_hd__tapvpwrvgnd_1
Xoutput91 _3942_/X VGND VGND VPWR VPWR rdata[13] sky130_fd_sc_hd__clkdlybuf4s25_1
XFILLER_110_645 VGND VGND VPWR VPWR sky130_fd_sc_hd__decap_3
XFILLER_1_791 VGND VGND VPWR VPWR sky130_fd_sc_hd__decap_3
XFILLER_68_559 VGND VGND VPWR VPWR sky130_fd_sc_hd__decap_3
X_4080_ _4075_/X _4076_/X _4078_/X _4079_/X VGND VGND VPWR VPWR _4080_/X sky130_fd_sc_hd__a22o_2
XFILLER_110_678 VGND VGND VPWR VPWR sky130_fd_sc_hd__fill_2
XFILLER_110_689 VGND VGND VPWR VPWR sky130_fd_sc_hd__decap_3
XFILLER_36_401 VGND VGND VPWR VPWR sky130_fd_sc_hd__fill_1
XFILLER_48_250 VGND VGND VPWR VPWR sky130_fd_sc_hd__fill_2
XFILLER_49_773 VGND VGND VPWR VPWR sky130_fd_sc_hd__fill_2
XFILLER_55_209 VGND VGND VPWR VPWR sky130_fd_sc_hd__fill_1
XFILLER_64_710 VGND VGND VPWR VPWR sky130_fd_sc_hd__fill_1
XFILLER_95_389 VGND VGND VPWR VPWR sky130_fd_sc_hd__decap_3
XTAP_TAPCELL_ROW_108_1803 VGND VPWR sky130_fd_sc_hd__tapvpwrvgnd_1
XFILLER_64_732 VGND VGND VPWR VPWR sky130_fd_sc_hd__decap_3
XFILLER_64_754 VGND VGND VPWR VPWR sky130_fd_sc_hd__fill_2
XFILLER_76_581 VGND VGND VPWR VPWR sky130_fd_sc_hd__decap_3
XFILLER_76_592 VGND VGND VPWR VPWR sky130_fd_sc_hd__decap_3
XFILLER_24_607 VGND VGND VPWR VPWR sky130_fd_sc_hd__fill_1
XTAP_TAPCELL_ROW_47_952 VGND VPWR sky130_fd_sc_hd__tapvpwrvgnd_1
XFILLER_17_692 VGND VGND VPWR VPWR sky130_fd_sc_hd__decap_3
XFILLER_23_117 VGND VGND VPWR VPWR sky130_fd_sc_hd__fill_1
XFILLER_36_489 VGND VGND VPWR VPWR sky130_fd_sc_hd__fill_1
XFILLER_51_426 VGND VGND VPWR VPWR sky130_fd_sc_hd__decap_3
XFILLER_63_275 VGND VGND VPWR VPWR sky130_fd_sc_hd__decap_3
X_7770_ _8671_/CLK _7770_/D load_slew687/X VGND VGND VPWR VPWR _7770_/Q sky130_fd_sc_hd__dfrtp_2
X_4982_ _4981_/X _7566_/Q _4986_/S VGND VGND VPWR VPWR _4983_/A sky130_fd_sc_hd__mux2_2
XFILLER_32_640 VGND VGND VPWR VPWR sky130_fd_sc_hd__decap_3
X_3933_ _4455_/A _3933_/B VGND VGND VPWR VPWR _3933_/X sky130_fd_sc_hd__or2_2
X_6721_ _8406_/Q _4722_/A _6723_/S VGND VGND VPWR VPWR _6722_/A sky130_fd_sc_hd__mux2_2
XFILLER_32_684 VGND VGND VPWR VPWR sky130_fd_sc_hd__decap_3
XTAP_TAPCELL_ROW_63_1176 VGND VPWR sky130_fd_sc_hd__tapvpwrvgnd_1
X_3864_ _3831_/A _3860_/X _3862_/X _3863_/X VGND VGND VPWR VPWR _3864_/X sky130_fd_sc_hd__a22o_2
X_6652_ _4933_/X _8375_/Q _6654_/S VGND VGND VPWR VPWR _6653_/A sky130_fd_sc_hd__mux2_2
X_5603_ _5603_/A VGND VGND VPWR VPWR _7845_/D sky130_fd_sc_hd__buf_1
XFILLER_118_701 VGND VGND VPWR VPWR sky130_fd_sc_hd__decap_3
XFILLER_118_712 VGND VGND VPWR VPWR sky130_fd_sc_hd__decap_3
X_3795_ _4460_/A VGND VGND VPWR VPWR _3795_/X sky130_fd_sc_hd__clkbuf_2
X_8322_ _8647_/CLK _8322_/D fanout534/X VGND VGND VPWR VPWR _8322_/Q sky130_fd_sc_hd__dfrtp_2
X_6583_ _4795_/X _8342_/Q _6591_/S VGND VGND VPWR VPWR _6584_/A sky130_fd_sc_hd__mux2_2
XFILLER_11_39 VGND VGND VPWR VPWR sky130_fd_sc_hd__decap_3
XTAP_TAPCELL_ROW_119_1954 VGND VPWR sky130_fd_sc_hd__tapvpwrvgnd_1
XTAP_TAPCELL_ROW_119_1965 VGND VPWR sky130_fd_sc_hd__tapvpwrvgnd_1
X_5534_ _5534_/A VGND VGND VPWR VPWR _7812_/D sky130_fd_sc_hd__buf_1
XFILLER_105_417 VGND VGND VPWR VPWR sky130_fd_sc_hd__decap_3
XFILLER_127_39 VGND VGND VPWR VPWR sky130_fd_sc_hd__decap_3
XFILLER_132_203 VGND VGND VPWR VPWR sky130_fd_sc_hd__decap_3
XFILLER_133_715 VGND VGND VPWR VPWR sky130_fd_sc_hd__decap_3
X_8253_ _8657_/CLK _8253_/D load_slew513/X VGND VGND VPWR VPWR _8253_/Q sky130_fd_sc_hd__dfrtp_2
X_5465_ _5465_/A VGND VGND VPWR VPWR _7780_/D sky130_fd_sc_hd__buf_1
XFILLER_132_236 VGND VGND VPWR VPWR sky130_fd_sc_hd__decap_3
XFILLER_133_759 VGND VGND VPWR VPWR sky130_fd_sc_hd__decap_3
X_8184_ _8387_/CLK _8184_/D wire631/X VGND VGND VPWR VPWR _8184_/Q sky130_fd_sc_hd__dfrtp_2
X_7204_ _7269_/A VGND VGND VPWR VPWR _7204_/X sky130_fd_sc_hd__clkbuf_1
X_4416_ _7695_/Q _3784_/X _4642_/A2 _7614_/Q _4682_/C1 VGND VGND VPWR VPWR _4416_/X
+ sky130_fd_sc_hd__o221a_2
XFILLER_99_673 VGND VGND VPWR VPWR sky130_fd_sc_hd__decap_3
Xfanout303 _4104_/B2 VGND VGND VPWR VPWR _4099_/B2 sky130_fd_sc_hd__clkdlybuf4s25_1
Xfanout314 _8046_/Q VGND VGND VPWR VPWR fanout314/X sky130_fd_sc_hd__clkdlybuf4s25_1
X_7135_ _4861_/X _8601_/Q _7151_/S VGND VGND VPWR VPWR _7136_/A sky130_fd_sc_hd__mux2_2
X_5396_ _7748_/Q _4722_/A _5398_/S VGND VGND VPWR VPWR _5397_/A sky130_fd_sc_hd__mux2_2
XFILLER_100_100 VGND VGND VPWR VPWR sky130_fd_sc_hd__decap_3
XFILLER_101_612 VGND VGND VPWR VPWR sky130_fd_sc_hd__decap_3
XFILLER_113_472 VGND VGND VPWR VPWR sky130_fd_sc_hd__decap_3
Xfanout325 _4637_/A VGND VGND VPWR VPWR wire326/A sky130_fd_sc_hd__clkdlybuf4s25_1
X_4347_ _4344_/X _4345_/X _4346_/X _4444_/A1 _4617_/B1 VGND VGND VPWR VPWR _4347_/X
+ sky130_fd_sc_hd__a221o_2
X_7066_ _7066_/A VGND VGND VPWR VPWR _8568_/D sky130_fd_sc_hd__buf_2
X_4278_ _8747_/Q _7522_/Q _4320_/S VGND VGND VPWR VPWR _4278_/X sky130_fd_sc_hd__mux2_2
XFILLER_74_529 VGND VGND VPWR VPWR sky130_fd_sc_hd__decap_3
XFILLER_86_389 VGND VGND VPWR VPWR sky130_fd_sc_hd__decap_3
X_6017_ _6017_/A VGND VGND VPWR VPWR _8075_/D sky130_fd_sc_hd__buf_2
XFILLER_100_188 VGND VGND VPWR VPWR sky130_fd_sc_hd__decap_3
XFILLER_54_220 VGND VGND VPWR VPWR sky130_fd_sc_hd__decap_3
XFILLER_55_732 VGND VGND VPWR VPWR sky130_fd_sc_hd__decap_3
XFILLER_27_478 VGND VGND VPWR VPWR sky130_fd_sc_hd__decap_3
XFILLER_54_253 VGND VGND VPWR VPWR sky130_fd_sc_hd__decap_3
XFILLER_55_765 VGND VGND VPWR VPWR sky130_fd_sc_hd__decap_3
XFILLER_70_713 VGND VGND VPWR VPWR sky130_fd_sc_hd__decap_3
XFILLER_14_106 VGND VGND VPWR VPWR sky130_fd_sc_hd__decap_3
XFILLER_82_573 VGND VGND VPWR VPWR sky130_fd_sc_hd__fill_2
XFILLER_82_584 VGND VGND VPWR VPWR sky130_fd_sc_hd__decap_3
XFILLER_82_595 VGND VGND VPWR VPWR sky130_fd_sc_hd__fill_1
X_7968_ _8545_/CLK _7968_/D load_slew661/X VGND VGND VPWR VPWR _7968_/Q sky130_fd_sc_hd__dfrtp_2
XFILLER_14_139 VGND VGND VPWR VPWR sky130_fd_sc_hd__fill_1
XFILLER_52_24 VGND VGND VPWR VPWR sky130_fd_sc_hd__decap_3
XFILLER_70_757 VGND VGND VPWR VPWR sky130_fd_sc_hd__decap_3
XTAP_TAPCELL_ROW_25_646 VGND VPWR sky130_fd_sc_hd__tapvpwrvgnd_1
X_7899_ _8719_/CLK _7899_/D load_slew591/X VGND VGND VPWR VPWR _7899_/Q sky130_fd_sc_hd__dfrtp_2
X_6919_ _4773_/X _8499_/Q _6937_/S VGND VGND VPWR VPWR _6920_/A sky130_fd_sc_hd__mux2_4
XFILLER_10_301 VGND VGND VPWR VPWR sky130_fd_sc_hd__decap_3
XFILLER_23_673 VGND VGND VPWR VPWR sky130_fd_sc_hd__fill_2
XFILLER_10_312 VGND VGND VPWR VPWR sky130_fd_sc_hd__decap_3
XFILLER_108_200 VGND VGND VPWR VPWR sky130_fd_sc_hd__decap_3
XFILLER_109_712 VGND VGND VPWR VPWR sky130_fd_sc_hd__decap_3
XFILLER_109_723 VGND VGND VPWR VPWR sky130_fd_sc_hd__decap_3
XTAP_TAPCELL_ROW_94_1604 VGND VPWR sky130_fd_sc_hd__tapvpwrvgnd_1
XTAP_TAPCELL_ROW_94_1615 VGND VPWR sky130_fd_sc_hd__tapvpwrvgnd_1
XFILLER_108_244 VGND VGND VPWR VPWR sky130_fd_sc_hd__decap_3
XFILLER_123_203 VGND VGND VPWR VPWR sky130_fd_sc_hd__decap_3
XFILLER_123_225 VGND VGND VPWR VPWR sky130_fd_sc_hd__fill_1
XFILLER_2_533 VGND VGND VPWR VPWR sky130_fd_sc_hd__fill_1
XFILLER_104_450 VGND VGND VPWR VPWR sky130_fd_sc_hd__decap_3
XFILLER_123_258 VGND VGND VPWR VPWR sky130_fd_sc_hd__fill_1
XFILLER_132_781 VGND VGND VPWR VPWR sky130_fd_sc_hd__decap_3
XFILLER_77_32 VGND VGND VPWR VPWR sky130_fd_sc_hd__fill_2
XFILLER_77_43 VGND VGND VPWR VPWR sky130_fd_sc_hd__fill_1
XFILLER_77_54 VGND VGND VPWR VPWR sky130_fd_sc_hd__fill_2
XFILLER_89_172 VGND VGND VPWR VPWR sky130_fd_sc_hd__fill_2
XFILLER_77_334 VGND VGND VPWR VPWR sky130_fd_sc_hd__fill_2
XFILLER_58_570 VGND VGND VPWR VPWR sky130_fd_sc_hd__decap_3
XFILLER_65_529 VGND VGND VPWR VPWR sky130_fd_sc_hd__decap_3
XTAP_TAPCELL_ROW_5_360 VGND VPWR sky130_fd_sc_hd__tapvpwrvgnd_1
XFILLER_133_60 VGND VGND VPWR VPWR sky130_fd_sc_hd__decap_3
XFILLER_133_93 VGND VGND VPWR VPWR sky130_fd_sc_hd__decap_3
XFILLER_58_592 VGND VGND VPWR VPWR sky130_fd_sc_hd__fill_1
XFILLER_46_787 VGND VGND VPWR VPWR sky130_fd_sc_hd__decap_3
XFILLER_92_359 VGND VGND VPWR VPWR sky130_fd_sc_hd__decap_3
XFILLER_93_53 VGND VGND VPWR VPWR sky130_fd_sc_hd__decap_3
XFILLER_18_489 VGND VGND VPWR VPWR sky130_fd_sc_hd__fill_2
XFILLER_33_415 VGND VGND VPWR VPWR sky130_fd_sc_hd__decap_3
XFILLER_73_573 VGND VGND VPWR VPWR sky130_fd_sc_hd__fill_1
XTAP_TAPCELL_ROW_44_911 VGND VPWR sky130_fd_sc_hd__tapvpwrvgnd_1
XFILLER_26_80 VGND VGND VPWR VPWR sky130_fd_sc_hd__decap_3
XFILLER_60_256 VGND VGND VPWR VPWR sky130_fd_sc_hd__fill_2
XTAP_TAPCELL_ROW_103_1733 VGND VPWR sky130_fd_sc_hd__tapvpwrvgnd_1
XFILLER_60_267 VGND VGND VPWR VPWR sky130_fd_sc_hd__fill_2
XFILLER_60_278 VGND VGND VPWR VPWR sky130_fd_sc_hd__decap_3
XFILLER_9_132 VGND VGND VPWR VPWR sky130_fd_sc_hd__decap_3
XFILLER_9_165 VGND VGND VPWR VPWR sky130_fd_sc_hd__decap_3
XFILLER_127_520 VGND VGND VPWR VPWR sky130_fd_sc_hd__decap_3
XFILLER_9_187 VGND VGND VPWR VPWR sky130_fd_sc_hd__decap_3
XFILLER_127_553 VGND VGND VPWR VPWR sky130_fd_sc_hd__decap_3
XFILLER_127_564 VGND VGND VPWR VPWR sky130_fd_sc_hd__decap_3
XFILLER_127_597 VGND VGND VPWR VPWR sky130_fd_sc_hd__decap_3
X_5250_ _7679_/Q _4773_/X _5268_/S VGND VGND VPWR VPWR _5251_/A sky130_fd_sc_hd__mux2_2
XFILLER_130_707 VGND VGND VPWR VPWR sky130_fd_sc_hd__decap_3
XFILLER_47_3 VGND VGND VPWR VPWR sky130_fd_sc_hd__decap_3
X_4201_ _4198_/X _4199_/X _4200_/X _4030_/S _4129_/A VGND VGND VPWR VPWR _4201_/X
+ sky130_fd_sc_hd__a221o_2
XFILLER_96_610 VGND VGND VPWR VPWR sky130_fd_sc_hd__decap_3
XTAP_TAPCELL_ROW_114_1884 VGND VPWR sky130_fd_sc_hd__tapvpwrvgnd_1
XTAP_TAPCELL_ROW_114_1895 VGND VPWR sky130_fd_sc_hd__tapvpwrvgnd_1
X_5181_ _5181_/A VGND VGND VPWR VPWR _7646_/D sky130_fd_sc_hd__buf_1
XFILLER_110_442 VGND VGND VPWR VPWR sky130_fd_sc_hd__fill_1
XFILLER_3_51 VGND VGND VPWR VPWR sky130_fd_sc_hd__decap_3
XFILLER_96_632 VGND VGND VPWR VPWR sky130_fd_sc_hd__decap_3
X_4132_ _4030_/S _4127_/X _4129_/X _4131_/X VGND VGND VPWR VPWR _4132_/X sky130_fd_sc_hd__a22o_2
XFILLER_110_475 VGND VGND VPWR VPWR sky130_fd_sc_hd__fill_1
XFILLER_3_84 VGND VGND VPWR VPWR sky130_fd_sc_hd__decap_3
XFILLER_56_507 VGND VGND VPWR VPWR sky130_fd_sc_hd__decap_3
XFILLER_83_304 VGND VGND VPWR VPWR sky130_fd_sc_hd__fill_1
XFILLER_95_142 VGND VGND VPWR VPWR sky130_fd_sc_hd__decap_3
XFILLER_95_175 VGND VGND VPWR VPWR sky130_fd_sc_hd__decap_3
X_4063_ _8322_/Q _4399_/A2 _3916_/B _8241_/Q _3776_/X VGND VGND VPWR VPWR _4063_/X
+ sky130_fd_sc_hd__o221a_2
XFILLER_49_592 VGND VGND VPWR VPWR sky130_fd_sc_hd__decap_3
XFILLER_83_337 VGND VGND VPWR VPWR sky130_fd_sc_hd__decap_3
XFILLER_52_713 VGND VGND VPWR VPWR sky130_fd_sc_hd__fill_1
XFILLER_64_573 VGND VGND VPWR VPWR sky130_fd_sc_hd__decap_3
XTAP_TAPCELL_ROW_65_1205 VGND VPWR sky130_fd_sc_hd__tapvpwrvgnd_1
X_7822_ _8645_/CLK _7822_/D load_slew499/X VGND VGND VPWR VPWR _7822_/Q sky130_fd_sc_hd__dfrtp_2
XFILLER_24_437 VGND VGND VPWR VPWR sky130_fd_sc_hd__fill_2
XFILLER_24_459 VGND VGND VPWR VPWR sky130_fd_sc_hd__decap_3
XFILLER_51_223 VGND VGND VPWR VPWR sky130_fd_sc_hd__fill_1
XFILLER_52_779 VGND VGND VPWR VPWR sky130_fd_sc_hd__fill_1
X_7753_ _8646_/CLK _7753_/D load_slew529/X VGND VGND VPWR VPWR _7753_/Q sky130_fd_sc_hd__dfrtp_2
X_4965_ _4965_/A VGND VGND VPWR VPWR _4965_/X sky130_fd_sc_hd__buf_1
XFILLER_11_109 VGND VGND VPWR VPWR sky130_fd_sc_hd__decap_3
XTAP_TAPCELL_ROW_22_605 VGND VPWR sky130_fd_sc_hd__tapvpwrvgnd_1
X_3916_ _7894_/Q _3916_/B VGND VGND VPWR VPWR _3916_/X sky130_fd_sc_hd__or2_2
X_6704_ _6830_/S VGND VGND VPWR VPWR _6723_/S sky130_fd_sc_hd__buf_2
XFILLER_32_492 VGND VGND VPWR VPWR sky130_fd_sc_hd__decap_3
X_7684_ _8624_/CLK _7684_/D load_slew647/X VGND VGND VPWR VPWR _7684_/Q sky130_fd_sc_hd__dfrtp_2
X_4896_ _4895_/X _4896_/A1 _4896_/S VGND VGND VPWR VPWR _4897_/A sky130_fd_sc_hd__mux2_2
XFILLER_20_665 VGND VGND VPWR VPWR sky130_fd_sc_hd__decap_3
XFILLER_22_38 VGND VGND VPWR VPWR sky130_fd_sc_hd__decap_3
X_3847_ _3849_/S1 _3845_/X _3846_/X VGND VGND VPWR VPWR _3847_/X sky130_fd_sc_hd__o21a_2
X_6635_ _6656_/S VGND VGND VPWR VPWR _6654_/S sky130_fd_sc_hd__buf_6
XFILLER_118_542 VGND VGND VPWR VPWR sky130_fd_sc_hd__fill_2
X_3778_ _8055_/Q _8136_/Q _3778_/S VGND VGND VPWR VPWR _3779_/B sky130_fd_sc_hd__mux2_2
X_6566_ _4761_/X _8334_/Q _6570_/S VGND VGND VPWR VPWR _6567_/A sky130_fd_sc_hd__mux2_2
XFILLER_106_704 VGND VGND VPWR VPWR sky130_fd_sc_hd__decap_3
XFILLER_118_9 VGND VGND VPWR VPWR sky130_fd_sc_hd__decap_3
X_8305_ _8792_/CLK _8305_/D fanout656/A VGND VGND VPWR VPWR _8305_/Q sky130_fd_sc_hd__dfrtp_2
X_5517_ _5517_/A VGND VGND VPWR VPWR _7804_/D sky130_fd_sc_hd__buf_1
XFILLER_105_214 VGND VGND VPWR VPWR sky130_fd_sc_hd__fill_1
XFILLER_105_225 VGND VGND VPWR VPWR sky130_fd_sc_hd__fill_2
XFILLER_133_523 VGND VGND VPWR VPWR sky130_fd_sc_hd__decap_3
XTAP_TAPCELL_ROW_76_1356 VGND VPWR sky130_fd_sc_hd__tapvpwrvgnd_1
X_8236_ _8560_/CLK _8236_/D _8053_/SET_B VGND VGND VPWR VPWR _8236_/Q sky130_fd_sc_hd__dfrtp_2
X_6497_ _4965_/X _8301_/Q _6507_/S VGND VGND VPWR VPWR _6498_/A sky130_fd_sc_hd__mux2_2
XFILLER_0_9 VGND VGND VPWR VPWR sky130_fd_sc_hd__decap_3
XFILLER_105_269 VGND VGND VPWR VPWR sky130_fd_sc_hd__fill_2
XFILLER_121_707 VGND VGND VPWR VPWR sky130_fd_sc_hd__fill_1
XFILLER_133_556 VGND VGND VPWR VPWR sky130_fd_sc_hd__decap_3
XFILLER_133_567 VGND VGND VPWR VPWR sky130_fd_sc_hd__decap_3
X_5448_ _5448_/A VGND VGND VPWR VPWR _7772_/D sky130_fd_sc_hd__buf_1
XFILLER_59_301 VGND VGND VPWR VPWR sky130_fd_sc_hd__fill_1
X_8167_ _8740_/CLK _8167_/D load_slew538/X VGND VGND VPWR VPWR _8167_/Q sky130_fd_sc_hd__dfrtp_2
X_5379_ _5463_/A VGND VGND VPWR VPWR _5398_/S sky130_fd_sc_hd__buf_2
XFILLER_87_643 VGND VGND VPWR VPWR sky130_fd_sc_hd__fill_2
X_8098_ _8746_/CLK _8098_/D fanout624/X VGND VGND VPWR VPWR _8098_/Q sky130_fd_sc_hd__dfrtp_2
X_7118_ _7248_/A2 _8593_/Q _7130_/S VGND VGND VPWR VPWR _7119_/A sky130_fd_sc_hd__mux2_2
XFILLER_101_475 VGND VGND VPWR VPWR sky130_fd_sc_hd__decap_3
XFILLER_47_46 VGND VGND VPWR VPWR sky130_fd_sc_hd__decap_3
XFILLER_47_529 VGND VGND VPWR VPWR sky130_fd_sc_hd__decap_3
XFILLER_86_153 VGND VGND VPWR VPWR sky130_fd_sc_hd__decap_3
XFILLER_87_676 VGND VGND VPWR VPWR sky130_fd_sc_hd__decap_3
X_7049_ _5031_/X _8560_/Q _7067_/S VGND VGND VPWR VPWR _7050_/A sky130_fd_sc_hd__mux2_2
XFILLER_47_57 VGND VGND VPWR VPWR sky130_fd_sc_hd__decap_3
XFILLER_74_337 VGND VGND VPWR VPWR sky130_fd_sc_hd__decap_3
XFILLER_86_186 VGND VGND VPWR VPWR sky130_fd_sc_hd__decap_3
XPHY_EDGE_ROW_29_Right_29 VGND VGND VPWR VPWR sky130_fd_sc_hd__decap_3
XFILLER_103_52 VGND VGND VPWR VPWR sky130_fd_sc_hd__decap_3
XFILLER_103_63 VGND VGND VPWR VPWR sky130_fd_sc_hd__decap_3
XFILLER_15_415 VGND VGND VPWR VPWR sky130_fd_sc_hd__decap_3
XFILLER_55_573 VGND VGND VPWR VPWR sky130_fd_sc_hd__decap_3
XFILLER_27_297 VGND VGND VPWR VPWR sky130_fd_sc_hd__fill_2
XFILLER_42_245 VGND VGND VPWR VPWR sky130_fd_sc_hd__decap_3
XFILLER_43_757 VGND VGND VPWR VPWR sky130_fd_sc_hd__fill_2
XFILLER_43_768 VGND VGND VPWR VPWR sky130_fd_sc_hd__decap_3
XFILLER_70_554 VGND VGND VPWR VPWR sky130_fd_sc_hd__fill_1
XFILLER_42_256 VGND VGND VPWR VPWR sky130_fd_sc_hd__fill_2
XFILLER_42_267 VGND VGND VPWR VPWR sky130_fd_sc_hd__decap_3
XFILLER_70_576 VGND VGND VPWR VPWR sky130_fd_sc_hd__decap_3
XFILLER_11_610 VGND VGND VPWR VPWR sky130_fd_sc_hd__decap_3
XFILLER_11_632 VGND VGND VPWR VPWR sky130_fd_sc_hd__decap_3
XFILLER_8_18 VGND VGND VPWR VPWR sky130_fd_sc_hd__decap_3
XFILLER_8_29 VGND VGND VPWR VPWR sky130_fd_sc_hd__decap_3
XFILLER_11_676 VGND VGND VPWR VPWR sky130_fd_sc_hd__decap_3
XFILLER_7_614 VGND VGND VPWR VPWR sky130_fd_sc_hd__fill_2
XPHY_EDGE_ROW_38_Right_38 VGND VGND VPWR VPWR sky130_fd_sc_hd__decap_3
XFILLER_128_339 VGND VGND VPWR VPWR sky130_fd_sc_hd__decap_3
XFILLER_6_135 VGND VGND VPWR VPWR sky130_fd_sc_hd__decap_3
XFILLER_7_647 VGND VGND VPWR VPWR sky130_fd_sc_hd__decap_3
XFILLER_109_564 VGND VGND VPWR VPWR sky130_fd_sc_hd__decap_3
XFILLER_12_71 VGND VGND VPWR VPWR sky130_fd_sc_hd__decap_3
XFILLER_109_586 VGND VGND VPWR VPWR sky130_fd_sc_hd__decap_3
XFILLER_124_512 VGND VGND VPWR VPWR sky130_fd_sc_hd__fill_1
XFILLER_128_71 VGND VGND VPWR VPWR sky130_fd_sc_hd__decap_3
XFILLER_112_707 VGND VGND VPWR VPWR sky130_fd_sc_hd__decap_3
XFILLER_124_578 VGND VGND VPWR VPWR sky130_fd_sc_hd__decap_3
XFILLER_124_589 VGND VGND VPWR VPWR sky130_fd_sc_hd__decap_3
XFILLER_104_280 VGND VGND VPWR VPWR sky130_fd_sc_hd__fill_1
XFILLER_38_518 VGND VGND VPWR VPWR sky130_fd_sc_hd__fill_1
XFILLER_78_687 VGND VGND VPWR VPWR sky130_fd_sc_hd__fill_1
XPHY_EDGE_ROW_47_Right_47 VGND VGND VPWR VPWR sky130_fd_sc_hd__decap_3
XFILLER_19_732 VGND VGND VPWR VPWR sky130_fd_sc_hd__fill_2
XFILLER_65_337 VGND VGND VPWR VPWR sky130_fd_sc_hd__decap_3
XFILLER_77_175 VGND VGND VPWR VPWR sky130_fd_sc_hd__decap_3
XFILLER_80_307 VGND VGND VPWR VPWR sky130_fd_sc_hd__fill_1
XFILLER_92_156 VGND VGND VPWR VPWR sky130_fd_sc_hd__decap_3
XFILLER_93_679 VGND VGND VPWR VPWR sky130_fd_sc_hd__decap_3
XFILLER_18_275 VGND VGND VPWR VPWR sky130_fd_sc_hd__decap_3
XFILLER_34_713 VGND VGND VPWR VPWR sky130_fd_sc_hd__fill_2
XFILLER_34_724 VGND VGND VPWR VPWR sky130_fd_sc_hd__decap_3
XFILLER_34_757 VGND VGND VPWR VPWR sky130_fd_sc_hd__decap_3
XFILLER_61_554 VGND VGND VPWR VPWR sky130_fd_sc_hd__decap_3
XPHY_EDGE_ROW_56_Right_56 VGND VGND VPWR VPWR sky130_fd_sc_hd__decap_3
XTAP_TAPCELL_ROW_60_1135 VGND VPWR sky130_fd_sc_hd__tapvpwrvgnd_1
X_4750_ _4749_/X _7511_/Q _4778_/S VGND VGND VPWR VPWR _4751_/A sky130_fd_sc_hd__mux2_2
XFILLER_119_317 VGND VGND VPWR VPWR sky130_fd_sc_hd__decap_3
X_4681_ _4681_/A _4681_/B VGND VGND VPWR VPWR _4681_/X sky130_fd_sc_hd__or2_2
X_6420_ _6420_/A VGND VGND VPWR VPWR _8265_/D sky130_fd_sc_hd__buf_2
XFILLER_134_309 VGND VGND VPWR VPWR sky130_fd_sc_hd__decap_3
XTAP_TAPCELL_ROW_116_1913 VGND VPWR sky130_fd_sc_hd__tapvpwrvgnd_1
X_6351_ _6351_/A VGND VGND VPWR VPWR _8232_/D sky130_fd_sc_hd__buf_2
X_5302_ _7704_/Q _4879_/X _5310_/S VGND VGND VPWR VPWR _5303_/A sky130_fd_sc_hd__mux2_2
X_6282_ _6282_/A VGND VGND VPWR VPWR _8200_/D sky130_fd_sc_hd__buf_6
XFILLER_130_504 VGND VGND VPWR VPWR sky130_fd_sc_hd__decap_3
XFILLER_69_610 VGND VGND VPWR VPWR sky130_fd_sc_hd__decap_3
XPHY_EDGE_ROW_65_Right_65 VGND VGND VPWR VPWR sky130_fd_sc_hd__decap_3
X_8021_ _8274_/CLK _8021_/D load_slew696/X VGND VGND VPWR VPWR _8021_/Q sky130_fd_sc_hd__dfrtp_2
X_5233_ _7671_/Q _4740_/X _5247_/S VGND VGND VPWR VPWR _5234_/A sky130_fd_sc_hd__mux2_2
XFILLER_124_18 VGND VGND VPWR VPWR sky130_fd_sc_hd__decap_3
XFILLER_124_29 VGND VGND VPWR VPWR sky130_fd_sc_hd__decap_3
XFILLER_130_548 VGND VGND VPWR VPWR sky130_fd_sc_hd__decap_3
XFILLER_68_120 VGND VGND VPWR VPWR sky130_fd_sc_hd__fill_2
X_5164_ _5164_/A VGND VGND VPWR VPWR _5291_/A sky130_fd_sc_hd__clkbuf_1
XFILLER_110_250 VGND VGND VPWR VPWR sky130_fd_sc_hd__fill_2
XFILLER_56_304 VGND VGND VPWR VPWR sky130_fd_sc_hd__decap_3
XFILLER_68_153 VGND VGND VPWR VPWR sky130_fd_sc_hd__decap_3
XFILLER_69_676 VGND VGND VPWR VPWR sky130_fd_sc_hd__decap_3
XTAP_TAPCELL_ROW_71_1286 VGND VPWR sky130_fd_sc_hd__tapvpwrvgnd_1
X_4115_ _4129_/A _4115_/B VGND VGND VPWR VPWR _4115_/X sky130_fd_sc_hd__or2_2
XFILLER_68_197 VGND VGND VPWR VPWR sky130_fd_sc_hd__decap_3
XFILLER_84_624 VGND VGND VPWR VPWR sky130_fd_sc_hd__decap_3
X_5095_ _4811_/X _7607_/Q _5095_/S VGND VGND VPWR VPWR _5096_/A sky130_fd_sc_hd__mux2_2
XFILLER_17_27 VGND VGND VPWR VPWR sky130_fd_sc_hd__decap_3
XFILLER_84_668 VGND VGND VPWR VPWR sky130_fd_sc_hd__decap_3
X_4046_ _4044_/X _4045_/X _4514_/S VGND VGND VPWR VPWR _4046_/X sky130_fd_sc_hd__mux2_2
XFILLER_25_735 VGND VGND VPWR VPWR sky130_fd_sc_hd__decap_3
XFILLER_83_167 VGND VGND VPWR VPWR sky130_fd_sc_hd__fill_1
XFILLER_83_189 VGND VGND VPWR VPWR sky130_fd_sc_hd__decap_3
XFILLER_24_212 VGND VGND VPWR VPWR sky130_fd_sc_hd__decap_3
XFILLER_24_234 VGND VGND VPWR VPWR sky130_fd_sc_hd__decap_3
XFILLER_52_554 VGND VGND VPWR VPWR sky130_fd_sc_hd__decap_3
X_7805_ _8785_/CLK _7805_/D load_slew678/X VGND VGND VPWR VPWR _7805_/Q sky130_fd_sc_hd__dfrtp_2
XFILLER_12_407 VGND VGND VPWR VPWR sky130_fd_sc_hd__decap_3
XPHY_EDGE_ROW_74_Right_74 VGND VGND VPWR VPWR sky130_fd_sc_hd__decap_3
X_8785_ _8785_/CLK _8785_/D fanout684/X VGND VGND VPWR VPWR _8785_/Q sky130_fd_sc_hd__dfrtp_2
X_5997_ _8066_/Q input6/X _6011_/S VGND VGND VPWR VPWR _5998_/A sky130_fd_sc_hd__mux2_2
XFILLER_40_738 VGND VGND VPWR VPWR sky130_fd_sc_hd__decap_3
XTAP_TAPCELL_ROW_35_785 VGND VPWR sky130_fd_sc_hd__tapvpwrvgnd_1
X_7736_ _8639_/CLK _7736_/D wire603/X VGND VGND VPWR VPWR _7736_/Q sky130_fd_sc_hd__dfrtp_2
X_4948_ _5160_/S VGND VGND VPWR VPWR _4986_/S sky130_fd_sc_hd__buf_2
XFILLER_20_451 VGND VGND VPWR VPWR sky130_fd_sc_hd__decap_3
X_7667_ _8658_/CLK _7667_/D load_slew515/X VGND VGND VPWR VPWR _7667_/Q sky130_fd_sc_hd__dfrtp_2
X_4879_ _4879_/A VGND VGND VPWR VPWR _4879_/X sky130_fd_sc_hd__buf_1
X_6618_ _6618_/A VGND VGND VPWR VPWR _8358_/D sky130_fd_sc_hd__buf_2
XFILLER_116_6 VGND VGND VPWR VPWR sky130_fd_sc_hd__decap_3
XFILLER_125_309 VGND VGND VPWR VPWR sky130_fd_sc_hd__decap_3
X_7598_ _8746_/CLK _7598_/D fanout525/X VGND VGND VPWR VPWR _7598_/Q sky130_fd_sc_hd__dfrtp_2
XFILLER_106_512 VGND VGND VPWR VPWR sky130_fd_sc_hd__decap_3
XFILLER_3_105 VGND VGND VPWR VPWR sky130_fd_sc_hd__decap_3
XFILLER_4_628 VGND VGND VPWR VPWR sky130_fd_sc_hd__decap_3
X_6549_ _4727_/X _8326_/Q _6549_/S VGND VGND VPWR VPWR _6550_/A sky130_fd_sc_hd__mux2_2
XFILLER_106_545 VGND VGND VPWR VPWR sky130_fd_sc_hd__decap_3
XFILLER_133_320 VGND VGND VPWR VPWR sky130_fd_sc_hd__decap_3
XPHY_EDGE_ROW_83_Right_83 VGND VGND VPWR VPWR sky130_fd_sc_hd__decap_3
XFILLER_106_589 VGND VGND VPWR VPWR sky130_fd_sc_hd__decap_3
XFILLER_133_364 VGND VGND VPWR VPWR sky130_fd_sc_hd__decap_3
XFILLER_79_429 VGND VGND VPWR VPWR sky130_fd_sc_hd__decap_3
X_8219_ _8624_/CLK _8219_/D load_slew647/X VGND VGND VPWR VPWR _8219_/Q sky130_fd_sc_hd__dfrtp_2
XFILLER_121_537 VGND VGND VPWR VPWR sky130_fd_sc_hd__fill_2
XFILLER_121_548 VGND VGND VPWR VPWR sky130_fd_sc_hd__decap_3
XFILLER_47_304 VGND VGND VPWR VPWR sky130_fd_sc_hd__decap_3
XFILLER_59_186 VGND VGND VPWR VPWR sky130_fd_sc_hd__fill_2
XFILLER_75_646 VGND VGND VPWR VPWR sky130_fd_sc_hd__decap_3
XTAP_TAPCELL_ROW_89_1536 VGND VPWR sky130_fd_sc_hd__tapvpwrvgnd_1
XFILLER_28_562 VGND VGND VPWR VPWR sky130_fd_sc_hd__decap_3
XFILLER_74_44 VGND VGND VPWR VPWR sky130_fd_sc_hd__fill_2
XFILLER_74_55 VGND VGND VPWR VPWR sky130_fd_sc_hd__fill_1
XFILLER_90_638 VGND VGND VPWR VPWR sky130_fd_sc_hd__fill_2
XFILLER_16_757 VGND VGND VPWR VPWR sky130_fd_sc_hd__decap_3
XFILLER_43_532 VGND VGND VPWR VPWR sky130_fd_sc_hd__decap_3
XPHY_EDGE_ROW_92_Right_92 VGND VGND VPWR VPWR sky130_fd_sc_hd__decap_3
XFILLER_130_50 VGND VGND VPWR VPWR sky130_fd_sc_hd__decap_3
XFILLER_43_576 VGND VGND VPWR VPWR sky130_fd_sc_hd__fill_2
XFILLER_70_351 VGND VGND VPWR VPWR sky130_fd_sc_hd__decap_3
XPHY_EDGE_ROW_133_Right_133 VGND VGND VPWR VPWR sky130_fd_sc_hd__decap_3
XFILLER_130_83 VGND VGND VPWR VPWR sky130_fd_sc_hd__fill_1
XFILLER_130_94 VGND VGND VPWR VPWR sky130_fd_sc_hd__decap_3
XFILLER_30_237 VGND VGND VPWR VPWR sky130_fd_sc_hd__decap_3
XFILLER_31_738 VGND VGND VPWR VPWR sky130_fd_sc_hd__decap_3
XFILLER_70_395 VGND VGND VPWR VPWR sky130_fd_sc_hd__decap_3
XFILLER_90_32 VGND VGND VPWR VPWR sky130_fd_sc_hd__decap_3
XFILLER_128_103 VGND VGND VPWR VPWR sky130_fd_sc_hd__decap_3
XFILLER_129_615 VGND VGND VPWR VPWR sky130_fd_sc_hd__fill_1
XFILLER_129_626 VGND VGND VPWR VPWR sky130_fd_sc_hd__decap_3
XFILLER_90_65 VGND VGND VPWR VPWR sky130_fd_sc_hd__fill_1
XFILLER_128_136 VGND VGND VPWR VPWR sky130_fd_sc_hd__decap_3
XFILLER_129_659 VGND VGND VPWR VPWR sky130_fd_sc_hd__decap_3
XFILLER_23_81 VGND VGND VPWR VPWR sky130_fd_sc_hd__decap_3
XFILLER_7_433 VGND VGND VPWR VPWR sky130_fd_sc_hd__decap_3
XTAP_TAPCELL_ROW_13_468 VGND VPWR sky130_fd_sc_hd__tapvpwrvgnd_1
XTAP_TAPCELL_ROW_13_479 VGND VPWR sky130_fd_sc_hd__tapvpwrvgnd_1
XFILLER_116_309 VGND VGND VPWR VPWR sky130_fd_sc_hd__decap_3
XFILLER_128_147 VGND VGND VPWR VPWR sky130_fd_sc_hd__decap_3
Xwire353 wire353/A VGND VGND VPWR VPWR _4503_/A sky130_fd_sc_hd__clkbuf_4
XFILLER_109_361 VGND VGND VPWR VPWR sky130_fd_sc_hd__decap_3
XFILLER_99_52 VGND VGND VPWR VPWR sky130_fd_sc_hd__decap_3
XFILLER_99_96 VGND VGND VPWR VPWR sky130_fd_sc_hd__decap_3
XFILLER_112_504 VGND VGND VPWR VPWR sky130_fd_sc_hd__decap_3
XFILLER_3_650 VGND VGND VPWR VPWR sky130_fd_sc_hd__decap_3
XFILLER_31_6 VGND VGND VPWR VPWR sky130_fd_sc_hd__decap_3
XFILLER_3_694 VGND VGND VPWR VPWR sky130_fd_sc_hd__decap_3
XTAP_TAPCELL_ROW_111_1843 VGND VPWR sky130_fd_sc_hd__tapvpwrvgnd_1
Xload_slew347 _4017_/S1 VGND VGND VPWR VPWR _3705_/C sky130_fd_sc_hd__buf_4
XFILLER_66_602 VGND VGND VPWR VPWR sky130_fd_sc_hd__decap_3
Xload_slew369 _3742_/B_N VGND VGND VPWR VPWR _3739_/B sky130_fd_sc_hd__clkbuf_4
Xload_slew358 _4496_/A1 VGND VGND VPWR VPWR _3984_/A sky130_fd_sc_hd__buf_4
XFILLER_66_635 VGND VGND VPWR VPWR sky130_fd_sc_hd__decap_3
XFILLER_78_473 VGND VGND VPWR VPWR sky130_fd_sc_hd__decap_3
XFILLER_93_421 VGND VGND VPWR VPWR sky130_fd_sc_hd__decap_3
XFILLER_66_657 VGND VGND VPWR VPWR sky130_fd_sc_hd__decap_3
XFILLER_0_41 VGND VGND VPWR VPWR sky130_fd_sc_hd__decap_3
XFILLER_65_178 VGND VGND VPWR VPWR sky130_fd_sc_hd__decap_3
X_5920_ _5946_/A VGND VGND VPWR VPWR _5920_/X sky130_fd_sc_hd__clkbuf_1
XFILLER_0_63 VGND VGND VPWR VPWR sky130_fd_sc_hd__decap_3
XFILLER_0_85 VGND VGND VPWR VPWR sky130_fd_sc_hd__decap_3
XFILLER_61_362 VGND VGND VPWR VPWR sky130_fd_sc_hd__decap_3
XPHY_EDGE_ROW_14_Left_150 VGND VGND VPWR VPWR sky130_fd_sc_hd__decap_3
X_5851_ _7267_/A VGND VGND VPWR VPWR _5907_/A sky130_fd_sc_hd__clkbuf_2
XFILLER_21_237 VGND VGND VPWR VPWR sky130_fd_sc_hd__fill_1
XPHY_EDGE_ROW_100_Right_100 VGND VGND VPWR VPWR sky130_fd_sc_hd__decap_3
XTAP_TAPCELL_ROW_122_1994 VGND VPWR sky130_fd_sc_hd__tapvpwrvgnd_1
X_8570_ _8732_/CLK _8570_/D fanout479/A VGND VGND VPWR VPWR _8570_/Q sky130_fd_sc_hd__dfrtp_2
X_5782_ _7930_/Q _4807_/A _5784_/S VGND VGND VPWR VPWR _5783_/A sky130_fd_sc_hd__mux2_2
X_4802_ _4802_/A _4810_/B VGND VGND VPWR VPWR _4803_/A sky130_fd_sc_hd__and2_2
XFILLER_119_103 VGND VGND VPWR VPWR sky130_fd_sc_hd__decap_3
XFILLER_21_259 VGND VGND VPWR VPWR sky130_fd_sc_hd__decap_3
XFILLER_9_72 VGND VGND VPWR VPWR sky130_fd_sc_hd__decap_3
XTAP_TAPCELL_ROW_32_744 VGND VPWR sky130_fd_sc_hd__tapvpwrvgnd_1
X_7521_ _8740_/CLK _7521_/D load_slew538/X VGND VGND VPWR VPWR _7521_/Q sky130_fd_sc_hd__dfrtp_2
X_4733_ _4733_/A VGND VGND VPWR VPWR _7507_/D sky130_fd_sc_hd__buf_1
XFILLER_119_18 VGND VGND VPWR VPWR sky130_fd_sc_hd__decap_3
X_7452_ _7452_/A VGND VGND VPWR VPWR _8782_/D sky130_fd_sc_hd__buf_1
XFILLER_119_169 VGND VGND VPWR VPWR sky130_fd_sc_hd__decap_3
X_6403_ _4777_/X hold921/X _6419_/S VGND VGND VPWR VPWR _6404_/A sky130_fd_sc_hd__mux2_1
X_4664_ _4569_/A _4662_/X _4663_/X VGND VGND VPWR VPWR _4664_/X sky130_fd_sc_hd__o21a_2
XFILLER_128_681 VGND VGND VPWR VPWR sky130_fd_sc_hd__decap_3
XFILLER_134_106 VGND VGND VPWR VPWR sky130_fd_sc_hd__decap_3
Xhold901 _7975_/Q VGND VGND VPWR VPWR hold901/X sky130_fd_sc_hd__dlygate4sd3_1
Xhold912 _8002_/Q VGND VGND VPWR VPWR hold912/X sky130_fd_sc_hd__dlygate4sd3_1
X_7383_ _7383_/A VGND VGND VPWR VPWR _8749_/D sky130_fd_sc_hd__buf_1
X_4595_ _8036_/Q _3969_/X _4594_/X VGND VGND VPWR VPWR _4595_/X sky130_fd_sc_hd__o21a_2
XFILLER_134_139 VGND VGND VPWR VPWR sky130_fd_sc_hd__fill_1
XTAP_TAPCELL_ROW_73_1315 VGND VPWR sky130_fd_sc_hd__tapvpwrvgnd_1
Xhold923 _8243_/Q VGND VGND VPWR VPWR hold923/X sky130_fd_sc_hd__dlygate4sd3_1
Xhold934 _8294_/Q VGND VGND VPWR VPWR hold934/X sky130_fd_sc_hd__dlygate4sd3_1
Xhold945 _8578_/Q VGND VGND VPWR VPWR hold945/X sky130_fd_sc_hd__dlygate4sd3_1
X_6334_ _6334_/A VGND VGND VPWR VPWR _8224_/D sky130_fd_sc_hd__buf_2
XFILLER_103_526 VGND VGND VPWR VPWR sky130_fd_sc_hd__decap_3
XFILLER_89_727 VGND VGND VPWR VPWR sky130_fd_sc_hd__fill_1
Xhold956 _8246_/Q VGND VGND VPWR VPWR hold956/X sky130_fd_sc_hd__dlygate4sd3_1
Xhold967 _8584_/Q VGND VGND VPWR VPWR hold967/X sky130_fd_sc_hd__dlygate4sd3_1
Xhold978 _8278_/Q VGND VGND VPWR VPWR hold978/X sky130_fd_sc_hd__dlygate4sd3_1
Xhold989 _7572_/Q VGND VGND VPWR VPWR hold989/X sky130_fd_sc_hd__dlygate4sd3_1
X_6265_ _6265_/A VGND VGND VPWR VPWR _8192_/D sky130_fd_sc_hd__buf_6
XFILLER_0_119 VGND VGND VPWR VPWR sky130_fd_sc_hd__decap_3
XFILLER_130_312 VGND VGND VPWR VPWR sky130_fd_sc_hd__decap_3
XFILLER_88_248 VGND VGND VPWR VPWR sky130_fd_sc_hd__decap_3
X_8004_ _8745_/CLK _8004_/D load_slew616/X VGND VGND VPWR VPWR _8004_/Q sky130_fd_sc_hd__dfrtp_2
X_5216_ _7663_/Q _4707_/X _5226_/S VGND VGND VPWR VPWR _5217_/A sky130_fd_sc_hd__mux2_2
XFILLER_88_259 VGND VGND VPWR VPWR sky130_fd_sc_hd__decap_3
X_6196_ _6196_/A VGND VGND VPWR VPWR _8159_/D sky130_fd_sc_hd__buf_6
XFILLER_28_15 VGND VGND VPWR VPWR sky130_fd_sc_hd__decap_3
XFILLER_29_337 VGND VGND VPWR VPWR sky130_fd_sc_hd__fill_2
XFILLER_57_613 VGND VGND VPWR VPWR sky130_fd_sc_hd__decap_3
XFILLER_84_421 VGND VGND VPWR VPWR sky130_fd_sc_hd__fill_2
XFILLER_96_281 VGND VGND VPWR VPWR sky130_fd_sc_hd__decap_3
XFILLER_97_782 VGND VGND VPWR VPWR sky130_fd_sc_hd__fill_2
XFILLER_97_793 VGND VGND VPWR VPWR sky130_fd_sc_hd__decap_3
X_5147_ _5147_/A VGND VGND VPWR VPWR _7631_/D sky130_fd_sc_hd__buf_1
XFILLER_57_668 VGND VGND VPWR VPWR sky130_fd_sc_hd__decap_3
XFILLER_84_432 VGND VGND VPWR VPWR sky130_fd_sc_hd__decap_3
X_5078_ _5078_/A VGND VGND VPWR VPWR _7598_/D sky130_fd_sc_hd__buf_1
XFILLER_71_104 VGND VGND VPWR VPWR sky130_fd_sc_hd__decap_3
XFILLER_84_498 VGND VGND VPWR VPWR sky130_fd_sc_hd__decap_3
X_4029_ _4027_/X _4028_/X _4129_/A VGND VGND VPWR VPWR _4029_/X sky130_fd_sc_hd__mux2_2
XFILLER_37_370 VGND VGND VPWR VPWR sky130_fd_sc_hd__fill_1
XFILLER_25_576 VGND VGND VPWR VPWR sky130_fd_sc_hd__fill_2
XFILLER_52_340 VGND VGND VPWR VPWR sky130_fd_sc_hd__fill_1
XFILLER_52_362 VGND VGND VPWR VPWR sky130_fd_sc_hd__fill_2
XTAP_TAPCELL_ROW_84_1466 VGND VPWR sky130_fd_sc_hd__tapvpwrvgnd_1
XFILLER_13_727 VGND VGND VPWR VPWR sky130_fd_sc_hd__fill_1
XFILLER_13_738 VGND VGND VPWR VPWR sky130_fd_sc_hd__decap_3
XFILLER_80_682 VGND VGND VPWR VPWR sky130_fd_sc_hd__fill_1
XFILLER_9_709 VGND VGND VPWR VPWR sky130_fd_sc_hd__decap_3
X_8768_ _8768_/CLK _8768_/D fanout567/X VGND VGND VPWR VPWR _8768_/Q sky130_fd_sc_hd__dfrtp_2
X_7719_ _8782_/CLK _7719_/D load_slew649/X VGND VGND VPWR VPWR _7719_/Q sky130_fd_sc_hd__dfrtp_2
XFILLER_100_97 VGND VGND VPWR VPWR sky130_fd_sc_hd__decap_3
XFILLER_21_782 VGND VGND VPWR VPWR sky130_fd_sc_hd__fill_2
X_8699_ _8699_/CLK _8699_/D fanout725/X VGND VGND VPWR VPWR _8699_/Q sky130_fd_sc_hd__dfrtp_2
XFILLER_126_607 VGND VGND VPWR VPWR sky130_fd_sc_hd__decap_3
XTAP_TAPCELL_ROW_10_427 VGND VPWR sky130_fd_sc_hd__tapvpwrvgnd_1
XTAP_TAPCELL_ROW_10_438 VGND VPWR sky130_fd_sc_hd__tapvpwrvgnd_1
XFILLER_109_40 VGND VGND VPWR VPWR sky130_fd_sc_hd__decap_3
XFILLER_114_3 VGND VGND VPWR VPWR sky130_fd_sc_hd__decap_3
XFILLER_119_670 VGND VGND VPWR VPWR sky130_fd_sc_hd__fill_2
XFILLER_134_651 VGND VGND VPWR VPWR sky130_fd_sc_hd__decap_3
XFILLER_4_458 VGND VGND VPWR VPWR sky130_fd_sc_hd__fill_2
XFILLER_133_161 VGND VGND VPWR VPWR sky130_fd_sc_hd__decap_3
XFILLER_134_684 VGND VGND VPWR VPWR sky130_fd_sc_hd__decap_3
XFILLER_106_397 VGND VGND VPWR VPWR sky130_fd_sc_hd__fill_1
XFILLER_133_172 VGND VGND VPWR VPWR sky130_fd_sc_hd__decap_3
XFILLER_79_237 VGND VGND VPWR VPWR sky130_fd_sc_hd__decap_3
XFILLER_0_642 VGND VGND VPWR VPWR sky130_fd_sc_hd__fill_2
XFILLER_88_760 VGND VGND VPWR VPWR sky130_fd_sc_hd__decap_3
XFILLER_0_697 VGND VGND VPWR VPWR sky130_fd_sc_hd__decap_3
XFILLER_102_581 VGND VGND VPWR VPWR sky130_fd_sc_hd__decap_3
XFILLER_121_389 VGND VGND VPWR VPWR sky130_fd_sc_hd__decap_3
XFILLER_125_72 VGND VGND VPWR VPWR sky130_fd_sc_hd__decap_3
XFILLER_47_101 VGND VGND VPWR VPWR sky130_fd_sc_hd__decap_3
XFILLER_85_43 VGND VGND VPWR VPWR sky130_fd_sc_hd__decap_3
XFILLER_94_218 VGND VGND VPWR VPWR sky130_fd_sc_hd__decap_3
XTAP_TAPCELL_ROW_126_2050 VGND VPWR sky130_fd_sc_hd__tapvpwrvgnd_1
XFILLER_47_167 VGND VGND VPWR VPWR sky130_fd_sc_hd__fill_1
XFILLER_63_638 VGND VGND VPWR VPWR sky130_fd_sc_hd__decap_3
XFILLER_75_487 VGND VGND VPWR VPWR sky130_fd_sc_hd__fill_1
XFILLER_90_402 VGND VGND VPWR VPWR sky130_fd_sc_hd__decap_3
XTAP_TAPCELL_ROW_126_2061 VGND VPWR sky130_fd_sc_hd__tapvpwrvgnd_1
XFILLER_28_370 VGND VGND VPWR VPWR sky130_fd_sc_hd__decap_3
XFILLER_90_424 VGND VGND VPWR VPWR sky130_fd_sc_hd__fill_2
XFILLER_90_435 VGND VGND VPWR VPWR sky130_fd_sc_hd__decap_3
XTAP_TAPCELL_ROW_18_538 VGND VPWR sky130_fd_sc_hd__tapvpwrvgnd_1
XTAP_TAPCELL_ROW_18_549 VGND VPWR sky130_fd_sc_hd__tapvpwrvgnd_1
XFILLER_71_671 VGND VGND VPWR VPWR sky130_fd_sc_hd__fill_1
XFILLER_16_598 VGND VGND VPWR VPWR sky130_fd_sc_hd__decap_3
XFILLER_70_192 VGND VGND VPWR VPWR sky130_fd_sc_hd__decap_3
XFILLER_129_423 VGND VGND VPWR VPWR sky130_fd_sc_hd__decap_3
XFILLER_12_760 VGND VGND VPWR VPWR sky130_fd_sc_hd__decap_3
XFILLER_8_731 VGND VGND VPWR VPWR sky130_fd_sc_hd__decap_3
XFILLER_117_607 VGND VGND VPWR VPWR sky130_fd_sc_hd__decap_3
XFILLER_11_281 VGND VGND VPWR VPWR sky130_fd_sc_hd__decap_3
XFILLER_129_467 VGND VGND VPWR VPWR sky130_fd_sc_hd__decap_3
XFILLER_12_793 VGND VGND VPWR VPWR sky130_fd_sc_hd__decap_3
XFILLER_7_230 VGND VGND VPWR VPWR sky130_fd_sc_hd__decap_3
XFILLER_8_775 VGND VGND VPWR VPWR sky130_fd_sc_hd__decap_3
XFILLER_109_191 VGND VGND VPWR VPWR sky130_fd_sc_hd__fill_2
X_4380_ _8107_/Q _8188_/Q _4402_/S VGND VGND VPWR VPWR _4380_/X sky130_fd_sc_hd__mux2_2
XFILLER_124_161 VGND VGND VPWR VPWR sky130_fd_sc_hd__decap_3
XFILLER_125_673 VGND VGND VPWR VPWR sky130_fd_sc_hd__decap_3
XFILLER_112_312 VGND VGND VPWR VPWR sky130_fd_sc_hd__decap_3
XTAP_TAPCELL_ROW_55_1056 VGND VPWR sky130_fd_sc_hd__tapvpwrvgnd_1
XTAP_TAPCELL_ROW_55_1067 VGND VPWR sky130_fd_sc_hd__tapvpwrvgnd_1
X_6050_ _6050_/A VGND VGND VPWR VPWR _8091_/D sky130_fd_sc_hd__buf_1
XFILLER_112_389 VGND VGND VPWR VPWR sky130_fd_sc_hd__decap_3
XFILLER_38_112 VGND VGND VPWR VPWR sky130_fd_sc_hd__decap_3
X_5001_ _5001_/A VGND VGND VPWR VPWR _7570_/D sky130_fd_sc_hd__buf_1
XFILLER_38_134 VGND VGND VPWR VPWR sky130_fd_sc_hd__decap_3
XFILLER_94_752 VGND VGND VPWR VPWR sky130_fd_sc_hd__decap_3
XFILLER_26_307 VGND VGND VPWR VPWR sky130_fd_sc_hd__fill_1
XFILLER_54_627 VGND VGND VPWR VPWR sky130_fd_sc_hd__decap_3
XTAP_TAPCELL_ROW_37_814 VGND VPWR sky130_fd_sc_hd__tapvpwrvgnd_1
XFILLER_81_446 VGND VGND VPWR VPWR sky130_fd_sc_hd__fill_2
X_6952_ _4841_/X _8515_/Q _6958_/S VGND VGND VPWR VPWR _6953_/A sky130_fd_sc_hd__mux2_4
X_6883_ _4703_/X _8482_/Q _6895_/S VGND VGND VPWR VPWR _6884_/A sky130_fd_sc_hd__mux2_4
X_5903_ _5906_/A1 _5906_/A2 _4757_/X _5906_/B1 hold890/X VGND VGND VPWR VPWR _7999_/D
+ sky130_fd_sc_hd__a32o_2
XFILLER_22_502 VGND VGND VPWR VPWR sky130_fd_sc_hd__fill_2
XFILLER_62_693 VGND VGND VPWR VPWR sky130_fd_sc_hd__decap_3
X_8622_ _8622_/CLK _8622_/D fanout656/A VGND VGND VPWR VPWR _8622_/Q sky130_fd_sc_hd__dfrtp_2
X_5834_ _5834_/A VGND VGND VPWR VPWR _7954_/D sky130_fd_sc_hd__buf_1
XFILLER_10_719 VGND VGND VPWR VPWR sky130_fd_sc_hd__decap_3
X_8553_ _8634_/CLK _8553_/D load_slew704/X VGND VGND VPWR VPWR _8553_/Q sky130_fd_sc_hd__dfrtp_2
X_5765_ _5849_/S VGND VGND VPWR VPWR _5784_/S sky130_fd_sc_hd__buf_2
XFILLER_108_607 VGND VGND VPWR VPWR sky130_fd_sc_hd__fill_2
X_8484_ _8646_/CLK _8484_/D wire531/X VGND VGND VPWR VPWR _8484_/Q sky130_fd_sc_hd__dfrtp_2
X_7504_ _8328_/CLK _7504_/D wire476/X VGND VGND VPWR VPWR _7504_/Q sky130_fd_sc_hd__dfrtp_2
X_5696_ _5696_/A0 _4977_/A _5700_/S VGND VGND VPWR VPWR _5697_/A sky130_fd_sc_hd__mux2_2
X_4716_ _4715_/X _4716_/A1 _4736_/S VGND VGND VPWR VPWR _4717_/A sky130_fd_sc_hd__mux2_2
XFILLER_30_38 VGND VGND VPWR VPWR sky130_fd_sc_hd__fill_1
X_7435_ _7435_/A0 _4907_/A _7449_/S VGND VGND VPWR VPWR _7436_/A sky130_fd_sc_hd__mux2_2
X_4647_ _8779_/Q _7554_/Q _4650_/S VGND VGND VPWR VPWR _4647_/X sky130_fd_sc_hd__mux2_2
X_7366_ _7366_/A VGND VGND VPWR VPWR _8741_/D sky130_fd_sc_hd__buf_1
XFILLER_116_684 VGND VGND VPWR VPWR sky130_fd_sc_hd__fill_1
XFILLER_122_109 VGND VGND VPWR VPWR sky130_fd_sc_hd__decap_3
XFILLER_89_502 VGND VGND VPWR VPWR sky130_fd_sc_hd__fill_2
Xhold764 _7990_/Q VGND VGND VPWR VPWR hold764/X sky130_fd_sc_hd__dlygate4sd3_1
X_6317_ _4945_/X hold935/X _6335_/S VGND VGND VPWR VPWR _6318_/A sky130_fd_sc_hd__mux2_1
X_4578_ _4581_/A1 _4576_/X _4577_/X VGND VGND VPWR VPWR _4578_/X sky130_fd_sc_hd__o21a_2
XFILLER_115_172 VGND VGND VPWR VPWR sky130_fd_sc_hd__decap_3
XFILLER_131_632 VGND VGND VPWR VPWR sky130_fd_sc_hd__decap_3
XFILLER_89_546 VGND VGND VPWR VPWR sky130_fd_sc_hd__decap_3
Xhold775 _8669_/Q VGND VGND VPWR VPWR hold775/X sky130_fd_sc_hd__dlygate4sd3_1
Xhold786 _8683_/Q VGND VGND VPWR VPWR hold786/X sky130_fd_sc_hd__dlygate4sd3_1
Xhold797 _7967_/Q VGND VGND VPWR VPWR hold797/X sky130_fd_sc_hd__dlygate4sd3_1
X_7297_ _7297_/A VGND VGND VPWR VPWR _8708_/D sky130_fd_sc_hd__buf_1
XFILLER_130_153 VGND VGND VPWR VPWR sky130_fd_sc_hd__decap_3
XFILLER_131_665 VGND VGND VPWR VPWR sky130_fd_sc_hd__decap_3
XFILLER_131_676 VGND VGND VPWR VPWR sky130_fd_sc_hd__decap_3
XFILLER_77_719 VGND VGND VPWR VPWR sky130_fd_sc_hd__fill_1
XFILLER_89_579 VGND VGND VPWR VPWR sky130_fd_sc_hd__decap_3
X_6248_ _6248_/A VGND VGND VPWR VPWR _8184_/D sky130_fd_sc_hd__buf_6
XFILLER_130_186 VGND VGND VPWR VPWR sky130_fd_sc_hd__decap_3
X_6179_ _6179_/A VGND VGND VPWR VPWR _8151_/D sky130_fd_sc_hd__buf_6
XFILLER_130_197 VGND VGND VPWR VPWR sky130_fd_sc_hd__decap_3
XFILLER_69_281 VGND VGND VPWR VPWR sky130_fd_sc_hd__fill_1
XFILLER_85_752 VGND VGND VPWR VPWR sky130_fd_sc_hd__decap_3
XFILLER_17_307 VGND VGND VPWR VPWR sky130_fd_sc_hd__fill_1
XFILLER_29_178 VGND VGND VPWR VPWR sky130_fd_sc_hd__decap_3
XFILLER_85_785 VGND VGND VPWR VPWR sky130_fd_sc_hd__decap_3
XFILLER_55_57 VGND VGND VPWR VPWR sky130_fd_sc_hd__decap_3
XFILLER_72_424 VGND VGND VPWR VPWR sky130_fd_sc_hd__decap_3
XFILLER_44_159 VGND VGND VPWR VPWR sky130_fd_sc_hd__fill_1
XTAP_TAPCELL_ROW_15_508 VGND VPWR sky130_fd_sc_hd__tapvpwrvgnd_1
XFILLER_111_63 VGND VGND VPWR VPWR sky130_fd_sc_hd__decap_3
XFILLER_13_535 VGND VGND VPWR VPWR sky130_fd_sc_hd__decap_3
XFILLER_111_96 VGND VGND VPWR VPWR sky130_fd_sc_hd__decap_3
XFILLER_40_354 VGND VGND VPWR VPWR sky130_fd_sc_hd__fill_2
XFILLER_40_365 VGND VGND VPWR VPWR sky130_fd_sc_hd__decap_3
XFILLER_71_89 VGND VGND VPWR VPWR sky130_fd_sc_hd__decap_3
XFILLER_40_398 VGND VGND VPWR VPWR sky130_fd_sc_hd__decap_3
XFILLER_4_200 VGND VGND VPWR VPWR sky130_fd_sc_hd__fill_1
XFILLER_5_712 VGND VGND VPWR VPWR sky130_fd_sc_hd__decap_3
XTAP_TAPCELL_ROW_97_1646 VGND VPWR sky130_fd_sc_hd__tapvpwrvgnd_1
XTAP_TAPCELL_ROW_97_1657 VGND VPWR sky130_fd_sc_hd__tapvpwrvgnd_1
XFILLER_126_448 VGND VGND VPWR VPWR sky130_fd_sc_hd__decap_3
XFILLER_5_756 VGND VGND VPWR VPWR sky130_fd_sc_hd__decap_3
XFILLER_106_150 VGND VGND VPWR VPWR sky130_fd_sc_hd__decap_3
XFILLER_134_492 VGND VGND VPWR VPWR sky130_fd_sc_hd__decap_3
XFILLER_20_71 VGND VGND VPWR VPWR sky130_fd_sc_hd__decap_3
XFILLER_121_175 VGND VGND VPWR VPWR sky130_fd_sc_hd__decap_3
XFILLER_121_186 VGND VGND VPWR VPWR sky130_fd_sc_hd__decap_3
XFILLER_96_64 VGND VGND VPWR VPWR sky130_fd_sc_hd__fill_2
XFILLER_75_251 VGND VGND VPWR VPWR sky130_fd_sc_hd__fill_2
XFILLER_75_262 VGND VGND VPWR VPWR sky130_fd_sc_hd__fill_2
XFILLER_75_273 VGND VGND VPWR VPWR sky130_fd_sc_hd__decap_3
XFILLER_63_446 VGND VGND VPWR VPWR sky130_fd_sc_hd__fill_2
XFILLER_91_755 VGND VGND VPWR VPWR sky130_fd_sc_hd__decap_3
XFILLER_91_777 VGND VGND VPWR VPWR sky130_fd_sc_hd__decap_3
XFILLER_44_693 VGND VGND VPWR VPWR sky130_fd_sc_hd__decap_3
XFILLER_91_799 VGND VGND VPWR VPWR sky130_fd_sc_hd__decap_3
XTAP_TAPCELL_ROW_106_1775 VGND VPWR sky130_fd_sc_hd__tapvpwrvgnd_1
X_3880_ _3880_/A VGND VGND VPWR VPWR _3916_/B sky130_fd_sc_hd__clkbuf_2
XTAP_TAPCELL_ROW_42_883 VGND VPWR sky130_fd_sc_hd__tapvpwrvgnd_1
XFILLER_129_220 VGND VGND VPWR VPWR sky130_fd_sc_hd__decap_3
XFILLER_129_231 VGND VGND VPWR VPWR sky130_fd_sc_hd__decap_3
X_5550_ _5550_/A VGND VGND VPWR VPWR _7820_/D sky130_fd_sc_hd__buf_1
XFILLER_129_264 VGND VGND VPWR VPWR sky130_fd_sc_hd__decap_3
X_5481_ _5481_/A VGND VGND VPWR VPWR _7788_/D sky130_fd_sc_hd__buf_1
X_4501_ _4462_/A _4490_/X _4493_/X _4496_/X _4500_/X VGND VGND VPWR VPWR _4501_/X
+ sky130_fd_sc_hd__o32a_2
X_7220_ wire234/X _4735_/X wire175/X wire205/X hold875/X VGND VGND VPWR VPWR _8652_/D
+ sky130_fd_sc_hd__a32o_2
X_4432_ _8436_/Q _8517_/Q _4435_/S VGND VGND VPWR VPWR _4432_/X sky130_fd_sc_hd__mux2_2
XFILLER_132_418 VGND VGND VPWR VPWR sky130_fd_sc_hd__fill_2
XFILLER_6_62 VGND VGND VPWR VPWR sky130_fd_sc_hd__decap_3
X_7151_ _4895_/X _8609_/Q _7151_/S VGND VGND VPWR VPWR _7152_/A sky130_fd_sc_hd__mux2_2
X_4363_ _4368_/A _4363_/B VGND VGND VPWR VPWR _4363_/X sky130_fd_sc_hd__or2_2
XFILLER_98_365 VGND VGND VPWR VPWR sky130_fd_sc_hd__decap_3
Xfanout507 fanout614/X VGND VGND VPWR VPWR fanout507/X sky130_fd_sc_hd__clkdlybuf4s25_1
Xfanout518 fanout522/X VGND VGND VPWR VPWR wire519/A sky130_fd_sc_hd__clkdlybuf4s25_1
X_7082_ _4757_/X hold919/X _7088_/S VGND VGND VPWR VPWR _7083_/A sky130_fd_sc_hd__mux2_1
X_6102_ _8116_/Q _4865_/A _6116_/S VGND VGND VPWR VPWR _6103_/A sky130_fd_sc_hd__mux2_2
X_4294_ _8586_/Q _4600_/A2 _4293_/X _3739_/B _4460_/A VGND VGND VPWR VPWR _4294_/X
+ sky130_fd_sc_hd__o221a_2
XFILLER_100_315 VGND VGND VPWR VPWR sky130_fd_sc_hd__decap_3
XFILLER_86_549 VGND VGND VPWR VPWR sky130_fd_sc_hd__decap_3
X_6033_ _6033_/A VGND VGND VPWR VPWR _8083_/D sky130_fd_sc_hd__buf_2
XFILLER_100_337 VGND VGND VPWR VPWR sky130_fd_sc_hd__decap_3
XFILLER_112_197 VGND VGND VPWR VPWR sky130_fd_sc_hd__decap_3
XFILLER_132_18 VGND VGND VPWR VPWR sky130_fd_sc_hd__decap_3
XFILLER_67_741 VGND VGND VPWR VPWR sky130_fd_sc_hd__fill_2
XFILLER_132_29 VGND VGND VPWR VPWR sky130_fd_sc_hd__decap_3
XFILLER_54_402 VGND VGND VPWR VPWR sky130_fd_sc_hd__decap_3
XFILLER_67_785 VGND VGND VPWR VPWR sky130_fd_sc_hd__decap_3
XFILLER_82_722 VGND VGND VPWR VPWR sky130_fd_sc_hd__decap_3
XTAP_TAPCELL_ROW_68_1247 VGND VPWR sky130_fd_sc_hd__tapvpwrvgnd_1
X_7984_ _8804_/CLK _7984_/D load_slew499/X VGND VGND VPWR VPWR _7984_/Q sky130_fd_sc_hd__dfrtp_2
XFILLER_25_27 VGND VGND VPWR VPWR sky130_fd_sc_hd__decap_3
XFILLER_54_468 VGND VGND VPWR VPWR sky130_fd_sc_hd__decap_3
XFILLER_81_265 VGND VGND VPWR VPWR sky130_fd_sc_hd__decap_3
X_6935_ _4807_/X _8507_/Q _6937_/S VGND VGND VPWR VPWR _6936_/A sky130_fd_sc_hd__mux2_4
XTAP_TAPCELL_ROW_81_1425 VGND VPWR sky130_fd_sc_hd__tapvpwrvgnd_1
XFILLER_22_321 VGND VGND VPWR VPWR sky130_fd_sc_hd__decap_3
XFILLER_34_192 VGND VGND VPWR VPWR sky130_fd_sc_hd__decap_3
X_6866_ _5011_/X _8474_/Q _6874_/S VGND VGND VPWR VPWR _6867_/A sky130_fd_sc_hd__mux2_4
XFILLER_22_365 VGND VGND VPWR VPWR sky130_fd_sc_hd__decap_3
XFILLER_50_685 VGND VGND VPWR VPWR sky130_fd_sc_hd__fill_1
X_8605_ _8689_/CLK _8605_/D fanout553/X VGND VGND VPWR VPWR _8605_/Q sky130_fd_sc_hd__dfrtp_2
X_6797_ _8442_/Q _4874_/A _6807_/S VGND VGND VPWR VPWR _6798_/A sky130_fd_sc_hd__mux2_2
X_5817_ _5817_/A VGND VGND VPWR VPWR _7946_/D sky130_fd_sc_hd__buf_1
XFILLER_41_48 VGND VGND VPWR VPWR sky130_fd_sc_hd__decap_3
XFILLER_6_509 VGND VGND VPWR VPWR sky130_fd_sc_hd__fill_2
X_8536_ _8700_/CLK _8536_/D fanout753/X VGND VGND VPWR VPWR _8536_/Q sky130_fd_sc_hd__dfrtp_2
X_5748_ _5748_/A VGND VGND VPWR VPWR _7913_/D sky130_fd_sc_hd__buf_1
XTAP_TAPCELL_ROW_20_566 VGND VPWR sky130_fd_sc_hd__tapvpwrvgnd_1
XTAP_TAPCELL_ROW_20_577 VGND VPWR sky130_fd_sc_hd__tapvpwrvgnd_1
X_8467_ _8545_/CLK _8467_/D load_slew661/X VGND VGND VPWR VPWR _8467_/Q sky130_fd_sc_hd__dfrtp_2
X_5679_ _6314_/A _8049_/Q _6314_/C _5679_/D VGND VGND VPWR VPWR _5680_/A sky130_fd_sc_hd__and4b_2
XFILLER_135_256 VGND VGND VPWR VPWR sky130_fd_sc_hd__decap_3
XFILLER_2_704 VGND VGND VPWR VPWR sky130_fd_sc_hd__decap_3
XTAP_TAPCELL_ROW_79_1398 VGND VPWR sky130_fd_sc_hd__tapvpwrvgnd_1
X_8398_ _8560_/CLK _8398_/D fanout544/X VGND VGND VPWR VPWR _8398_/Q sky130_fd_sc_hd__dfrtp_2
X_7418_ _8766_/Q _4874_/A _7428_/S VGND VGND VPWR VPWR _7419_/A sky130_fd_sc_hd__mux2_2
XFILLER_104_610 VGND VGND VPWR VPWR sky130_fd_sc_hd__fill_1
XFILLER_104_632 VGND VGND VPWR VPWR sky130_fd_sc_hd__decap_3
XFILLER_1_225 VGND VGND VPWR VPWR sky130_fd_sc_hd__decap_3
XFILLER_2_737 VGND VGND VPWR VPWR sky130_fd_sc_hd__decap_3
XFILLER_89_321 VGND VGND VPWR VPWR sky130_fd_sc_hd__decap_3
XFILLER_9_6 VGND VGND VPWR VPWR sky130_fd_sc_hd__decap_3
X_7349_ _8733_/Q _4734_/A _7365_/S VGND VGND VPWR VPWR _7350_/A sky130_fd_sc_hd__mux2_2
XFILLER_77_505 VGND VGND VPWR VPWR sky130_fd_sc_hd__decap_3
XFILLER_89_343 VGND VGND VPWR VPWR sky130_fd_sc_hd__decap_3
XFILLER_89_365 VGND VGND VPWR VPWR sky130_fd_sc_hd__decap_3
XTAP_TAPCELL_ROW_92_1576 VGND VPWR sky130_fd_sc_hd__tapvpwrvgnd_1
XTAP_TAPCELL_ROW_92_1587 VGND VPWR sky130_fd_sc_hd__tapvpwrvgnd_1
XFILLER_103_164 VGND VGND VPWR VPWR sky130_fd_sc_hd__decap_3
XFILLER_103_175 VGND VGND VPWR VPWR sky130_fd_sc_hd__decap_3
XFILLER_106_41 VGND VGND VPWR VPWR sky130_fd_sc_hd__decap_3
XFILLER_131_473 VGND VGND VPWR VPWR sky130_fd_sc_hd__decap_3
XFILLER_106_96 VGND VGND VPWR VPWR sky130_fd_sc_hd__fill_1
XFILLER_18_616 VGND VGND VPWR VPWR sky130_fd_sc_hd__decap_3
XFILLER_45_435 VGND VGND VPWR VPWR sky130_fd_sc_hd__decap_3
XTAP_TAPCELL_ROW_123_2020 VGND VPWR sky130_fd_sc_hd__tapvpwrvgnd_1
Xclkbuf_4_9_0_CLK clkbuf_0_CLK/X VGND VGND VPWR VPWR clkbuf_4_9_0_CLK/X sky130_fd_sc_hd__clkbuf_8
XFILLER_26_660 VGND VGND VPWR VPWR sky130_fd_sc_hd__decap_3
XFILLER_26_693 VGND VGND VPWR VPWR sky130_fd_sc_hd__fill_2
XFILLER_72_265 VGND VGND VPWR VPWR sky130_fd_sc_hd__decap_3
XFILLER_72_287 VGND VGND VPWR VPWR sky130_fd_sc_hd__decap_3
XTAP_TAPCELL_ROW_0_280 VGND VPWR sky130_fd_sc_hd__tapvpwrvgnd_1
XTAP_TAPCELL_ROW_28_688 VGND VPWR sky130_fd_sc_hd__tapvpwrvgnd_1
XFILLER_13_332 VGND VGND VPWR VPWR sky130_fd_sc_hd__decap_3
XFILLER_41_652 VGND VGND VPWR VPWR sky130_fd_sc_hd__decap_3
XFILLER_82_77 VGND VGND VPWR VPWR sky130_fd_sc_hd__decap_3
XFILLER_82_88 VGND VGND VPWR VPWR sky130_fd_sc_hd__decap_3
XTAP_TAPCELL_ROW_0_291 VGND VPWR sky130_fd_sc_hd__tapvpwrvgnd_1
XFILLER_15_60 VGND VGND VPWR VPWR sky130_fd_sc_hd__decap_3
XFILLER_15_93 VGND VGND VPWR VPWR sky130_fd_sc_hd__fill_2
XFILLER_41_685 VGND VGND VPWR VPWR sky130_fd_sc_hd__decap_3
XFILLER_9_314 VGND VGND VPWR VPWR sky130_fd_sc_hd__decap_3
XFILLER_40_195 VGND VGND VPWR VPWR sky130_fd_sc_hd__fill_1
XFILLER_127_724 VGND VGND VPWR VPWR sky130_fd_sc_hd__decap_3
XFILLER_127_735 VGND VGND VPWR VPWR sky130_fd_sc_hd__decap_3
XFILLER_127_768 VGND VGND VPWR VPWR sky130_fd_sc_hd__decap_3
XTAP_TAPCELL_ROW_134_2171 VGND VPWR sky130_fd_sc_hd__tapvpwrvgnd_1
XTAP_TAPCELL_ROW_52_1015 VGND VPWR sky130_fd_sc_hd__tapvpwrvgnd_1
XFILLER_110_602 VGND VGND VPWR VPWR sky130_fd_sc_hd__decap_3
XFILLER_68_527 VGND VGND VPWR VPWR sky130_fd_sc_hd__decap_3
XTAP_TAPCELL_ROW_52_1026 VGND VPWR sky130_fd_sc_hd__tapvpwrvgnd_1
Xoutput92 _3954_/X VGND VGND VPWR VPWR rdata[14] sky130_fd_sc_hd__clkdlybuf4s25_1
XFILLER_110_657 VGND VGND VPWR VPWR sky130_fd_sc_hd__decap_3
XFILLER_95_357 VGND VGND VPWR VPWR sky130_fd_sc_hd__fill_1
XFILLER_76_560 VGND VGND VPWR VPWR sky130_fd_sc_hd__decap_3
XFILLER_83_508 VGND VGND VPWR VPWR sky130_fd_sc_hd__decap_3
XFILLER_95_379 VGND VGND VPWR VPWR sky130_fd_sc_hd__decap_3
XTAP_TAPCELL_ROW_108_1804 VGND VPWR sky130_fd_sc_hd__tapvpwrvgnd_1
XFILLER_48_273 VGND VGND VPWR VPWR sky130_fd_sc_hd__decap_3
XFILLER_63_221 VGND VGND VPWR VPWR sky130_fd_sc_hd__decap_3
XTAP_TAPCELL_ROW_47_953 VGND VPWR sky130_fd_sc_hd__tapvpwrvgnd_1
XFILLER_17_660 VGND VGND VPWR VPWR sky130_fd_sc_hd__decap_3
XFILLER_17_682 VGND VGND VPWR VPWR sky130_fd_sc_hd__decap_3
XFILLER_51_438 VGND VGND VPWR VPWR sky130_fd_sc_hd__fill_2
X_4981_ _4981_/A VGND VGND VPWR VPWR _4981_/X sky130_fd_sc_hd__buf_1
X_3932_ _8715_/Q _8796_/Q _4454_/S VGND VGND VPWR VPWR _3933_/B sky130_fd_sc_hd__mux2_2
X_6720_ _6720_/A VGND VGND VPWR VPWR _8405_/D sky130_fd_sc_hd__buf_2
XTAP_TAPCELL_ROW_63_1177 VGND VPWR sky130_fd_sc_hd__tapvpwrvgnd_1
X_3863_ _8304_/Q _3939_/A _4065_/A _8223_/Q _3890_/A VGND VGND VPWR VPWR _3863_/X
+ sky130_fd_sc_hd__o221a_2
X_6651_ _6651_/A VGND VGND VPWR VPWR _8374_/D sky130_fd_sc_hd__buf_2
XFILLER_31_162 VGND VGND VPWR VPWR sky130_fd_sc_hd__decap_3
X_6582_ _6582_/A VGND VGND VPWR VPWR _8341_/D sky130_fd_sc_hd__buf_2
X_5602_ _7845_/Q _4791_/A _5612_/S VGND VGND VPWR VPWR _5603_/A sky130_fd_sc_hd__mux2_2
XFILLER_118_724 VGND VGND VPWR VPWR sky130_fd_sc_hd__decap_3
X_3794_ _8056_/Q _8137_/Q _8218_/Q _8299_/Q _3845_/S _3849_/S1 VGND VGND VPWR VPWR
+ _3794_/X sky130_fd_sc_hd__mux4_2
X_8321_ _8645_/CLK _8321_/D load_slew501/X VGND VGND VPWR VPWR _8321_/Q sky130_fd_sc_hd__dfrtp_2
X_5533_ _7812_/Q _4995_/A _5549_/S VGND VGND VPWR VPWR _5534_/A sky130_fd_sc_hd__mux2_2
XFILLER_117_223 VGND VGND VPWR VPWR sky130_fd_sc_hd__fill_1
XFILLER_118_746 VGND VGND VPWR VPWR sky130_fd_sc_hd__decap_3
XFILLER_118_757 VGND VGND VPWR VPWR sky130_fd_sc_hd__decap_3
XFILLER_11_18 VGND VGND VPWR VPWR sky130_fd_sc_hd__decap_3
XTAP_TAPCELL_ROW_119_1955 VGND VPWR sky130_fd_sc_hd__tapvpwrvgnd_1
XFILLER_127_18 VGND VGND VPWR VPWR sky130_fd_sc_hd__decap_3
XFILLER_133_727 VGND VGND VPWR VPWR sky130_fd_sc_hd__fill_1
X_8252_ _8495_/CLK _8252_/D load_slew515/X VGND VGND VPWR VPWR _8252_/Q sky130_fd_sc_hd__dfrtp_2
X_5464_ _7780_/Q _4856_/A _5482_/S VGND VGND VPWR VPWR _5465_/A sky130_fd_sc_hd__mux2_2
XFILLER_126_790 VGND VGND VPWR VPWR sky130_fd_sc_hd__decap_3
XFILLER_132_215 VGND VGND VPWR VPWR sky130_fd_sc_hd__decap_3
XFILLER_133_738 VGND VGND VPWR VPWR sky130_fd_sc_hd__decap_3
X_8183_ _8782_/CLK _8183_/D load_slew642/X VGND VGND VPWR VPWR _8183_/Q sky130_fd_sc_hd__dfrtp_2
X_7203_ _7202_/X _5027_/X _7191_/X wire207/X hold798/X VGND VGND VPWR VPWR _8640_/D
+ sky130_fd_sc_hd__a32o_2
X_5395_ _5395_/A VGND VGND VPWR VPWR _7747_/D sky130_fd_sc_hd__buf_1
X_4415_ _4415_/A _4415_/B VGND VGND VPWR VPWR _4415_/X sky130_fd_sc_hd__or2_2
XFILLER_132_248 VGND VGND VPWR VPWR sky130_fd_sc_hd__decap_3
XFILLER_132_259 VGND VGND VPWR VPWR sky130_fd_sc_hd__decap_3
XFILLER_99_641 VGND VGND VPWR VPWR sky130_fd_sc_hd__decap_3
X_7134_ _7134_/A VGND VGND VPWR VPWR _8600_/D sky130_fd_sc_hd__buf_2
X_4346_ _7770_/Q _7851_/Q _7932_/Q _8013_/Q _4352_/S _4368_/A VGND VGND VPWR VPWR
+ _4346_/X sky130_fd_sc_hd__mux4_2
XFILLER_86_313 VGND VGND VPWR VPWR sky130_fd_sc_hd__decap_3
Xfanout337 _4158_/A VGND VGND VPWR VPWR _4110_/S1 sky130_fd_sc_hd__clkdlybuf4s25_1
Xfanout348 _4524_/S1 VGND VGND VPWR VPWR _4039_/S1 sky130_fd_sc_hd__clkdlybuf4s25_1
XFILLER_98_184 VGND VGND VPWR VPWR sky130_fd_sc_hd__decap_3
Xfanout359 _4013_/A1 VGND VGND VPWR VPWR _3958_/A sky130_fd_sc_hd__clkdlybuf4s25_1
X_7065_ _4723_/X hold925/X _7067_/S VGND VGND VPWR VPWR _7066_/A sky130_fd_sc_hd__mux2_1
X_4277_ _4313_/A1 _4268_/X _4271_/X _4276_/X VGND VGND VPWR VPWR _4277_/X sky130_fd_sc_hd__o31a_2
XFILLER_39_251 VGND VGND VPWR VPWR sky130_fd_sc_hd__decap_3
XFILLER_86_368 VGND VGND VPWR VPWR sky130_fd_sc_hd__fill_1
X_6016_ _8075_/Q _5035_/A _6032_/S VGND VGND VPWR VPWR _6017_/A sky130_fd_sc_hd__mux2_2
XFILLER_27_424 VGND VGND VPWR VPWR sky130_fd_sc_hd__decap_3
XFILLER_39_284 VGND VGND VPWR VPWR sky130_fd_sc_hd__fill_2
XFILLER_55_755 VGND VGND VPWR VPWR sky130_fd_sc_hd__fill_2
XFILLER_55_777 VGND VGND VPWR VPWR sky130_fd_sc_hd__decap_3
XPHY_EDGE_ROW_6_Left_142 VGND VGND VPWR VPWR sky130_fd_sc_hd__decap_3
XFILLER_54_265 VGND VGND VPWR VPWR sky130_fd_sc_hd__decap_3
XFILLER_70_725 VGND VGND VPWR VPWR sky130_fd_sc_hd__decap_3
X_7967_ _8623_/CLK _7967_/D load_slew676/X VGND VGND VPWR VPWR _7967_/Q sky130_fd_sc_hd__dfrtp_2
XFILLER_35_490 VGND VGND VPWR VPWR sky130_fd_sc_hd__fill_2
XTAP_TAPCELL_ROW_25_636 VGND VPWR sky130_fd_sc_hd__tapvpwrvgnd_1
XTAP_TAPCELL_ROW_25_647 VGND VPWR sky130_fd_sc_hd__tapvpwrvgnd_1
X_7898_ _8639_/CLK _7898_/D wire603/X VGND VGND VPWR VPWR _7898_/Q sky130_fd_sc_hd__dfrtp_2
X_6918_ _7002_/S VGND VGND VPWR VPWR _6937_/S sky130_fd_sc_hd__buf_6
XFILLER_11_803 VGND VGND VPWR VPWR sky130_fd_sc_hd__fill_1
XFILLER_52_47 VGND VGND VPWR VPWR sky130_fd_sc_hd__decap_3
X_6849_ _4977_/X _8466_/Q _6853_/S VGND VGND VPWR VPWR _6850_/A sky130_fd_sc_hd__mux2_4
XFILLER_10_346 VGND VGND VPWR VPWR sky130_fd_sc_hd__decap_3
XFILLER_10_368 VGND VGND VPWR VPWR sky130_fd_sc_hd__decap_3
XFILLER_22_195 VGND VGND VPWR VPWR sky130_fd_sc_hd__fill_1
XFILLER_108_223 VGND VGND VPWR VPWR sky130_fd_sc_hd__decap_3
XTAP_TAPCELL_ROW_94_1605 VGND VPWR sky130_fd_sc_hd__tapvpwrvgnd_1
X_8519_ _8685_/CLK _8519_/D fanout575/X VGND VGND VPWR VPWR _8519_/Q sky130_fd_sc_hd__dfrtp_2
XFILLER_108_267 VGND VGND VPWR VPWR sky130_fd_sc_hd__decap_3
XFILLER_77_11 VGND VGND VPWR VPWR sky130_fd_sc_hd__decap_3
XFILLER_7_3 VGND VGND VPWR VPWR sky130_fd_sc_hd__decap_3
XFILLER_104_462 VGND VGND VPWR VPWR sky130_fd_sc_hd__decap_3
XFILLER_117_84 VGND VGND VPWR VPWR sky130_fd_sc_hd__decap_3
XFILLER_132_760 VGND VGND VPWR VPWR sky130_fd_sc_hd__decap_3
XFILLER_132_793 VGND VGND VPWR VPWR sky130_fd_sc_hd__decap_3
XFILLER_131_281 VGND VGND VPWR VPWR sky130_fd_sc_hd__decap_3
XFILLER_65_508 VGND VGND VPWR VPWR sky130_fd_sc_hd__decap_3
XFILLER_77_357 VGND VGND VPWR VPWR sky130_fd_sc_hd__decap_3
XTAP_TAPCELL_ROW_5_361 VGND VPWR sky130_fd_sc_hd__tapvpwrvgnd_1
XFILLER_133_72 VGND VGND VPWR VPWR sky130_fd_sc_hd__decap_3
XFILLER_18_424 VGND VGND VPWR VPWR sky130_fd_sc_hd__decap_3
XFILLER_46_722 VGND VGND VPWR VPWR sky130_fd_sc_hd__decap_3
XFILLER_92_338 VGND VGND VPWR VPWR sky130_fd_sc_hd__decap_3
XFILLER_93_32 VGND VGND VPWR VPWR sky130_fd_sc_hd__decap_3
XFILLER_18_468 VGND VGND VPWR VPWR sky130_fd_sc_hd__decap_3
XFILLER_45_221 VGND VGND VPWR VPWR sky130_fd_sc_hd__decap_3
XFILLER_61_703 VGND VGND VPWR VPWR sky130_fd_sc_hd__decap_3
XFILLER_73_541 VGND VGND VPWR VPWR sky130_fd_sc_hd__decap_3
XFILLER_33_427 VGND VGND VPWR VPWR sky130_fd_sc_hd__decap_3
XFILLER_45_265 VGND VGND VPWR VPWR sky130_fd_sc_hd__decap_3
XTAP_TAPCELL_ROW_44_912 VGND VPWR sky130_fd_sc_hd__tapvpwrvgnd_1
XFILLER_33_449 VGND VGND VPWR VPWR sky130_fd_sc_hd__decap_3
XFILLER_61_747 VGND VGND VPWR VPWR sky130_fd_sc_hd__decap_3
XTAP_TAPCELL_ROW_103_1734 VGND VPWR sky130_fd_sc_hd__tapvpwrvgnd_1
XFILLER_9_111 VGND VGND VPWR VPWR sky130_fd_sc_hd__fill_1
XFILLER_127_532 VGND VGND VPWR VPWR sky130_fd_sc_hd__decap_3
XFILLER_127_576 VGND VGND VPWR VPWR sky130_fd_sc_hd__decap_3
XFILLER_5_361 VGND VGND VPWR VPWR sky130_fd_sc_hd__decap_3
XFILLER_130_719 VGND VGND VPWR VPWR sky130_fd_sc_hd__decap_3
XFILLER_69_803 VGND VGND VPWR VPWR sky130_fd_sc_hd__fill_1
X_4200_ _8739_/Q _7514_/Q _7595_/Q _7676_/Q _4193_/S _4158_/A VGND VGND VPWR VPWR
+ _4200_/X sky130_fd_sc_hd__mux4_2
XFILLER_123_771 VGND VGND VPWR VPWR sky130_fd_sc_hd__decap_3
XFILLER_3_30 VGND VGND VPWR VPWR sky130_fd_sc_hd__decap_3
XFILLER_96_622 VGND VGND VPWR VPWR sky130_fd_sc_hd__fill_1
XTAP_TAPCELL_ROW_114_1885 VGND VPWR sky130_fd_sc_hd__tapvpwrvgnd_1
X_5180_ _7646_/Q _4977_/X _5184_/S VGND VGND VPWR VPWR _5181_/A sky130_fd_sc_hd__mux2_2
XFILLER_3_63 VGND VGND VPWR VPWR sky130_fd_sc_hd__decap_3
X_4131_ _3828_/X _4130_/X _4545_/B1 VGND VGND VPWR VPWR _4131_/X sky130_fd_sc_hd__o21a_2
XFILLER_3_96 VGND VGND VPWR VPWR sky130_fd_sc_hd__decap_3
XFILLER_96_699 VGND VGND VPWR VPWR sky130_fd_sc_hd__fill_1
X_4062_ _4146_/A _4062_/B VGND VGND VPWR VPWR _4062_/X sky130_fd_sc_hd__or2_2
XFILLER_37_722 VGND VGND VPWR VPWR sky130_fd_sc_hd__decap_3
XFILLER_83_316 VGND VGND VPWR VPWR sky130_fd_sc_hd__fill_2
XFILLER_95_187 VGND VGND VPWR VPWR sky130_fd_sc_hd__decap_3
XFILLER_37_799 VGND VGND VPWR VPWR sky130_fd_sc_hd__decap_3
XTAP_TAPCELL_ROW_65_1206 VGND VPWR sky130_fd_sc_hd__tapvpwrvgnd_1
X_7821_ _8731_/CLK _7821_/D load_slew496/X VGND VGND VPWR VPWR _7821_/Q sky130_fd_sc_hd__dfrtp_2
XFILLER_91_393 VGND VGND VPWR VPWR sky130_fd_sc_hd__decap_3
X_7752_ _8660_/CLK _7752_/D load_slew524/X VGND VGND VPWR VPWR _7752_/Q sky130_fd_sc_hd__dfrtp_2
X_4964_ _4964_/A _4984_/B VGND VGND VPWR VPWR _4965_/A sky130_fd_sc_hd__and2_2
XFILLER_32_460 VGND VGND VPWR VPWR sky130_fd_sc_hd__decap_3
XFILLER_51_268 VGND VGND VPWR VPWR sky130_fd_sc_hd__fill_1
XTAP_TAPCELL_ROW_22_606 VGND VPWR sky130_fd_sc_hd__tapvpwrvgnd_1
X_3915_ _4083_/C1 _3905_/X _3908_/X _3914_/X VGND VGND VPWR VPWR _3915_/X sky130_fd_sc_hd__o31a_2
X_6703_ _6703_/A VGND VGND VPWR VPWR _8397_/D sky130_fd_sc_hd__buf_2
X_7683_ _8740_/CLK _7683_/D load_slew526/X VGND VGND VPWR VPWR _7683_/Q sky130_fd_sc_hd__dfrtp_2
X_4895_ _4895_/A VGND VGND VPWR VPWR _4895_/X sky130_fd_sc_hd__buf_1
XFILLER_22_17 VGND VGND VPWR VPWR sky130_fd_sc_hd__decap_3
X_3846_ _7645_/Q _4326_/B _3805_/A _7564_/Q _3732_/A VGND VGND VPWR VPWR _3846_/X
+ sky130_fd_sc_hd__o221a_2
X_6634_ _6634_/A VGND VGND VPWR VPWR _8366_/D sky130_fd_sc_hd__buf_2
XFILLER_118_510 VGND VGND VPWR VPWR sky130_fd_sc_hd__decap_3
X_3777_ _8298_/Q _3774_/X _4645_/B1 _8217_/Q _4677_/C1 VGND VGND VPWR VPWR _3777_/X
+ sky130_fd_sc_hd__o221a_2
X_6565_ _6565_/A VGND VGND VPWR VPWR _8333_/D sky130_fd_sc_hd__buf_2
X_8304_ _8547_/CLK _8304_/D fanout650/X VGND VGND VPWR VPWR _8304_/Q sky130_fd_sc_hd__dfrtp_2
X_6496_ _6496_/A VGND VGND VPWR VPWR _8300_/D sky130_fd_sc_hd__buf_2
X_5516_ _7804_/Q _4961_/A _5528_/S VGND VGND VPWR VPWR _5517_/A sky130_fd_sc_hd__mux2_2
XFILLER_133_535 VGND VGND VPWR VPWR sky130_fd_sc_hd__decap_3
XTAP_TAPCELL_ROW_76_1357 VGND VPWR sky130_fd_sc_hd__tapvpwrvgnd_1
X_8235_ _8335_/CLK _8235_/D load_slew541/X VGND VGND VPWR VPWR _8235_/Q sky130_fd_sc_hd__dfrtp_2
X_5447_ _7772_/Q _4823_/A _5461_/S VGND VGND VPWR VPWR _5448_/A sky130_fd_sc_hd__mux2_2
XFILLER_114_782 VGND VGND VPWR VPWR sky130_fd_sc_hd__fill_1
XFILLER_120_218 VGND VGND VPWR VPWR sky130_fd_sc_hd__decap_3
XFILLER_121_719 VGND VGND VPWR VPWR sky130_fd_sc_hd__decap_3
XFILLER_133_579 VGND VGND VPWR VPWR sky130_fd_sc_hd__decap_3
XFILLER_87_600 VGND VGND VPWR VPWR sky130_fd_sc_hd__decap_3
X_8166_ _8733_/CLK _8166_/D fanout507/X VGND VGND VPWR VPWR _8166_/Q sky130_fd_sc_hd__dfrtp_2
X_5378_ _5378_/A VGND VGND VPWR VPWR _7739_/D sky130_fd_sc_hd__buf_1
XFILLER_101_421 VGND VGND VPWR VPWR sky130_fd_sc_hd__decap_3
XFILLER_113_281 VGND VGND VPWR VPWR sky130_fd_sc_hd__decap_3
XFILLER_59_346 VGND VGND VPWR VPWR sky130_fd_sc_hd__decap_3
XFILLER_99_482 VGND VGND VPWR VPWR sky130_fd_sc_hd__decap_3
X_8097_ _8583_/CLK _8097_/D wire618/X VGND VGND VPWR VPWR _8097_/Q sky130_fd_sc_hd__dfrtp_2
X_7117_ _7117_/A VGND VGND VPWR VPWR _8592_/D sky130_fd_sc_hd__buf_2
X_4329_ _8103_/Q _8184_/Q _4680_/S VGND VGND VPWR VPWR _4330_/B sky130_fd_sc_hd__mux2_2
XFILLER_74_305 VGND VGND VPWR VPWR sky130_fd_sc_hd__decap_3
XFILLER_86_165 VGND VGND VPWR VPWR sky130_fd_sc_hd__decap_3
X_7048_ _7174_/S VGND VGND VPWR VPWR _7067_/S sky130_fd_sc_hd__buf_4
XFILLER_74_316 VGND VGND VPWR VPWR sky130_fd_sc_hd__decap_3
XPHY_EDGE_ROW_114_Right_114 VGND VGND VPWR VPWR sky130_fd_sc_hd__decap_3
XTAP_TAPCELL_ROW_2_320 VGND VPWR sky130_fd_sc_hd__tapvpwrvgnd_1
XFILLER_103_75 VGND VGND VPWR VPWR sky130_fd_sc_hd__decap_3
XFILLER_27_254 VGND VGND VPWR VPWR sky130_fd_sc_hd__decap_3
XFILLER_63_57 VGND VGND VPWR VPWR sky130_fd_sc_hd__decap_3
XFILLER_30_419 VGND VGND VPWR VPWR sky130_fd_sc_hd__fill_1
XFILLER_128_318 VGND VGND VPWR VPWR sky130_fd_sc_hd__decap_3
XFILLER_50_290 VGND VGND VPWR VPWR sky130_fd_sc_hd__decap_3
XFILLER_10_165 VGND VGND VPWR VPWR sky130_fd_sc_hd__decap_3
XFILLER_11_688 VGND VGND VPWR VPWR sky130_fd_sc_hd__decap_3
XFILLER_7_626 VGND VGND VPWR VPWR sky130_fd_sc_hd__decap_3
XFILLER_12_50 VGND VGND VPWR VPWR sky130_fd_sc_hd__decap_3
XFILLER_7_659 VGND VGND VPWR VPWR sky130_fd_sc_hd__decap_3
XFILLER_109_598 VGND VGND VPWR VPWR sky130_fd_sc_hd__decap_3
XFILLER_128_50 VGND VGND VPWR VPWR sky130_fd_sc_hd__decap_3
XFILLER_12_83 VGND VGND VPWR VPWR sky130_fd_sc_hd__fill_1
XTAP_TAPCELL_ROW_131_2130 VGND VPWR sky130_fd_sc_hd__tapvpwrvgnd_1
XFILLER_124_557 VGND VGND VPWR VPWR sky130_fd_sc_hd__decap_3
XFILLER_128_83 VGND VGND VPWR VPWR sky130_fd_sc_hd__fill_1
XFILLER_128_94 VGND VGND VPWR VPWR sky130_fd_sc_hd__decap_3
Xload_slew529 fanout528/X VGND VGND VPWR VPWR load_slew529/X sky130_fd_sc_hd__clkbuf_4
XFILLER_104_292 VGND VGND VPWR VPWR sky130_fd_sc_hd__decap_3
XFILLER_26_9 VGND VGND VPWR VPWR sky130_fd_sc_hd__decap_3
XFILLER_78_666 VGND VGND VPWR VPWR sky130_fd_sc_hd__decap_3
XPHY_EDGE_ROW_69_Left_205 VGND VGND VPWR VPWR sky130_fd_sc_hd__decap_3
XFILLER_77_187 VGND VGND VPWR VPWR sky130_fd_sc_hd__decap_3
XTAP_TAPCELL_ROW_129_2092 VGND VPWR sky130_fd_sc_hd__tapvpwrvgnd_1
Xfanout690 wire693/A VGND VGND VPWR VPWR fanout690/X sky130_fd_sc_hd__clkdlybuf4s25_1
XFILLER_19_755 VGND VGND VPWR VPWR sky130_fd_sc_hd__decap_3
XFILLER_37_91 VGND VGND VPWR VPWR sky130_fd_sc_hd__decap_3
XFILLER_46_585 VGND VGND VPWR VPWR sky130_fd_sc_hd__decap_3
XFILLER_61_500 VGND VGND VPWR VPWR sky130_fd_sc_hd__decap_3
XFILLER_18_287 VGND VGND VPWR VPWR sky130_fd_sc_hd__decap_3
XFILLER_73_393 VGND VGND VPWR VPWR sky130_fd_sc_hd__decap_3
XFILLER_21_408 VGND VGND VPWR VPWR sky130_fd_sc_hd__decap_3
XFILLER_33_257 VGND VGND VPWR VPWR sky130_fd_sc_hd__fill_1
XFILLER_61_588 VGND VGND VPWR VPWR sky130_fd_sc_hd__decap_3
XFILLER_53_90 VGND VGND VPWR VPWR sky130_fd_sc_hd__fill_1
XPHY_EDGE_ROW_78_Left_214 VGND VGND VPWR VPWR sky130_fd_sc_hd__decap_3
XFILLER_41_290 VGND VGND VPWR VPWR sky130_fd_sc_hd__decap_3
XTAP_TAPCELL_ROW_60_1136 VGND VPWR sky130_fd_sc_hd__tapvpwrvgnd_1
X_4680_ _8134_/Q _8215_/Q _4680_/S VGND VGND VPWR VPWR _4681_/B sky130_fd_sc_hd__mux2_2
XFILLER_119_329 VGND VGND VPWR VPWR sky130_fd_sc_hd__decap_3
XFILLER_127_340 VGND VGND VPWR VPWR sky130_fd_sc_hd__fill_1
XTAP_TAPCELL_ROW_116_1914 VGND VPWR sky130_fd_sc_hd__tapvpwrvgnd_1
X_6350_ _5015_/X _8232_/Q _6356_/S VGND VGND VPWR VPWR _6351_/A sky130_fd_sc_hd__mux2_2
XFILLER_127_362 VGND VGND VPWR VPWR sky130_fd_sc_hd__decap_3
XFILLER_6_681 VGND VGND VPWR VPWR sky130_fd_sc_hd__decap_3
X_5301_ _5301_/A VGND VGND VPWR VPWR _7703_/D sky130_fd_sc_hd__buf_1
X_6281_ _4879_/X _8200_/Q _6289_/S VGND VGND VPWR VPWR _6282_/A sky130_fd_sc_hd__mux2_4
XFILLER_115_579 VGND VGND VPWR VPWR sky130_fd_sc_hd__decap_3
XFILLER_130_516 VGND VGND VPWR VPWR sky130_fd_sc_hd__decap_3
XTAP_TAPCELL_ROW_58_1098 VGND VPWR sky130_fd_sc_hd__tapvpwrvgnd_1
X_8020_ _8759_/CLK _8020_/D fanout708/X VGND VGND VPWR VPWR _8020_/Q sky130_fd_sc_hd__dfrtp_2
X_5232_ _5232_/A VGND VGND VPWR VPWR _7670_/D sky130_fd_sc_hd__buf_1
XFILLER_96_430 VGND VGND VPWR VPWR sky130_fd_sc_hd__decap_3
XPHY_EDGE_ROW_87_Left_223 VGND VGND VPWR VPWR sky130_fd_sc_hd__decap_3
X_5163_ _6486_/B _5679_/D _7004_/C VGND VGND VPWR VPWR _5164_/A sky130_fd_sc_hd__and3b_2
XFILLER_111_774 VGND VGND VPWR VPWR sky130_fd_sc_hd__fill_1
XFILLER_69_688 VGND VGND VPWR VPWR sky130_fd_sc_hd__fill_1
XTAP_TAPCELL_ROW_71_1287 VGND VPWR sky130_fd_sc_hd__tapvpwrvgnd_1
X_4114_ _8732_/Q _7507_/Q _7588_/Q _7669_/Q _4166_/S0 _4166_/S1 VGND VGND VPWR VPWR
+ _4115_/B sky130_fd_sc_hd__mux4_2
XFILLER_111_785 VGND VGND VPWR VPWR sky130_fd_sc_hd__decap_3
XFILLER_68_187 VGND VGND VPWR VPWR sky130_fd_sc_hd__fill_2
X_5094_ _5094_/A VGND VGND VPWR VPWR _7606_/D sky130_fd_sc_hd__buf_1
X_4045_ _8725_/Q _7500_/Q _7581_/Q _7662_/Q _4090_/S0 _4091_/S1 VGND VGND VPWR VPWR
+ _4045_/X sky130_fd_sc_hd__mux4_2
XFILLER_17_39 VGND VGND VPWR VPWR sky130_fd_sc_hd__decap_3
XFILLER_91_190 VGND VGND VPWR VPWR sky130_fd_sc_hd__decap_3
X_7804_ _8623_/CLK _7804_/D load_slew667/X VGND VGND VPWR VPWR _7804_/Q sky130_fd_sc_hd__dfrtp_2
XFILLER_12_419 VGND VGND VPWR VPWR sky130_fd_sc_hd__fill_1
XFILLER_25_769 VGND VGND VPWR VPWR sky130_fd_sc_hd__decap_3
XFILLER_52_566 VGND VGND VPWR VPWR sky130_fd_sc_hd__decap_3
XPHY_EDGE_ROW_96_Left_232 VGND VGND VPWR VPWR sky130_fd_sc_hd__decap_3
X_8784_ _8792_/CLK _8784_/D fanout658/X VGND VGND VPWR VPWR _8784_/Q sky130_fd_sc_hd__dfrtp_2
X_5996_ _5996_/A VGND VGND VPWR VPWR _8065_/D sky130_fd_sc_hd__buf_1
XTAP_TAPCELL_ROW_35_786 VGND VPWR sky130_fd_sc_hd__tapvpwrvgnd_1
X_7735_ _8799_/CLK _7735_/D fanout601/X VGND VGND VPWR VPWR _7735_/Q sky130_fd_sc_hd__dfrtp_2
X_4947_ _4947_/A VGND VGND VPWR VPWR _5118_/A sky130_fd_sc_hd__clkbuf_1
XFILLER_130_9 VGND VGND VPWR VPWR sky130_fd_sc_hd__decap_3
X_7666_ _8328_/CLK _7666_/D wire476/X VGND VGND VPWR VPWR _7666_/Q sky130_fd_sc_hd__dfrtp_2
X_4878_ _4878_/A _4902_/B VGND VGND VPWR VPWR _4879_/A sky130_fd_sc_hd__and2_2
X_3829_ _7724_/Q _7805_/Q _7886_/Q _7967_/Q _3824_/S _3825_/A VGND VGND VPWR VPWR
+ _3829_/X sky130_fd_sc_hd__mux4_2
X_6617_ _4861_/X _8358_/Q _6633_/S VGND VGND VPWR VPWR _6618_/A sky130_fd_sc_hd__mux2_2
XFILLER_4_607 VGND VGND VPWR VPWR sky130_fd_sc_hd__decap_3
Xclkbuf_leaf_146_CLK clkbuf_leaf_3_CLK/A VGND VGND VPWR VPWR _7669_/CLK sky130_fd_sc_hd__clkbuf_8
X_7597_ _8743_/CLK _7597_/D wire519/X VGND VGND VPWR VPWR _7597_/Q sky130_fd_sc_hd__dfrtp_2
XFILLER_118_362 VGND VGND VPWR VPWR sky130_fd_sc_hd__fill_2
X_6548_ _6548_/A VGND VGND VPWR VPWR _8325_/D sky130_fd_sc_hd__buf_2
XFILLER_106_557 VGND VGND VPWR VPWR sky130_fd_sc_hd__decap_3
XFILLER_133_332 VGND VGND VPWR VPWR sky130_fd_sc_hd__decap_3
XFILLER_133_343 VGND VGND VPWR VPWR sky130_fd_sc_hd__decap_3
XFILLER_3_128 VGND VGND VPWR VPWR sky130_fd_sc_hd__decap_3
X_6479_ _6479_/A VGND VGND VPWR VPWR _8293_/D sky130_fd_sc_hd__buf_2
XFILLER_121_505 VGND VGND VPWR VPWR sky130_fd_sc_hd__fill_2
XFILLER_121_516 VGND VGND VPWR VPWR sky130_fd_sc_hd__decap_3
XFILLER_133_376 VGND VGND VPWR VPWR sky130_fd_sc_hd__decap_3
XFILLER_79_408 VGND VGND VPWR VPWR sky130_fd_sc_hd__decap_3
X_8218_ _8785_/CLK _8218_/D load_slew678/X VGND VGND VPWR VPWR _8218_/Q sky130_fd_sc_hd__dfrtp_2
XFILLER_59_121 VGND VGND VPWR VPWR sky130_fd_sc_hd__decap_3
XFILLER_99_290 VGND VGND VPWR VPWR sky130_fd_sc_hd__decap_3
X_8149_ _8680_/CLK _8149_/D wire693/X VGND VGND VPWR VPWR _8149_/Q sky130_fd_sc_hd__dfrtp_2
XFILLER_102_763 VGND VGND VPWR VPWR sky130_fd_sc_hd__fill_1
XFILLER_87_441 VGND VGND VPWR VPWR sky130_fd_sc_hd__decap_3
XFILLER_87_463 VGND VGND VPWR VPWR sky130_fd_sc_hd__decap_3
XFILLER_101_284 VGND VGND VPWR VPWR sky130_fd_sc_hd__fill_1
XFILLER_102_785 VGND VGND VPWR VPWR sky130_fd_sc_hd__decap_3
XFILLER_74_113 VGND VGND VPWR VPWR sky130_fd_sc_hd__decap_3
XTAP_TAPCELL_ROW_89_1537 VGND VPWR sky130_fd_sc_hd__tapvpwrvgnd_1
XFILLER_114_85 VGND VGND VPWR VPWR sky130_fd_sc_hd__decap_3
XFILLER_15_202 VGND VGND VPWR VPWR sky130_fd_sc_hd__decap_3
XFILLER_28_574 VGND VGND VPWR VPWR sky130_fd_sc_hd__decap_3
XFILLER_43_500 VGND VGND VPWR VPWR sky130_fd_sc_hd__decap_3
XFILLER_16_747 VGND VGND VPWR VPWR sky130_fd_sc_hd__decap_3
XFILLER_55_393 VGND VGND VPWR VPWR sky130_fd_sc_hd__decap_3
XFILLER_130_62 VGND VGND VPWR VPWR sky130_fd_sc_hd__decap_3
XFILLER_43_555 VGND VGND VPWR VPWR sky130_fd_sc_hd__decap_3
XFILLER_70_363 VGND VGND VPWR VPWR sky130_fd_sc_hd__fill_1
XFILLER_15_279 VGND VGND VPWR VPWR sky130_fd_sc_hd__fill_1
XFILLER_90_44 VGND VGND VPWR VPWR sky130_fd_sc_hd__decap_3
XFILLER_30_249 VGND VGND VPWR VPWR sky130_fd_sc_hd__decap_3
XFILLER_90_88 VGND VGND VPWR VPWR sky130_fd_sc_hd__decap_3
XFILLER_128_115 VGND VGND VPWR VPWR sky130_fd_sc_hd__decap_3
XFILLER_129_638 VGND VGND VPWR VPWR sky130_fd_sc_hd__decap_3
XFILLER_23_60 VGND VGND VPWR VPWR sky130_fd_sc_hd__decap_3
XFILLER_7_412 VGND VGND VPWR VPWR sky130_fd_sc_hd__decap_3
XTAP_TAPCELL_ROW_13_469 VGND VPWR sky130_fd_sc_hd__tapvpwrvgnd_1
XFILLER_125_800 VGND VGND VPWR VPWR sky130_fd_sc_hd__decap_3
XFILLER_128_159 VGND VGND VPWR VPWR sky130_fd_sc_hd__decap_3
XFILLER_7_445 VGND VGND VPWR VPWR sky130_fd_sc_hd__decap_3
Xclkbuf_leaf_137_CLK clkload1/A VGND VGND VPWR VPWR _8743_/CLK sky130_fd_sc_hd__clkbuf_8
XFILLER_109_373 VGND VGND VPWR VPWR sky130_fd_sc_hd__decap_3
XFILLER_124_343 VGND VGND VPWR VPWR sky130_fd_sc_hd__decap_3
XFILLER_124_365 VGND VGND VPWR VPWR sky130_fd_sc_hd__decap_3
XFILLER_3_662 VGND VGND VPWR VPWR sky130_fd_sc_hd__decap_3
XFILLER_3_673 VGND VGND VPWR VPWR sky130_fd_sc_hd__decap_3
Xload_slew304 _4099_/B2 VGND VGND VPWR VPWR _4231_/A sky130_fd_sc_hd__clkbuf_4
XTAP_TAPCELL_ROW_111_1844 VGND VPWR sky130_fd_sc_hd__tapvpwrvgnd_1
Xload_slew315 fanout314/X VGND VGND VPWR VPWR _4092_/S sky130_fd_sc_hd__clkbuf_2
XFILLER_24_6 VGND VGND VPWR VPWR sky130_fd_sc_hd__decap_3
XFILLER_65_113 VGND VGND VPWR VPWR sky130_fd_sc_hd__decap_3
XFILLER_66_614 VGND VGND VPWR VPWR sky130_fd_sc_hd__decap_3
XFILLER_93_400 VGND VGND VPWR VPWR sky130_fd_sc_hd__decap_3
XFILLER_66_669 VGND VGND VPWR VPWR sky130_fd_sc_hd__decap_3
XFILLER_0_53 VGND VGND VPWR VPWR sky130_fd_sc_hd__decap_3
XFILLER_53_319 VGND VGND VPWR VPWR sky130_fd_sc_hd__decap_3
XFILLER_81_617 VGND VGND VPWR VPWR sky130_fd_sc_hd__decap_3
XFILLER_93_499 VGND VGND VPWR VPWR sky130_fd_sc_hd__decap_3
XFILLER_0_75 VGND VGND VPWR VPWR sky130_fd_sc_hd__decap_3
XFILLER_34_522 VGND VGND VPWR VPWR sky130_fd_sc_hd__fill_1
XFILLER_34_533 VGND VGND VPWR VPWR sky130_fd_sc_hd__fill_1
XFILLER_0_97 VGND VGND VPWR VPWR sky130_fd_sc_hd__decap_3
X_5850_ _5850_/A VGND VGND VPWR VPWR _7962_/D sky130_fd_sc_hd__buf_1
XFILLER_22_728 VGND VGND VPWR VPWR sky130_fd_sc_hd__fill_1
X_5781_ _5781_/A VGND VGND VPWR VPWR _7929_/D sky130_fd_sc_hd__buf_1
X_4801_ _4801_/A VGND VGND VPWR VPWR _7523_/D sky130_fd_sc_hd__buf_1
XFILLER_9_51 VGND VGND VPWR VPWR sky130_fd_sc_hd__decap_3
XTAP_TAPCELL_ROW_122_1995 VGND VPWR sky130_fd_sc_hd__tapvpwrvgnd_1
XTAP_TAPCELL_ROW_32_734 VGND VPWR sky130_fd_sc_hd__tapvpwrvgnd_1
XTAP_TAPCELL_ROW_32_745 VGND VPWR sky130_fd_sc_hd__tapvpwrvgnd_1
X_7520_ _8745_/CLK _7520_/D load_slew626/X VGND VGND VPWR VPWR _7520_/Q sky130_fd_sc_hd__dfrtp_2
X_4732_ _4731_/X _7507_/Q _4736_/S VGND VGND VPWR VPWR _4733_/A sky130_fd_sc_hd__mux2_2
XFILLER_9_84 VGND VGND VPWR VPWR sky130_fd_sc_hd__decap_3
X_7451_ _8782_/Q _4940_/A _7451_/S VGND VGND VPWR VPWR _7452_/A sky130_fd_sc_hd__mux2_2
X_4663_ _8375_/Q _3767_/A _3817_/A _8294_/Q _4590_/S VGND VGND VPWR VPWR _4663_/X
+ sky130_fd_sc_hd__o221a_2
Xclkbuf_leaf_128_CLK clkbuf_5_6__f_CLK/X VGND VGND VPWR VPWR _8586_/CLK sky130_fd_sc_hd__clkbuf_8
X_6402_ _6402_/A VGND VGND VPWR VPWR _8256_/D sky130_fd_sc_hd__buf_2
XFILLER_128_660 VGND VGND VPWR VPWR sky130_fd_sc_hd__decap_3
XFILLER_134_118 VGND VGND VPWR VPWR sky130_fd_sc_hd__decap_3
Xhold902 _7989_/Q VGND VGND VPWR VPWR hold902/X sky130_fd_sc_hd__dlygate4sd3_1
Xhold913 _8636_/Q VGND VGND VPWR VPWR hold913/X sky130_fd_sc_hd__dlygate4sd3_1
X_7382_ _7382_/A0 _4802_/A _7386_/S VGND VGND VPWR VPWR _7383_/A sky130_fd_sc_hd__mux2_2
X_4594_ _7955_/Q _4642_/A2 _4593_/X _4633_/A wire326/X VGND VGND VPWR VPWR _4594_/X
+ sky130_fd_sc_hd__o221a_2
XFILLER_127_181 VGND VGND VPWR VPWR sky130_fd_sc_hd__decap_3
XFILLER_128_693 VGND VGND VPWR VPWR sky130_fd_sc_hd__decap_3
Xhold924 _8618_/Q VGND VGND VPWR VPWR hold924/X sky130_fd_sc_hd__dlygate4sd3_1
Xhold935 _8216_/Q VGND VGND VPWR VPWR hold935/X sky130_fd_sc_hd__dlygate4sd3_1
Xhold946 _8582_/Q VGND VGND VPWR VPWR hold946/X sky130_fd_sc_hd__dlygate4sd3_1
X_6333_ _4981_/X _8224_/Q _6335_/S VGND VGND VPWR VPWR _6334_/A sky130_fd_sc_hd__mux2_2
XFILLER_0_109 VGND VGND VPWR VPWR sky130_fd_sc_hd__decap_3
XFILLER_130_302 VGND VGND VPWR VPWR sky130_fd_sc_hd__decap_3
XFILLER_131_803 VGND VGND VPWR VPWR sky130_fd_sc_hd__fill_1
XFILLER_135_18 VGND VGND VPWR VPWR sky130_fd_sc_hd__decap_3
XFILLER_135_29 VGND VGND VPWR VPWR sky130_fd_sc_hd__decap_3
XTAP_TAPCELL_ROW_73_1316 VGND VPWR sky130_fd_sc_hd__tapvpwrvgnd_1
Xhold957 _8797_/Q VGND VGND VPWR VPWR hold957/X sky130_fd_sc_hd__dlygate4sd3_1
Xhold968 _8262_/Q VGND VGND VPWR VPWR hold968/X sky130_fd_sc_hd__dlygate4sd3_1
Xhold979 _7555_/Q VGND VGND VPWR VPWR hold979/X sky130_fd_sc_hd__dlygate4sd3_1
X_6264_ _4845_/X _8192_/Q _6268_/S VGND VGND VPWR VPWR _6265_/A sky130_fd_sc_hd__mux2_4
XFILLER_130_335 VGND VGND VPWR VPWR sky130_fd_sc_hd__decap_3
X_8003_ _8583_/CLK _8003_/D wire618/X VGND VGND VPWR VPWR _8003_/Q sky130_fd_sc_hd__dfrtp_2
X_5215_ _5215_/A VGND VGND VPWR VPWR _7662_/D sky130_fd_sc_hd__buf_1
XFILLER_69_452 VGND VGND VPWR VPWR sky130_fd_sc_hd__decap_3
XFILLER_97_750 VGND VGND VPWR VPWR sky130_fd_sc_hd__decap_3
X_6195_ _4707_/X _8159_/Q _6205_/S VGND VGND VPWR VPWR _6196_/A sky130_fd_sc_hd__mux2_4
XFILLER_28_27 VGND VGND VPWR VPWR sky130_fd_sc_hd__fill_1
XFILLER_28_38 VGND VGND VPWR VPWR sky130_fd_sc_hd__decap_3
XFILLER_29_305 VGND VGND VPWR VPWR sky130_fd_sc_hd__decap_3
XFILLER_69_485 VGND VGND VPWR VPWR sky130_fd_sc_hd__decap_3
XFILLER_84_411 VGND VGND VPWR VPWR sky130_fd_sc_hd__decap_3
X_5146_ _4913_/X _7631_/Q _5158_/S VGND VGND VPWR VPWR _5147_/A sky130_fd_sc_hd__mux2_2
XFILLER_96_293 VGND VGND VPWR VPWR sky130_fd_sc_hd__decap_3
X_5077_ _4773_/X _7598_/Q _5095_/S VGND VGND VPWR VPWR _5078_/A sky130_fd_sc_hd__mux2_2
X_4028_ _7741_/Q _7822_/Q _7903_/Q _7984_/Q _4098_/S0 _4036_/A VGND VGND VPWR VPWR
+ _4028_/X sky130_fd_sc_hd__mux4_2
XFILLER_44_15 VGND VGND VPWR VPWR sky130_fd_sc_hd__fill_2
XFILLER_71_116 VGND VGND VPWR VPWR sky130_fd_sc_hd__fill_2
XTAP_TAPCELL_ROW_84_1467 VGND VPWR sky130_fd_sc_hd__tapvpwrvgnd_1
XFILLER_12_227 VGND VGND VPWR VPWR sky130_fd_sc_hd__decap_3
XFILLER_25_599 VGND VGND VPWR VPWR sky130_fd_sc_hd__decap_3
XFILLER_52_374 VGND VGND VPWR VPWR sky130_fd_sc_hd__decap_3
X_8767_ _8770_/CLK _8767_/D load_slew550/X VGND VGND VPWR VPWR _8767_/Q sky130_fd_sc_hd__dfrtp_2
X_5979_ _5979_/A VGND VGND VPWR VPWR _8057_/D sky130_fd_sc_hd__buf_1
XFILLER_100_32 VGND VGND VPWR VPWR sky130_fd_sc_hd__decap_3
X_7718_ _8781_/CLK _7718_/D fanout749/A VGND VGND VPWR VPWR _7718_/Q sky130_fd_sc_hd__dfrtp_2
XFILLER_60_25 VGND VGND VPWR VPWR sky130_fd_sc_hd__decap_3
X_8698_ _8698_/CLK _8698_/D fanout747/X VGND VGND VPWR VPWR _8698_/Q sky130_fd_sc_hd__dfrtp_2
XFILLER_126_619 VGND VGND VPWR VPWR sky130_fd_sc_hd__fill_1
XTAP_TAPCELL_ROW_10_428 VGND VPWR sky130_fd_sc_hd__tapvpwrvgnd_1
XTAP_TAPCELL_ROW_10_439 VGND VPWR sky130_fd_sc_hd__tapvpwrvgnd_1
Xclkbuf_leaf_119_CLK clkbuf_5_16__f_CLK/X VGND VGND VPWR VPWR _8662_/CLK sky130_fd_sc_hd__clkbuf_8
X_7649_ _8712_/CLK _7649_/D load_slew589/X VGND VGND VPWR VPWR _7649_/Q sky130_fd_sc_hd__dfrtp_2
XFILLER_119_682 VGND VGND VPWR VPWR sky130_fd_sc_hd__decap_3
XFILLER_125_129 VGND VGND VPWR VPWR sky130_fd_sc_hd__fill_1
XFILLER_107_3 VGND VGND VPWR VPWR sky130_fd_sc_hd__fill_2
XFILLER_109_63 VGND VGND VPWR VPWR sky130_fd_sc_hd__fill_1
XFILLER_134_641 VGND VGND VPWR VPWR sky130_fd_sc_hd__decap_3
XFILLER_69_23 VGND VGND VPWR VPWR sky130_fd_sc_hd__decap_3
XFILLER_106_365 VGND VGND VPWR VPWR sky130_fd_sc_hd__decap_3
XFILLER_133_140 VGND VGND VPWR VPWR sky130_fd_sc_hd__decap_3
XFILLER_134_663 VGND VGND VPWR VPWR sky130_fd_sc_hd__decap_3
XFILLER_121_324 VGND VGND VPWR VPWR sky130_fd_sc_hd__fill_1
XFILLER_121_335 VGND VGND VPWR VPWR sky130_fd_sc_hd__fill_1
XFILLER_133_184 VGND VGND VPWR VPWR sky130_fd_sc_hd__decap_3
XFILLER_134_696 VGND VGND VPWR VPWR sky130_fd_sc_hd__decap_3
XFILLER_79_216 VGND VGND VPWR VPWR sky130_fd_sc_hd__decap_3
XFILLER_79_249 VGND VGND VPWR VPWR sky130_fd_sc_hd__decap_3
XFILLER_0_654 VGND VGND VPWR VPWR sky130_fd_sc_hd__decap_3
XFILLER_121_346 VGND VGND VPWR VPWR sky130_fd_sc_hd__decap_3
XFILLER_125_51 VGND VGND VPWR VPWR sky130_fd_sc_hd__decap_3
XFILLER_0_676 VGND VGND VPWR VPWR sky130_fd_sc_hd__decap_3
XFILLER_102_560 VGND VGND VPWR VPWR sky130_fd_sc_hd__decap_3
XFILLER_125_84 VGND VGND VPWR VPWR sky130_fd_sc_hd__decap_3
XFILLER_47_113 VGND VGND VPWR VPWR sky130_fd_sc_hd__decap_3
XFILLER_87_293 VGND VGND VPWR VPWR sky130_fd_sc_hd__decap_3
Xclkbuf_5_14__f_CLK clkbuf_4_7_0_CLK/X VGND VGND VPWR VPWR clkbuf_leaf_48_CLK/A sky130_fd_sc_hd__clkbuf_16
XFILLER_18_71 VGND VGND VPWR VPWR sky130_fd_sc_hd__decap_3
XFILLER_63_617 VGND VGND VPWR VPWR sky130_fd_sc_hd__fill_1
XTAP_TAPCELL_ROW_126_2051 VGND VPWR sky130_fd_sc_hd__tapvpwrvgnd_1
XTAP_TAPCELL_ROW_126_2062 VGND VPWR sky130_fd_sc_hd__tapvpwrvgnd_1
XFILLER_16_511 VGND VGND VPWR VPWR sky130_fd_sc_hd__decap_3
XFILLER_75_499 VGND VGND VPWR VPWR sky130_fd_sc_hd__decap_3
XTAP_TAPCELL_ROW_18_539 VGND VPWR sky130_fd_sc_hd__tapvpwrvgnd_1
XFILLER_43_341 VGND VGND VPWR VPWR sky130_fd_sc_hd__decap_3
XFILLER_31_514 VGND VGND VPWR VPWR sky130_fd_sc_hd__decap_3
XFILLER_43_374 VGND VGND VPWR VPWR sky130_fd_sc_hd__decap_3
XFILLER_129_402 VGND VGND VPWR VPWR sky130_fd_sc_hd__decap_3
XFILLER_31_547 VGND VGND VPWR VPWR sky130_fd_sc_hd__decap_3
XFILLER_31_558 VGND VGND VPWR VPWR sky130_fd_sc_hd__fill_2
XFILLER_129_435 VGND VGND VPWR VPWR sky130_fd_sc_hd__decap_3
XFILLER_12_750 VGND VGND VPWR VPWR sky130_fd_sc_hd__decap_3
XFILLER_12_772 VGND VGND VPWR VPWR sky130_fd_sc_hd__decap_3
XFILLER_8_710 VGND VGND VPWR VPWR sky130_fd_sc_hd__decap_3
XFILLER_8_743 VGND VGND VPWR VPWR sky130_fd_sc_hd__decap_3
XFILLER_129_479 VGND VGND VPWR VPWR sky130_fd_sc_hd__decap_3
XFILLER_8_787 VGND VGND VPWR VPWR sky130_fd_sc_hd__decap_3
XFILLER_50_80 VGND VGND VPWR VPWR sky130_fd_sc_hd__decap_3
Xwire195 _5463_/A VGND VGND VPWR VPWR _5505_/S sky130_fd_sc_hd__buf_2
XFILLER_112_324 VGND VGND VPWR VPWR sky130_fd_sc_hd__decap_3
XFILLER_125_696 VGND VGND VPWR VPWR sky130_fd_sc_hd__decap_3
XFILLER_98_536 VGND VGND VPWR VPWR sky130_fd_sc_hd__decap_3
XTAP_TAPCELL_ROW_55_1057 VGND VPWR sky130_fd_sc_hd__tapvpwrvgnd_1
XFILLER_124_195 VGND VGND VPWR VPWR sky130_fd_sc_hd__fill_1
XTAP_TAPCELL_ROW_55_1068 VGND VPWR sky130_fd_sc_hd__tapvpwrvgnd_1
X_5000_ _4999_/X hold960/X _5028_/S VGND VGND VPWR VPWR _5001_/A sky130_fd_sc_hd__mux2_2
XFILLER_38_102 VGND VGND VPWR VPWR sky130_fd_sc_hd__fill_2
XFILLER_66_411 VGND VGND VPWR VPWR sky130_fd_sc_hd__fill_1
XFILLER_79_783 VGND VGND VPWR VPWR sky130_fd_sc_hd__fill_1
XFILLER_79_794 VGND VGND VPWR VPWR sky130_fd_sc_hd__fill_2
XFILLER_85_208 VGND VGND VPWR VPWR sky130_fd_sc_hd__fill_2
XFILLER_85_219 VGND VGND VPWR VPWR sky130_fd_sc_hd__decap_3
XFILLER_78_293 VGND VGND VPWR VPWR sky130_fd_sc_hd__decap_3
XFILLER_66_477 VGND VGND VPWR VPWR sky130_fd_sc_hd__decap_3
XFILLER_93_252 VGND VGND VPWR VPWR sky130_fd_sc_hd__decap_3
XTAP_TAPCELL_ROW_37_804 VGND VPWR sky130_fd_sc_hd__tapvpwrvgnd_1
XTAP_TAPCELL_ROW_37_815 VGND VPWR sky130_fd_sc_hd__tapvpwrvgnd_1
XFILLER_19_371 VGND VGND VPWR VPWR sky130_fd_sc_hd__fill_1
XFILLER_19_393 VGND VGND VPWR VPWR sky130_fd_sc_hd__fill_2
XFILLER_54_639 VGND VGND VPWR VPWR sky130_fd_sc_hd__decap_3
X_6951_ _6951_/A VGND VGND VPWR VPWR _8514_/D sky130_fd_sc_hd__buf_6
XFILLER_81_458 VGND VGND VPWR VPWR sky130_fd_sc_hd__fill_2
X_6882_ _6882_/A VGND VGND VPWR VPWR _8481_/D sky130_fd_sc_hd__buf_6
X_5902_ _5906_/A1 _5906_/A2 _4753_/X _5906_/B1 hold861/X VGND VGND VPWR VPWR _7998_/D
+ sky130_fd_sc_hd__a32o_2
XFILLER_14_18 VGND VGND VPWR VPWR sky130_fd_sc_hd__decap_3
XFILLER_34_374 VGND VGND VPWR VPWR sky130_fd_sc_hd__decap_3
X_8621_ _8621_/CLK _8621_/D wire680/X VGND VGND VPWR VPWR _8621_/Q sky130_fd_sc_hd__dfrtp_2
X_5833_ _7954_/Q _4908_/A _5847_/S VGND VGND VPWR VPWR _5834_/A sky130_fd_sc_hd__mux2_2
XFILLER_14_29 VGND VGND VPWR VPWR sky130_fd_sc_hd__decap_3
XFILLER_61_182 VGND VGND VPWR VPWR sky130_fd_sc_hd__decap_3
X_8552_ _8637_/CLK _8552_/D fanout606/X VGND VGND VPWR VPWR _8552_/Q sky130_fd_sc_hd__dfrtp_2
X_7503_ _8727_/CLK _7503_/D load_slew533/X VGND VGND VPWR VPWR _7503_/Q sky130_fd_sc_hd__dfrtp_2
X_5764_ _5764_/A VGND VGND VPWR VPWR _7921_/D sky130_fd_sc_hd__buf_1
X_8483_ _8483_/CLK _8483_/D fanout506/X VGND VGND VPWR VPWR _8483_/Q sky130_fd_sc_hd__dfrtp_2
X_5695_ _5695_/A VGND VGND VPWR VPWR _7888_/D sky130_fd_sc_hd__buf_1
X_4715_ _4715_/A VGND VGND VPWR VPWR _4715_/X sky130_fd_sc_hd__buf_1
X_7434_ _7434_/A VGND VGND VPWR VPWR _8773_/D sky130_fd_sc_hd__buf_1
X_4646_ _4646_/A1 _4644_/X _4645_/X VGND VGND VPWR VPWR _4646_/X sky130_fd_sc_hd__o21a_2
XFILLER_135_438 VGND VGND VPWR VPWR sky130_fd_sc_hd__decap_3
X_7365_ _8741_/Q _4768_/A _7365_/S VGND VGND VPWR VPWR _7366_/A sky130_fd_sc_hd__mux2_2
X_4577_ _8368_/Q _3774_/X _4645_/B1 _8287_/Q _3955_/A VGND VGND VPWR VPWR _4577_/X
+ sky130_fd_sc_hd__o221a_2
XFILLER_115_140 VGND VGND VPWR VPWR sky130_fd_sc_hd__fill_1
XFILLER_131_600 VGND VGND VPWR VPWR sky130_fd_sc_hd__decap_3
X_6316_ _6484_/S VGND VGND VPWR VPWR _6335_/S sky130_fd_sc_hd__buf_4
XFILLER_115_162 VGND VGND VPWR VPWR sky130_fd_sc_hd__decap_3
XFILLER_115_184 VGND VGND VPWR VPWR sky130_fd_sc_hd__decap_3
Xhold765 _8625_/Q VGND VGND VPWR VPWR hold765/X sky130_fd_sc_hd__dlygate4sd3_1
Xhold776 _8688_/Q VGND VGND VPWR VPWR hold776/X sky130_fd_sc_hd__dlygate4sd3_1
Xhold787 _8637_/Q VGND VGND VPWR VPWR hold787/X sky130_fd_sc_hd__dlygate4sd3_1
X_7296_ _8708_/Q _4972_/A _7302_/S VGND VGND VPWR VPWR _7297_/A sky130_fd_sc_hd__mux2_2
XFILLER_103_335 VGND VGND VPWR VPWR sky130_fd_sc_hd__fill_1
XFILLER_103_357 VGND VGND VPWR VPWR sky130_fd_sc_hd__fill_2
XFILLER_130_121 VGND VGND VPWR VPWR sky130_fd_sc_hd__decap_3
XFILLER_131_644 VGND VGND VPWR VPWR sky130_fd_sc_hd__decap_3
Xhold798 _8640_/Q VGND VGND VPWR VPWR hold798/X sky130_fd_sc_hd__dlygate4sd3_1
X_6247_ _4811_/X _8184_/Q _6247_/S VGND VGND VPWR VPWR _6248_/A sky130_fd_sc_hd__mux2_4
XFILLER_130_165 VGND VGND VPWR VPWR sky130_fd_sc_hd__decap_3
XFILLER_131_688 VGND VGND VPWR VPWR sky130_fd_sc_hd__decap_3
XFILLER_57_411 VGND VGND VPWR VPWR sky130_fd_sc_hd__decap_3
X_6178_ _5015_/X _8151_/Q _6184_/S VGND VGND VPWR VPWR _6179_/A sky130_fd_sc_hd__mux2_4
X_5129_ _4879_/X _5129_/A1 _5137_/S VGND VGND VPWR VPWR _5130_/A sky130_fd_sc_hd__mux2_2
XFILLER_57_477 VGND VGND VPWR VPWR sky130_fd_sc_hd__decap_3
XFILLER_72_403 VGND VGND VPWR VPWR sky130_fd_sc_hd__decap_3
XFILLER_44_138 VGND VGND VPWR VPWR sky130_fd_sc_hd__fill_2
XFILLER_55_69 VGND VGND VPWR VPWR sky130_fd_sc_hd__decap_3
XFILLER_84_274 VGND VGND VPWR VPWR sky130_fd_sc_hd__fill_2
XFILLER_37_190 VGND VGND VPWR VPWR sky130_fd_sc_hd__decap_3
XFILLER_53_694 VGND VGND VPWR VPWR sky130_fd_sc_hd__fill_1
XTAP_TAPCELL_ROW_15_509 VGND VPWR sky130_fd_sc_hd__tapvpwrvgnd_1
XFILLER_13_547 VGND VGND VPWR VPWR sky130_fd_sc_hd__fill_1
XFILLER_40_377 VGND VGND VPWR VPWR sky130_fd_sc_hd__decap_3
XFILLER_71_57 VGND VGND VPWR VPWR sky130_fd_sc_hd__fill_1
XFILLER_126_427 VGND VGND VPWR VPWR sky130_fd_sc_hd__decap_3
XPHY_EDGE_ROW_33_Left_169 VGND VGND VPWR VPWR sky130_fd_sc_hd__decap_3
XTAP_TAPCELL_ROW_97_1647 VGND VPWR sky130_fd_sc_hd__tapvpwrvgnd_1
XFILLER_4_212 VGND VGND VPWR VPWR sky130_fd_sc_hd__decap_3
XFILLER_5_724 VGND VGND VPWR VPWR sky130_fd_sc_hd__decap_3
XFILLER_5_735 VGND VGND VPWR VPWR sky130_fd_sc_hd__decap_3
XFILLER_134_460 VGND VGND VPWR VPWR sky130_fd_sc_hd__decap_3
XFILLER_20_50 VGND VGND VPWR VPWR sky130_fd_sc_hd__decap_3
XFILLER_5_768 VGND VGND VPWR VPWR sky130_fd_sc_hd__decap_3
XFILLER_20_83 VGND VGND VPWR VPWR sky130_fd_sc_hd__fill_1
XFILLER_4_278 VGND VGND VPWR VPWR sky130_fd_sc_hd__decap_3
XFILLER_96_32 VGND VGND VPWR VPWR sky130_fd_sc_hd__decap_3
XFILLER_0_462 VGND VGND VPWR VPWR sky130_fd_sc_hd__decap_3
XFILLER_122_688 VGND VGND VPWR VPWR sky130_fd_sc_hd__decap_3
XFILLER_48_400 VGND VGND VPWR VPWR sky130_fd_sc_hd__decap_3
XFILLER_48_444 VGND VGND VPWR VPWR sky130_fd_sc_hd__fill_2
XPHY_EDGE_ROW_42_Left_178 VGND VGND VPWR VPWR sky130_fd_sc_hd__decap_3
XFILLER_75_241 VGND VGND VPWR VPWR sky130_fd_sc_hd__decap_3
XFILLER_29_691 VGND VGND VPWR VPWR sky130_fd_sc_hd__decap_3
XFILLER_35_116 VGND VGND VPWR VPWR sky130_fd_sc_hd__fill_2
XFILLER_75_296 VGND VGND VPWR VPWR sky130_fd_sc_hd__decap_3
XFILLER_90_200 VGND VGND VPWR VPWR sky130_fd_sc_hd__fill_2
XFILLER_16_330 VGND VGND VPWR VPWR sky130_fd_sc_hd__fill_2
XFILLER_35_149 VGND VGND VPWR VPWR sky130_fd_sc_hd__fill_1
XFILLER_90_233 VGND VGND VPWR VPWR sky130_fd_sc_hd__decap_3
XFILLER_16_363 VGND VGND VPWR VPWR sky130_fd_sc_hd__fill_1
XFILLER_16_374 VGND VGND VPWR VPWR sky130_fd_sc_hd__fill_1
XFILLER_45_91 VGND VGND VPWR VPWR sky130_fd_sc_hd__decap_3
XTAP_TAPCELL_ROW_106_1776 VGND VPWR sky130_fd_sc_hd__tapvpwrvgnd_1
XFILLER_31_322 VGND VGND VPWR VPWR sky130_fd_sc_hd__decap_3
XFILLER_71_491 VGND VGND VPWR VPWR sky130_fd_sc_hd__decap_3
XFILLER_129_243 VGND VGND VPWR VPWR sky130_fd_sc_hd__decap_3
XFILLER_31_388 VGND VGND VPWR VPWR sky130_fd_sc_hd__decap_3
XFILLER_31_399 VGND VGND VPWR VPWR sky130_fd_sc_hd__decap_3
XPHY_EDGE_ROW_51_Left_187 VGND VGND VPWR VPWR sky130_fd_sc_hd__decap_3
XTAP_TAPCELL_ROW_42_884 VGND VPWR sky130_fd_sc_hd__tapvpwrvgnd_1
XFILLER_117_427 VGND VGND VPWR VPWR sky130_fd_sc_hd__decap_3
XFILLER_129_276 VGND VGND VPWR VPWR sky130_fd_sc_hd__decap_3
XFILLER_8_551 VGND VGND VPWR VPWR sky130_fd_sc_hd__decap_3
X_5480_ _7788_/Q _4890_/A _5482_/S VGND VGND VPWR VPWR _5481_/A sky130_fd_sc_hd__mux2_2
X_4500_ _4522_/S _4498_/X _4499_/X _4510_/A1 VGND VGND VPWR VPWR _4500_/X sky130_fd_sc_hd__a31o_2
XANTENNA_1 _3735_/X VGND VGND VPWR VPWR sky130_fd_sc_hd__diode_2
XFILLER_117_449 VGND VGND VPWR VPWR sky130_fd_sc_hd__decap_3
XFILLER_129_287 VGND VGND VPWR VPWR sky130_fd_sc_hd__decap_3
XFILLER_6_41 VGND VGND VPWR VPWR sky130_fd_sc_hd__decap_3
XFILLER_8_595 VGND VGND VPWR VPWR sky130_fd_sc_hd__decap_3
X_4431_ _4458_/B2 _4422_/X _4425_/X _4428_/X _4430_/X VGND VGND VPWR VPWR _4431_/X
+ sky130_fd_sc_hd__o32a_2
XFILLER_6_74 VGND VGND VPWR VPWR sky130_fd_sc_hd__decap_3
XFILLER_6_85 VGND VGND VPWR VPWR sky130_fd_sc_hd__decap_3
XFILLER_98_300 VGND VGND VPWR VPWR sky130_fd_sc_hd__decap_3
X_7150_ _7150_/A VGND VGND VPWR VPWR _8608_/D sky130_fd_sc_hd__buf_2
X_4362_ _7772_/Q _7853_/Q _4367_/S VGND VGND VPWR VPWR _4363_/B sky130_fd_sc_hd__mux2_2
XFILLER_4_790 VGND VGND VPWR VPWR sky130_fd_sc_hd__decap_3
Xfanout508 fanout517/X VGND VGND VPWR VPWR fanout508/X sky130_fd_sc_hd__clkdlybuf4s25_1
X_7081_ _7081_/A VGND VGND VPWR VPWR _8575_/D sky130_fd_sc_hd__buf_2
X_6101_ _6101_/A VGND VGND VPWR VPWR _8115_/D sky130_fd_sc_hd__buf_1
X_4293_ _8424_/Q _8505_/Q _4305_/S VGND VGND VPWR VPWR _4293_/X sky130_fd_sc_hd__mux2_2
XFILLER_58_219 VGND VGND VPWR VPWR sky130_fd_sc_hd__decap_3
XFILLER_98_377 VGND VGND VPWR VPWR sky130_fd_sc_hd__decap_3
XPHY_EDGE_ROW_60_Left_196 VGND VGND VPWR VPWR sky130_fd_sc_hd__decap_3
X_6032_ _8083_/Q _4726_/A _6032_/S VGND VGND VPWR VPWR _6033_/A sky130_fd_sc_hd__mux2_2
XFILLER_39_422 VGND VGND VPWR VPWR sky130_fd_sc_hd__decap_3
XFILLER_66_230 VGND VGND VPWR VPWR sky130_fd_sc_hd__decap_3
XFILLER_67_764 VGND VGND VPWR VPWR sky130_fd_sc_hd__fill_2
XFILLER_82_701 VGND VGND VPWR VPWR sky130_fd_sc_hd__decap_3
XFILLER_54_414 VGND VGND VPWR VPWR sky130_fd_sc_hd__decap_3
XFILLER_66_285 VGND VGND VPWR VPWR sky130_fd_sc_hd__decap_3
XTAP_TAPCELL_ROW_68_1248 VGND VPWR sky130_fd_sc_hd__tapvpwrvgnd_1
X_7983_ _8731_/CLK _7983_/D load_slew496/X VGND VGND VPWR VPWR _7983_/Q sky130_fd_sc_hd__dfrtp_2
XFILLER_19_190 VGND VGND VPWR VPWR sky130_fd_sc_hd__decap_3
XFILLER_54_447 VGND VGND VPWR VPWR sky130_fd_sc_hd__decap_3
X_6934_ _6934_/A VGND VGND VPWR VPWR _8506_/D sky130_fd_sc_hd__buf_6
XFILLER_25_39 VGND VGND VPWR VPWR sky130_fd_sc_hd__decap_3
XFILLER_41_119 VGND VGND VPWR VPWR sky130_fd_sc_hd__decap_3
XFILLER_81_288 VGND VGND VPWR VPWR sky130_fd_sc_hd__fill_1
XFILLER_50_631 VGND VGND VPWR VPWR sky130_fd_sc_hd__decap_3
XFILLER_62_480 VGND VGND VPWR VPWR sky130_fd_sc_hd__decap_3
XTAP_TAPCELL_ROW_81_1426 VGND VPWR sky130_fd_sc_hd__tapvpwrvgnd_1
X_8604_ _8685_/CLK _8604_/D wire574/X VGND VGND VPWR VPWR _8604_/Q sky130_fd_sc_hd__dfrtp_2
X_6865_ _6865_/A VGND VGND VPWR VPWR _8473_/D sky130_fd_sc_hd__buf_6
XFILLER_50_675 VGND VGND VPWR VPWR sky130_fd_sc_hd__fill_1
X_6796_ _6796_/A VGND VGND VPWR VPWR _8441_/D sky130_fd_sc_hd__buf_2
X_5816_ _7946_/Q _4875_/A _5826_/S VGND VGND VPWR VPWR _5817_/A sky130_fd_sc_hd__mux2_2
XFILLER_10_528 VGND VGND VPWR VPWR sky130_fd_sc_hd__fill_1
XFILLER_50_697 VGND VGND VPWR VPWR sky130_fd_sc_hd__decap_3
X_8535_ _8695_/CLK _8535_/D load_slew733/X VGND VGND VPWR VPWR _8535_/Q sky130_fd_sc_hd__dfrtp_2
X_5747_ _7913_/Q _4735_/A _5763_/S VGND VGND VPWR VPWR _5748_/A sky130_fd_sc_hd__mux2_2
X_8466_ _8790_/CLK _8466_/D load_slew673/X VGND VGND VPWR VPWR _8466_/Q sky130_fd_sc_hd__dfrtp_2
XFILLER_108_427 VGND VGND VPWR VPWR sky130_fd_sc_hd__decap_3
XTAP_TAPCELL_ROW_20_567 VGND VPWR sky130_fd_sc_hd__tapvpwrvgnd_1
XTAP_TAPCELL_ROW_20_578 VGND VPWR sky130_fd_sc_hd__tapvpwrvgnd_1
X_7417_ _7417_/A VGND VGND VPWR VPWR _8765_/D sky130_fd_sc_hd__buf_1
X_5678_ _5678_/A VGND VGND VPWR VPWR _7881_/D sky130_fd_sc_hd__buf_1
XFILLER_135_246 VGND VGND VPWR VPWR sky130_fd_sc_hd__decap_3
XFILLER_135_268 VGND VGND VPWR VPWR sky130_fd_sc_hd__decap_3
XTAP_TAPCELL_ROW_79_1399 VGND VPWR sky130_fd_sc_hd__tapvpwrvgnd_1
X_8397_ _8721_/CLK _8397_/D load_slew587/X VGND VGND VPWR VPWR _8397_/Q sky130_fd_sc_hd__dfrtp_2
X_4629_ _8039_/Q _4629_/B VGND VGND VPWR VPWR _4629_/X sky130_fd_sc_hd__or2_2
XFILLER_2_716 VGND VGND VPWR VPWR sky130_fd_sc_hd__decap_3
XFILLER_2_749 VGND VGND VPWR VPWR sky130_fd_sc_hd__decap_3
Xclkbuf_leaf_50_CLK clkload4/A VGND VGND VPWR VPWR _8719_/CLK sky130_fd_sc_hd__clkbuf_8
Xmax_cap270 _4465_/A VGND VGND VPWR VPWR _4315_/C1 sky130_fd_sc_hd__buf_6
X_7348_ _7348_/A VGND VGND VPWR VPWR _8732_/D sky130_fd_sc_hd__buf_1
XFILLER_131_430 VGND VGND VPWR VPWR sky130_fd_sc_hd__decap_3
XFILLER_89_333 VGND VGND VPWR VPWR sky130_fd_sc_hd__decap_3
XTAP_TAPCELL_ROW_92_1577 VGND VPWR sky130_fd_sc_hd__tapvpwrvgnd_1
X_7279_ _7267_/X _4933_/X _7269_/X _7270_/X hold762/X VGND VGND VPWR VPWR _8699_/D
+ sky130_fd_sc_hd__a32o_2
XFILLER_104_677 VGND VGND VPWR VPWR sky130_fd_sc_hd__decap_3
XFILLER_131_452 VGND VGND VPWR VPWR sky130_fd_sc_hd__decap_3
XFILLER_131_485 VGND VGND VPWR VPWR sky130_fd_sc_hd__decap_3
XFILLER_103_198 VGND VGND VPWR VPWR sky130_fd_sc_hd__fill_1
XFILLER_66_24 VGND VGND VPWR VPWR sky130_fd_sc_hd__decap_3
XFILLER_66_57 VGND VGND VPWR VPWR sky130_fd_sc_hd__fill_2
XFILLER_85_561 VGND VGND VPWR VPWR sky130_fd_sc_hd__decap_3
XFILLER_17_105 VGND VGND VPWR VPWR sky130_fd_sc_hd__decap_3
XTAP_TAPCELL_ROW_123_2010 VGND VPWR sky130_fd_sc_hd__tapvpwrvgnd_1
XTAP_TAPCELL_ROW_123_2021 VGND VPWR sky130_fd_sc_hd__tapvpwrvgnd_1
XFILLER_122_52 VGND VGND VPWR VPWR sky130_fd_sc_hd__decap_3
XFILLER_45_447 VGND VGND VPWR VPWR sky130_fd_sc_hd__fill_1
XFILLER_45_458 VGND VGND VPWR VPWR sky130_fd_sc_hd__decap_3
XFILLER_73_756 VGND VGND VPWR VPWR sky130_fd_sc_hd__decap_3
XFILLER_32_108 VGND VGND VPWR VPWR sky130_fd_sc_hd__decap_3
XTAP_TAPCELL_ROW_0_281 VGND VPWR sky130_fd_sc_hd__tapvpwrvgnd_1
XTAP_TAPCELL_ROW_28_678 VGND VPWR sky130_fd_sc_hd__tapvpwrvgnd_1
XTAP_TAPCELL_ROW_28_689 VGND VPWR sky130_fd_sc_hd__tapvpwrvgnd_1
XFILLER_41_631 VGND VGND VPWR VPWR sky130_fd_sc_hd__decap_3
XFILLER_53_491 VGND VGND VPWR VPWR sky130_fd_sc_hd__decap_3
XTAP_TAPCELL_ROW_0_292 VGND VPWR sky130_fd_sc_hd__tapvpwrvgnd_1
XFILLER_15_72 VGND VGND VPWR VPWR sky130_fd_sc_hd__decap_3
XFILLER_41_664 VGND VGND VPWR VPWR sky130_fd_sc_hd__decap_3
XFILLER_41_697 VGND VGND VPWR VPWR sky130_fd_sc_hd__decap_3
XFILLER_9_337 VGND VGND VPWR VPWR sky130_fd_sc_hd__decap_3
XFILLER_127_703 VGND VGND VPWR VPWR sky130_fd_sc_hd__decap_3
XFILLER_127_747 VGND VGND VPWR VPWR sky130_fd_sc_hd__decap_3
XFILLER_31_60 VGND VGND VPWR VPWR sky130_fd_sc_hd__fill_2
XTAP_TAPCELL_ROW_134_2172 VGND VPWR sky130_fd_sc_hd__tapvpwrvgnd_1
XFILLER_126_279 VGND VGND VPWR VPWR sky130_fd_sc_hd__fill_1
XFILLER_135_791 VGND VGND VPWR VPWR sky130_fd_sc_hd__decap_3
XPHY_EDGE_ROW_128_Right_128 VGND VGND VPWR VPWR sky130_fd_sc_hd__decap_3
Xclkbuf_leaf_41_CLK clkbuf_leaf_48_CLK/A VGND VGND VPWR VPWR _8798_/CLK sky130_fd_sc_hd__clkbuf_8
XFILLER_110_614 VGND VGND VPWR VPWR sky130_fd_sc_hd__decap_3
XFILLER_122_474 VGND VGND VPWR VPWR sky130_fd_sc_hd__fill_2
XFILLER_1_771 VGND VGND VPWR VPWR sky130_fd_sc_hd__decap_3
XTAP_TAPCELL_ROW_52_1016 VGND VPWR sky130_fd_sc_hd__tapvpwrvgnd_1
XTAP_TAPCELL_ROW_52_1027 VGND VPWR sky130_fd_sc_hd__tapvpwrvgnd_1
Xoutput93 _3965_/X VGND VGND VPWR VPWR rdata[15] sky130_fd_sc_hd__clkdlybuf4s25_1
XFILLER_0_281 VGND VGND VPWR VPWR sky130_fd_sc_hd__decap_3
XFILLER_95_347 VGND VGND VPWR VPWR sky130_fd_sc_hd__fill_1
XFILLER_110_669 VGND VGND VPWR VPWR sky130_fd_sc_hd__decap_3
XFILLER_64_701 VGND VGND VPWR VPWR sky130_fd_sc_hd__decap_3
XTAP_TAPCELL_ROW_108_1805 VGND VPWR sky130_fd_sc_hd__tapvpwrvgnd_1
XFILLER_36_414 VGND VGND VPWR VPWR sky130_fd_sc_hd__decap_3
XFILLER_76_572 VGND VGND VPWR VPWR sky130_fd_sc_hd__decap_3
XFILLER_91_564 VGND VGND VPWR VPWR sky130_fd_sc_hd__decap_3
XTAP_TAPCELL_ROW_47_954 VGND VPWR sky130_fd_sc_hd__tapvpwrvgnd_1
X_4980_ _4980_/A _4984_/B VGND VGND VPWR VPWR _4981_/A sky130_fd_sc_hd__and2_2
XFILLER_44_491 VGND VGND VPWR VPWR sky130_fd_sc_hd__fill_1
X_3931_ _4455_/A _3929_/X _3930_/X VGND VGND VPWR VPWR _3931_/X sky130_fd_sc_hd__o21a_2
XFILLER_31_130 VGND VGND VPWR VPWR sky130_fd_sc_hd__decap_3
XTAP_TAPCELL_ROW_63_1178 VGND VPWR sky130_fd_sc_hd__tapvpwrvgnd_1
X_3862_ _3862_/A _3862_/B VGND VGND VPWR VPWR _3862_/X sky130_fd_sc_hd__or2_2
X_6650_ _4929_/X _8374_/Q _6654_/S VGND VGND VPWR VPWR _6651_/A sky130_fd_sc_hd__mux2_2
X_6581_ _4791_/X _8341_/Q _6591_/S VGND VGND VPWR VPWR _6582_/A sky130_fd_sc_hd__mux2_2
X_5601_ _5601_/A VGND VGND VPWR VPWR _7844_/D sky130_fd_sc_hd__buf_1
X_3793_ _4393_/A _3793_/B VGND VGND VPWR VPWR _3793_/X sky130_fd_sc_hd__or2_2
X_8320_ _8648_/CLK _8320_/D load_slew489/X VGND VGND VPWR VPWR _8320_/Q sky130_fd_sc_hd__dfrtp_2
X_5532_ _5532_/A VGND VGND VPWR VPWR _7811_/D sky130_fd_sc_hd__buf_1
XFILLER_118_736 VGND VGND VPWR VPWR sky130_fd_sc_hd__decap_3
XTAP_TAPCELL_ROW_119_1956 VGND VPWR sky130_fd_sc_hd__tapvpwrvgnd_1
XFILLER_118_769 VGND VGND VPWR VPWR sky130_fd_sc_hd__decap_3
XFILLER_133_706 VGND VGND VPWR VPWR sky130_fd_sc_hd__decap_3
X_8251_ _8737_/CLK _8251_/D load_slew511/X VGND VGND VPWR VPWR _8251_/Q sky130_fd_sc_hd__dfrtp_2
X_5463_ _5463_/A VGND VGND VPWR VPWR _5482_/S sky130_fd_sc_hd__buf_2
XFILLER_132_227 VGND VGND VPWR VPWR sky130_fd_sc_hd__decap_3
XFILLER_99_620 VGND VGND VPWR VPWR sky130_fd_sc_hd__decap_3
Xclkbuf_leaf_32_CLK clkbuf_leaf_35_CLK/A VGND VGND VPWR VPWR _8683_/CLK sky130_fd_sc_hd__clkbuf_8
X_8182_ _8670_/CLK _8182_/D load_slew633/X VGND VGND VPWR VPWR _8182_/Q sky130_fd_sc_hd__dfrtp_2
X_7202_ _7267_/A VGND VGND VPWR VPWR _7202_/X sky130_fd_sc_hd__clkbuf_1
X_5394_ _7747_/Q _4718_/A _5398_/S VGND VGND VPWR VPWR _5395_/A sky130_fd_sc_hd__mux2_2
X_4414_ _8758_/Q _7533_/Q _4414_/S VGND VGND VPWR VPWR _4415_/B sky130_fd_sc_hd__mux2_2
XFILLER_113_430 VGND VGND VPWR VPWR sky130_fd_sc_hd__decap_3
Xfanout305 fanout314/X VGND VGND VPWR VPWR _4104_/B2 sky130_fd_sc_hd__clkdlybuf4s25_1
X_7133_ _4857_/X _8600_/Q _7151_/S VGND VGND VPWR VPWR _7134_/A sky130_fd_sc_hd__mux2_2
X_4345_ _7689_/Q _4682_/A2 _3752_/X _7608_/Q _4682_/C1 VGND VGND VPWR VPWR _4345_/X
+ sky130_fd_sc_hd__o221a_2
XFILLER_113_452 VGND VGND VPWR VPWR sky130_fd_sc_hd__decap_3
XFILLER_98_141 VGND VGND VPWR VPWR sky130_fd_sc_hd__decap_3
Xfanout316 wire330/A VGND VGND VPWR VPWR _4328_/C1 sky130_fd_sc_hd__clkdlybuf4s25_1
Xfanout327 _4672_/S VGND VGND VPWR VPWR _4637_/A sky130_fd_sc_hd__clkdlybuf4s25_1
Xfanout338 fanout364/X VGND VGND VPWR VPWR _4158_/A sky130_fd_sc_hd__clkdlybuf4s25_1
XFILLER_100_124 VGND VGND VPWR VPWR sky130_fd_sc_hd__decap_3
X_7064_ _7064_/A VGND VGND VPWR VPWR _8567_/D sky130_fd_sc_hd__buf_2
X_4276_ _4273_/X _4274_/X _4275_/X _4241_/S _3726_/A VGND VGND VPWR VPWR _4276_/X
+ sky130_fd_sc_hd__a221o_2
X_6015_ _6015_/A VGND VGND VPWR VPWR _8074_/D sky130_fd_sc_hd__buf_2
XFILLER_36_27 VGND VGND VPWR VPWR sky130_fd_sc_hd__fill_1
XFILLER_82_520 VGND VGND VPWR VPWR sky130_fd_sc_hd__decap_3
XFILLER_94_380 VGND VGND VPWR VPWR sky130_fd_sc_hd__fill_2
XFILLER_27_469 VGND VGND VPWR VPWR sky130_fd_sc_hd__fill_1
XFILLER_36_38 VGND VGND VPWR VPWR sky130_fd_sc_hd__decap_3
XFILLER_82_542 VGND VGND VPWR VPWR sky130_fd_sc_hd__decap_3
XFILLER_42_417 VGND VGND VPWR VPWR sky130_fd_sc_hd__decap_3
XFILLER_54_277 VGND VGND VPWR VPWR sky130_fd_sc_hd__decap_3
Xclkbuf_leaf_99_CLK clkbuf_leaf_99_CLK/A VGND VGND VPWR VPWR _8789_/CLK sky130_fd_sc_hd__clkbuf_8
X_7966_ _8627_/CLK _7966_/D fanout674/X VGND VGND VPWR VPWR _7966_/Q sky130_fd_sc_hd__dfrtp_2
XFILLER_23_620 VGND VGND VPWR VPWR sky130_fd_sc_hd__decap_3
XTAP_TAPCELL_ROW_25_637 VGND VPWR sky130_fd_sc_hd__tapvpwrvgnd_1
XTAP_TAPCELL_ROW_25_648 VGND VPWR sky130_fd_sc_hd__tapvpwrvgnd_1
X_7897_ _8637_/CLK _7897_/D fanout595/A VGND VGND VPWR VPWR _7897_/Q sky130_fd_sc_hd__dfrtp_2
X_6917_ _6917_/A VGND VGND VPWR VPWR _8498_/D sky130_fd_sc_hd__buf_6
XFILLER_22_141 VGND VGND VPWR VPWR sky130_fd_sc_hd__fill_1
X_6848_ _6848_/A VGND VGND VPWR VPWR _8465_/D sky130_fd_sc_hd__buf_6
XFILLER_109_703 VGND VGND VPWR VPWR sky130_fd_sc_hd__decap_3
X_8518_ _8518_/CLK _8518_/D load_slew704/X VGND VGND VPWR VPWR _8518_/Q sky130_fd_sc_hd__dfrtp_2
X_6779_ _6779_/A VGND VGND VPWR VPWR _8433_/D sky130_fd_sc_hd__buf_2
XFILLER_108_213 VGND VGND VPWR VPWR sky130_fd_sc_hd__decap_3
XFILLER_109_736 VGND VGND VPWR VPWR sky130_fd_sc_hd__fill_2
XFILLER_109_747 VGND VGND VPWR VPWR sky130_fd_sc_hd__decap_3
XFILLER_6_318 VGND VGND VPWR VPWR sky130_fd_sc_hd__decap_3
XTAP_TAPCELL_ROW_94_1606 VGND VPWR sky130_fd_sc_hd__tapvpwrvgnd_1
XFILLER_108_235 VGND VGND VPWR VPWR sky130_fd_sc_hd__decap_3
XPHY_EDGE_ROW_107_Left_243 VGND VGND VPWR VPWR sky130_fd_sc_hd__decap_3
X_8449_ _8773_/CLK _8449_/D load_slew738/X VGND VGND VPWR VPWR _8449_/Q sky130_fd_sc_hd__dfrtp_2
XFILLER_108_279 VGND VGND VPWR VPWR sky130_fd_sc_hd__decap_3
XFILLER_117_791 VGND VGND VPWR VPWR sky130_fd_sc_hd__decap_3
Xclkbuf_leaf_23_CLK clkbuf_5_9__f_CLK/X VGND VGND VPWR VPWR _8400_/CLK sky130_fd_sc_hd__clkbuf_8
XFILLER_117_63 VGND VGND VPWR VPWR sky130_fd_sc_hd__decap_3
XFILLER_104_474 VGND VGND VPWR VPWR sky130_fd_sc_hd__fill_2
XFILLER_132_772 VGND VGND VPWR VPWR sky130_fd_sc_hd__decap_3
XFILLER_77_23 VGND VGND VPWR VPWR sky130_fd_sc_hd__decap_3
XFILLER_77_314 VGND VGND VPWR VPWR sky130_fd_sc_hd__decap_3
XFILLER_131_293 VGND VGND VPWR VPWR sky130_fd_sc_hd__decap_3
XFILLER_77_325 VGND VGND VPWR VPWR sky130_fd_sc_hd__decap_3
XFILLER_77_67 VGND VGND VPWR VPWR sky130_fd_sc_hd__fill_2
XFILLER_46_701 VGND VGND VPWR VPWR sky130_fd_sc_hd__decap_3
XFILLER_58_561 VGND VGND VPWR VPWR sky130_fd_sc_hd__decap_3
XTAP_TAPCELL_ROW_5_362 VGND VPWR sky130_fd_sc_hd__tapvpwrvgnd_1
XFILLER_133_51 VGND VGND VPWR VPWR sky130_fd_sc_hd__decap_3
XFILLER_133_84 VGND VGND VPWR VPWR sky130_fd_sc_hd__decap_3
XFILLER_85_380 VGND VGND VPWR VPWR sky130_fd_sc_hd__decap_3
XFILLER_46_778 VGND VGND VPWR VPWR sky130_fd_sc_hd__decap_3
XFILLER_73_553 VGND VGND VPWR VPWR sky130_fd_sc_hd__decap_3
XFILLER_93_44 VGND VGND VPWR VPWR sky130_fd_sc_hd__decap_3
XPHY_EDGE_ROW_116_Left_252 VGND VGND VPWR VPWR sky130_fd_sc_hd__decap_3
XFILLER_61_715 VGND VGND VPWR VPWR sky130_fd_sc_hd__decap_3
XFILLER_73_564 VGND VGND VPWR VPWR sky130_fd_sc_hd__decap_3
XFILLER_73_586 VGND VGND VPWR VPWR sky130_fd_sc_hd__decap_3
XTAP_TAPCELL_ROW_44_902 VGND VPWR sky130_fd_sc_hd__tapvpwrvgnd_1
XTAP_TAPCELL_ROW_44_913 VGND VPWR sky130_fd_sc_hd__tapvpwrvgnd_1
XFILLER_14_631 VGND VGND VPWR VPWR sky130_fd_sc_hd__decap_3
XFILLER_26_71 VGND VGND VPWR VPWR sky130_fd_sc_hd__decap_3
XTAP_TAPCELL_ROW_103_1735 VGND VPWR sky130_fd_sc_hd__tapvpwrvgnd_1
XFILLER_127_500 VGND VGND VPWR VPWR sky130_fd_sc_hd__decap_3
XFILLER_127_511 VGND VGND VPWR VPWR sky130_fd_sc_hd__decap_3
XFILLER_9_178 VGND VGND VPWR VPWR sky130_fd_sc_hd__decap_3
XPHY_EDGE_ROW_125_Left_261 VGND VGND VPWR VPWR sky130_fd_sc_hd__decap_3
XFILLER_127_544 VGND VGND VPWR VPWR sky130_fd_sc_hd__decap_3
XFILLER_5_340 VGND VGND VPWR VPWR sky130_fd_sc_hd__decap_3
XFILLER_127_588 VGND VGND VPWR VPWR sky130_fd_sc_hd__decap_3
Xclkbuf_leaf_14_CLK clkbuf_5_6__f_CLK/X VGND VGND VPWR VPWR _8647_/CLK sky130_fd_sc_hd__clkbuf_8
XFILLER_108_791 VGND VGND VPWR VPWR sky130_fd_sc_hd__decap_3
XFILLER_123_750 VGND VGND VPWR VPWR sky130_fd_sc_hd__decap_3
XFILLER_123_783 VGND VGND VPWR VPWR sky130_fd_sc_hd__fill_1
XTAP_TAPCELL_ROW_114_1886 VGND VPWR sky130_fd_sc_hd__tapvpwrvgnd_1
X_4130_ _8409_/Q _8490_/Q _8571_/Q _8652_/Q _4124_/S _4166_/S1 VGND VGND VPWR VPWR
+ _4130_/X sky130_fd_sc_hd__mux4_2
XFILLER_110_411 VGND VGND VPWR VPWR sky130_fd_sc_hd__decap_3
XFILLER_3_42 VGND VGND VPWR VPWR sky130_fd_sc_hd__decap_3
XFILLER_95_122 VGND VGND VPWR VPWR sky130_fd_sc_hd__decap_3
XFILLER_96_645 VGND VGND VPWR VPWR sky130_fd_sc_hd__fill_2
XFILLER_3_75 VGND VGND VPWR VPWR sky130_fd_sc_hd__decap_3
XFILLER_49_561 VGND VGND VPWR VPWR sky130_fd_sc_hd__decap_3
XFILLER_95_166 VGND VGND VPWR VPWR sky130_fd_sc_hd__fill_2
XFILLER_96_689 VGND VGND VPWR VPWR sky130_fd_sc_hd__fill_1
X_4061_ _8079_/Q _8160_/Q _4100_/S VGND VGND VPWR VPWR _4062_/B sky130_fd_sc_hd__mux2_2
XFILLER_110_477 VGND VGND VPWR VPWR sky130_fd_sc_hd__decap_3
XFILLER_95_199 VGND VGND VPWR VPWR sky130_fd_sc_hd__fill_2
XPHY_EDGE_ROW_134_Left_270 VGND VGND VPWR VPWR sky130_fd_sc_hd__decap_3
XFILLER_64_553 VGND VGND VPWR VPWR sky130_fd_sc_hd__fill_1
X_7820_ _8470_/CLK _7820_/D fanout586/X VGND VGND VPWR VPWR _7820_/Q sky130_fd_sc_hd__dfrtp_2
XFILLER_51_203 VGND VGND VPWR VPWR sky130_fd_sc_hd__decap_3
XFILLER_64_564 VGND VGND VPWR VPWR sky130_fd_sc_hd__fill_2
XFILLER_91_361 VGND VGND VPWR VPWR sky130_fd_sc_hd__decap_3
XTAP_TAPCELL_ROW_65_1207 VGND VPWR sky130_fd_sc_hd__tapvpwrvgnd_1
XFILLER_51_225 VGND VGND VPWR VPWR sky130_fd_sc_hd__fill_2
X_7751_ _8655_/CLK _7751_/D load_slew484/X VGND VGND VPWR VPWR _7751_/Q sky130_fd_sc_hd__dfrtp_2
X_4963_ _4963_/A VGND VGND VPWR VPWR _7561_/D sky130_fd_sc_hd__buf_1
XTAP_TAPCELL_ROW_22_607 VGND VPWR sky130_fd_sc_hd__tapvpwrvgnd_1
X_3914_ _3988_/A _3910_/X _3911_/X _3913_/X VGND VGND VPWR VPWR _3914_/X sky130_fd_sc_hd__a31o_2
X_7682_ _8749_/CLK _7682_/D load_slew623/X VGND VGND VPWR VPWR _7682_/Q sky130_fd_sc_hd__dfrtp_2
X_6702_ _8397_/Q _5026_/A _6702_/S VGND VGND VPWR VPWR _6703_/A sky130_fd_sc_hd__mux2_2
XFILLER_20_612 VGND VGND VPWR VPWR sky130_fd_sc_hd__decap_3
XFILLER_20_634 VGND VGND VPWR VPWR sky130_fd_sc_hd__decap_3
XFILLER_32_483 VGND VGND VPWR VPWR sky130_fd_sc_hd__decap_3
X_6633_ _4895_/X _8366_/Q _6633_/S VGND VGND VPWR VPWR _6634_/A sky130_fd_sc_hd__mux2_2
X_4894_ _4894_/A _4902_/B VGND VGND VPWR VPWR _4895_/A sky130_fd_sc_hd__and2_2
XFILLER_20_645 VGND VGND VPWR VPWR sky130_fd_sc_hd__fill_2
XFILLER_22_29 VGND VGND VPWR VPWR sky130_fd_sc_hd__decap_3
X_3845_ _8708_/Q _8789_/Q _3845_/S VGND VGND VPWR VPWR _3845_/X sky130_fd_sc_hd__mux2_2
XFILLER_118_533 VGND VGND VPWR VPWR sky130_fd_sc_hd__decap_3
X_3776_ _3890_/A VGND VGND VPWR VPWR _3776_/X sky130_fd_sc_hd__clkbuf_2
X_6564_ _4757_/X _8333_/Q _6570_/S VGND VGND VPWR VPWR _6565_/A sky130_fd_sc_hd__mux2_2
XFILLER_118_566 VGND VGND VPWR VPWR sky130_fd_sc_hd__decap_3
X_8303_ _8709_/CLK _8303_/D fanout674/X VGND VGND VPWR VPWR _8303_/Q sky130_fd_sc_hd__dfrtp_2
X_6495_ _4961_/X _8300_/Q _6507_/S VGND VGND VPWR VPWR _6496_/A sky130_fd_sc_hd__mux2_2
X_5515_ _5515_/A VGND VGND VPWR VPWR _7803_/D sky130_fd_sc_hd__buf_1
XFILLER_118_577 VGND VGND VPWR VPWR sky130_fd_sc_hd__fill_2
XFILLER_118_599 VGND VGND VPWR VPWR sky130_fd_sc_hd__decap_3
XFILLER_133_503 VGND VGND VPWR VPWR sky130_fd_sc_hd__fill_1
XFILLER_133_514 VGND VGND VPWR VPWR sky130_fd_sc_hd__decap_3
XTAP_TAPCELL_ROW_76_1358 VGND VPWR sky130_fd_sc_hd__tapvpwrvgnd_1
Xclkbuf_4_8_0_CLK clkbuf_0_CLK/X VGND VGND VPWR VPWR clkbuf_4_8_0_CLK/X sky130_fd_sc_hd__clkbuf_8
X_8234_ _8801_/CLK _8234_/D load_slew608/X VGND VGND VPWR VPWR _8234_/Q sky130_fd_sc_hd__dfrtp_2
X_5446_ _5446_/A VGND VGND VPWR VPWR _7771_/D sky130_fd_sc_hd__buf_1
XFILLER_133_547 VGND VGND VPWR VPWR sky130_fd_sc_hd__decap_3
XFILLER_87_612 VGND VGND VPWR VPWR sky130_fd_sc_hd__decap_3
X_8165_ _8732_/CLK _8165_/D load_slew480/X VGND VGND VPWR VPWR _8165_/Q sky130_fd_sc_hd__dfrtp_2
X_5377_ _7739_/Q _5026_/A _5377_/S VGND VGND VPWR VPWR _5378_/A sky130_fd_sc_hd__mux2_2
XFILLER_113_271 VGND VGND VPWR VPWR sky130_fd_sc_hd__decap_3
X_8096_ _8751_/CLK _8096_/D load_slew628/X VGND VGND VPWR VPWR _8096_/Q sky130_fd_sc_hd__dfrtp_2
X_7116_ _4824_/X _8592_/Q _7130_/S VGND VGND VPWR VPWR _7117_/A sky130_fd_sc_hd__mux2_2
X_4328_ _8589_/Q _4424_/A2 _4327_/X _4330_/A _4328_/C1 VGND VGND VPWR VPWR _4328_/X
+ sky130_fd_sc_hd__o221a_2
X_7047_ _7047_/A VGND VGND VPWR VPWR _8559_/D sky130_fd_sc_hd__buf_2
X_4259_ _4256_/X _4257_/X _4258_/X _4605_/A1 VGND VGND VPWR VPWR _4259_/X sky130_fd_sc_hd__a22o_2
XFILLER_28_701 VGND VGND VPWR VPWR sky130_fd_sc_hd__decap_3
XTAP_TAPCELL_ROW_2_321 VGND VPWR sky130_fd_sc_hd__tapvpwrvgnd_1
XFILLER_55_553 VGND VGND VPWR VPWR sky130_fd_sc_hd__decap_3
XFILLER_67_391 VGND VGND VPWR VPWR sky130_fd_sc_hd__fill_1
XFILLER_27_266 VGND VGND VPWR VPWR sky130_fd_sc_hd__decap_3
XFILLER_27_277 VGND VGND VPWR VPWR sky130_fd_sc_hd__decap_3
XFILLER_28_778 VGND VGND VPWR VPWR sky130_fd_sc_hd__fill_2
XFILLER_43_726 VGND VGND VPWR VPWR sky130_fd_sc_hd__fill_2
XFILLER_55_564 VGND VGND VPWR VPWR sky130_fd_sc_hd__decap_3
XFILLER_42_214 VGND VGND VPWR VPWR sky130_fd_sc_hd__decap_3
X_7949_ _8764_/CLK _7949_/D fanout564/X VGND VGND VPWR VPWR _7949_/Q sky130_fd_sc_hd__dfrtp_2
XFILLER_11_601 VGND VGND VPWR VPWR sky130_fd_sc_hd__decap_3
XFILLER_11_623 VGND VGND VPWR VPWR sky130_fd_sc_hd__decap_3
XFILLER_51_781 VGND VGND VPWR VPWR sky130_fd_sc_hd__decap_3
XFILLER_70_589 VGND VGND VPWR VPWR sky130_fd_sc_hd__decap_3
XFILLER_23_494 VGND VGND VPWR VPWR sky130_fd_sc_hd__fill_1
XFILLER_7_605 VGND VGND VPWR VPWR sky130_fd_sc_hd__decap_3
XFILLER_109_511 VGND VGND VPWR VPWR sky130_fd_sc_hd__decap_3
XFILLER_7_638 VGND VGND VPWR VPWR sky130_fd_sc_hd__decap_3
Xwire547 wire547/A VGND VGND VPWR VPWR wire547/X sky130_fd_sc_hd__clkbuf_4
XFILLER_109_555 VGND VGND VPWR VPWR sky130_fd_sc_hd__decap_3
XFILLER_12_62 VGND VGND VPWR VPWR sky130_fd_sc_hd__decap_3
XFILLER_6_159 VGND VGND VPWR VPWR sky130_fd_sc_hd__decap_3
XFILLER_109_577 VGND VGND VPWR VPWR sky130_fd_sc_hd__fill_2
XFILLER_124_503 VGND VGND VPWR VPWR sky130_fd_sc_hd__decap_3
XFILLER_124_525 VGND VGND VPWR VPWR sky130_fd_sc_hd__decap_3
XFILLER_128_62 VGND VGND VPWR VPWR sky130_fd_sc_hd__decap_3
XTAP_TAPCELL_ROW_131_2120 VGND VPWR sky130_fd_sc_hd__tapvpwrvgnd_1
XTAP_TAPCELL_ROW_131_2131 VGND VPWR sky130_fd_sc_hd__tapvpwrvgnd_1
XFILLER_111_208 VGND VGND VPWR VPWR sky130_fd_sc_hd__decap_3
XFILLER_2_365 VGND VGND VPWR VPWR sky130_fd_sc_hd__fill_2
XFILLER_88_88 VGND VGND VPWR VPWR sky130_fd_sc_hd__decap_3
XFILLER_104_271 VGND VGND VPWR VPWR sky130_fd_sc_hd__decap_3
XFILLER_120_775 VGND VGND VPWR VPWR sky130_fd_sc_hd__decap_3
XFILLER_78_678 VGND VGND VPWR VPWR sky130_fd_sc_hd__decap_3
XFILLER_19_9 VGND VGND VPWR VPWR sky130_fd_sc_hd__decap_3
XFILLER_93_615 VGND VGND VPWR VPWR sky130_fd_sc_hd__fill_1
XTAP_TAPCELL_ROW_129_2093 VGND VPWR sky130_fd_sc_hd__tapvpwrvgnd_1
XFILLER_92_136 VGND VGND VPWR VPWR sky130_fd_sc_hd__decap_3
XFILLER_19_778 VGND VGND VPWR VPWR sky130_fd_sc_hd__decap_3
XFILLER_34_704 VGND VGND VPWR VPWR sky130_fd_sc_hd__fill_1
XFILLER_61_512 VGND VGND VPWR VPWR sky130_fd_sc_hd__decap_3
XFILLER_73_361 VGND VGND VPWR VPWR sky130_fd_sc_hd__decap_3
XFILLER_80_309 VGND VGND VPWR VPWR sky130_fd_sc_hd__decap_3
XFILLER_18_299 VGND VGND VPWR VPWR sky130_fd_sc_hd__fill_1
XFILLER_61_545 VGND VGND VPWR VPWR sky130_fd_sc_hd__decap_3
Xclkbuf_leaf_3_CLK clkbuf_leaf_3_CLK/A VGND VGND VPWR VPWR _8729_/CLK sky130_fd_sc_hd__clkbuf_8
XTAP_TAPCELL_ROW_60_1126 VGND VPWR sky130_fd_sc_hd__tapvpwrvgnd_1
XTAP_TAPCELL_ROW_60_1137 VGND VPWR sky130_fd_sc_hd__tapvpwrvgnd_1
XTAP_TAPCELL_ROW_116_1915 VGND VPWR sky130_fd_sc_hd__tapvpwrvgnd_1
XFILLER_6_660 VGND VGND VPWR VPWR sky130_fd_sc_hd__decap_3
X_5300_ _7703_/Q _4875_/X _5310_/S VGND VGND VPWR VPWR _5301_/A sky130_fd_sc_hd__mux2_2
XFILLER_115_558 VGND VGND VPWR VPWR sky130_fd_sc_hd__fill_2
XFILLER_127_396 VGND VGND VPWR VPWR sky130_fd_sc_hd__fill_1
XFILLER_6_693 VGND VGND VPWR VPWR sky130_fd_sc_hd__decap_3
X_6280_ _6280_/A VGND VGND VPWR VPWR _8199_/D sky130_fd_sc_hd__buf_6
XFILLER_5_192 VGND VGND VPWR VPWR sky130_fd_sc_hd__fill_1
XTAP_TAPCELL_ROW_58_1099 VGND VPWR sky130_fd_sc_hd__tapvpwrvgnd_1
X_5231_ _7670_/Q _4735_/X _5247_/S VGND VGND VPWR VPWR _5232_/A sky130_fd_sc_hd__mux2_2
XFILLER_123_591 VGND VGND VPWR VPWR sky130_fd_sc_hd__decap_3
XFILLER_130_528 VGND VGND VPWR VPWR sky130_fd_sc_hd__decap_3
XFILLER_130_539 VGND VGND VPWR VPWR sky130_fd_sc_hd__decap_3
XFILLER_69_634 VGND VGND VPWR VPWR sky130_fd_sc_hd__decap_3
X_5162_ _6314_/A _8049_/Q VGND VGND VPWR VPWR _6486_/B sky130_fd_sc_hd__nand2_2
XTAP_TAPCELL_ROW_71_1288 VGND VPWR sky130_fd_sc_hd__tapvpwrvgnd_1
X_5093_ _4807_/X _7606_/Q _5095_/S VGND VGND VPWR VPWR _5094_/A sky130_fd_sc_hd__mux2_2
X_4113_ _4113_/A VGND VGND VPWR VPWR _4113_/X sky130_fd_sc_hd__buf_1
XFILLER_68_177 VGND VGND VPWR VPWR sky130_fd_sc_hd__fill_2
XFILLER_96_486 VGND VGND VPWR VPWR sky130_fd_sc_hd__decap_3
XFILLER_17_18 VGND VGND VPWR VPWR sky130_fd_sc_hd__decap_3
X_4044_ _7743_/Q _7824_/Q _7905_/Q _7986_/Q _4091_/S0 _4106_/S1 VGND VGND VPWR VPWR
+ _4044_/X sky130_fd_sc_hd__mux4_2
XFILLER_25_704 VGND VGND VPWR VPWR sky130_fd_sc_hd__decap_3
XFILLER_92_670 VGND VGND VPWR VPWR sky130_fd_sc_hd__fill_2
XFILLER_52_523 VGND VGND VPWR VPWR sky130_fd_sc_hd__fill_1
X_8783_ _8783_/CLK _8783_/D fanout683/X VGND VGND VPWR VPWR _8783_/Q sky130_fd_sc_hd__dfrtp_2
X_7803_ _8785_/CLK _7803_/D load_slew676/X VGND VGND VPWR VPWR _7803_/Q sky130_fd_sc_hd__dfrtp_2
XFILLER_24_247 VGND VGND VPWR VPWR sky130_fd_sc_hd__fill_1
X_7734_ _8680_/CLK _7734_/D wire693/X VGND VGND VPWR VPWR _7734_/Q sky130_fd_sc_hd__dfrtp_2
X_5995_ _8065_/Q input5/X _6011_/S VGND VGND VPWR VPWR _5996_/A sky130_fd_sc_hd__mux2_2
XFILLER_52_589 VGND VGND VPWR VPWR sky130_fd_sc_hd__fill_1
XTAP_TAPCELL_ROW_35_776 VGND VPWR sky130_fd_sc_hd__tapvpwrvgnd_1
XTAP_TAPCELL_ROW_35_787 VGND VPWR sky130_fd_sc_hd__tapvpwrvgnd_1
X_4946_ _6314_/A _7004_/B _6314_/C _5679_/D VGND VGND VPWR VPWR _4947_/A sky130_fd_sc_hd__or4b_2
X_7665_ _8647_/CLK _7665_/D fanout532/X VGND VGND VPWR VPWR _7665_/Q sky130_fd_sc_hd__dfrtp_2
X_4877_ _4877_/A VGND VGND VPWR VPWR _7541_/D sky130_fd_sc_hd__buf_1
X_3828_ _4117_/A VGND VGND VPWR VPWR _3828_/X sky130_fd_sc_hd__clkbuf_2
X_7596_ _8586_/CLK _7596_/D load_slew536/X VGND VGND VPWR VPWR _7596_/Q sky130_fd_sc_hd__dfrtp_2
X_6616_ _6616_/A VGND VGND VPWR VPWR _8357_/D sky130_fd_sc_hd__buf_2
XFILLER_118_330 VGND VGND VPWR VPWR sky130_fd_sc_hd__fill_2
X_6547_ _4723_/X _8325_/Q _6549_/S VGND VGND VPWR VPWR _6548_/A sky130_fd_sc_hd__mux2_2
XFILLER_4_619 VGND VGND VPWR VPWR sky130_fd_sc_hd__decap_3
X_3759_ _3955_/A VGND VGND VPWR VPWR _3865_/S sky130_fd_sc_hd__clkbuf_2
XFILLER_106_536 VGND VGND VPWR VPWR sky130_fd_sc_hd__decap_3
XFILLER_133_311 VGND VGND VPWR VPWR sky130_fd_sc_hd__decap_3
X_6478_ _4929_/X _8293_/Q _6482_/S VGND VGND VPWR VPWR _6479_/A sky130_fd_sc_hd__mux2_2
XFILLER_0_803 VGND VGND VPWR VPWR sky130_fd_sc_hd__fill_1
XFILLER_106_569 VGND VGND VPWR VPWR sky130_fd_sc_hd__decap_3
XFILLER_133_355 VGND VGND VPWR VPWR sky130_fd_sc_hd__decap_3
X_8217_ _8786_/CLK _8217_/D load_slew667/X VGND VGND VPWR VPWR _8217_/Q sky130_fd_sc_hd__dfrtp_2
X_5429_ _5429_/A VGND VGND VPWR VPWR _7763_/D sky130_fd_sc_hd__buf_1
XFILLER_121_528 VGND VGND VPWR VPWR sky130_fd_sc_hd__decap_3
XFILLER_133_388 VGND VGND VPWR VPWR sky130_fd_sc_hd__decap_3
XFILLER_133_399 VGND VGND VPWR VPWR sky130_fd_sc_hd__decap_3
XFILLER_87_420 VGND VGND VPWR VPWR sky130_fd_sc_hd__decap_3
X_8148_ _8761_/CLK _8148_/D wire707/X VGND VGND VPWR VPWR _8148_/Q sky130_fd_sc_hd__dfrtp_2
XFILLER_102_753 VGND VGND VPWR VPWR sky130_fd_sc_hd__decap_3
XFILLER_75_626 VGND VGND VPWR VPWR sky130_fd_sc_hd__decap_3
XTAP_TAPCELL_ROW_89_1538 VGND VPWR sky130_fd_sc_hd__tapvpwrvgnd_1
X_8079_ _8727_/CLK _8079_/D load_slew533/X VGND VGND VPWR VPWR _8079_/Q sky130_fd_sc_hd__dfrtp_2
XFILLER_74_125 VGND VGND VPWR VPWR sky130_fd_sc_hd__fill_2
XFILLER_74_24 VGND VGND VPWR VPWR sky130_fd_sc_hd__decap_3
XFILLER_16_704 VGND VGND VPWR VPWR sky130_fd_sc_hd__decap_3
XFILLER_74_35 VGND VGND VPWR VPWR sky130_fd_sc_hd__decap_3
XFILLER_90_607 VGND VGND VPWR VPWR sky130_fd_sc_hd__decap_3
XFILLER_16_737 VGND VGND VPWR VPWR sky130_fd_sc_hd__fill_1
XFILLER_28_586 VGND VGND VPWR VPWR sky130_fd_sc_hd__fill_2
XFILLER_70_320 VGND VGND VPWR VPWR sky130_fd_sc_hd__decap_3
XFILLER_82_180 VGND VGND VPWR VPWR sky130_fd_sc_hd__decap_3
XFILLER_130_41 VGND VGND VPWR VPWR sky130_fd_sc_hd__decap_3
XFILLER_130_74 VGND VGND VPWR VPWR sky130_fd_sc_hd__decap_3
XFILLER_130_85 VGND VGND VPWR VPWR sky130_fd_sc_hd__decap_3
XFILLER_24_781 VGND VGND VPWR VPWR sky130_fd_sc_hd__fill_2
XFILLER_30_206 VGND VGND VPWR VPWR sky130_fd_sc_hd__decap_3
XFILLER_30_228 VGND VGND VPWR VPWR sky130_fd_sc_hd__decap_3
XFILLER_129_606 VGND VGND VPWR VPWR sky130_fd_sc_hd__decap_3
XFILLER_129_617 VGND VGND VPWR VPWR sky130_fd_sc_hd__decap_3
XFILLER_23_291 VGND VGND VPWR VPWR sky130_fd_sc_hd__decap_3
XFILLER_90_56 VGND VGND VPWR VPWR sky130_fd_sc_hd__decap_3
XFILLER_128_127 VGND VGND VPWR VPWR sky130_fd_sc_hd__decap_3
XFILLER_23_50 VGND VGND VPWR VPWR sky130_fd_sc_hd__decap_3
XFILLER_23_72 VGND VGND VPWR VPWR sky130_fd_sc_hd__decap_3
XFILLER_7_424 VGND VGND VPWR VPWR sky130_fd_sc_hd__decap_3
XFILLER_23_94 VGND VGND VPWR VPWR sky130_fd_sc_hd__fill_1
XFILLER_7_457 VGND VGND VPWR VPWR sky130_fd_sc_hd__decap_3
XFILLER_109_352 VGND VGND VPWR VPWR sky130_fd_sc_hd__decap_3
XFILLER_99_43 VGND VGND VPWR VPWR sky130_fd_sc_hd__decap_3
XFILLER_109_385 VGND VGND VPWR VPWR sky130_fd_sc_hd__decap_3
XFILLER_109_396 VGND VGND VPWR VPWR sky130_fd_sc_hd__fill_2
XFILLER_3_641 VGND VGND VPWR VPWR sky130_fd_sc_hd__decap_3
XFILLER_3_685 VGND VGND VPWR VPWR sky130_fd_sc_hd__decap_3
XFILLER_97_217 VGND VGND VPWR VPWR sky130_fd_sc_hd__decap_3
XFILLER_97_228 VGND VGND VPWR VPWR sky130_fd_sc_hd__fill_1
XTAP_TAPCELL_ROW_111_1845 VGND VPWR sky130_fd_sc_hd__tapvpwrvgnd_1
XFILLER_78_431 VGND VGND VPWR VPWR sky130_fd_sc_hd__decap_3
Xload_slew349 _4039_/S1 VGND VGND VPWR VPWR _4498_/A sky130_fd_sc_hd__buf_4
XFILLER_93_412 VGND VGND VPWR VPWR sky130_fd_sc_hd__decap_3
XFILLER_17_6 VGND VGND VPWR VPWR sky130_fd_sc_hd__decap_3
XFILLER_48_80 VGND VGND VPWR VPWR sky130_fd_sc_hd__decap_3
XFILLER_48_91 VGND VGND VPWR VPWR sky130_fd_sc_hd__decap_3
XFILLER_66_648 VGND VGND VPWR VPWR sky130_fd_sc_hd__decap_3
XFILLER_0_21 VGND VGND VPWR VPWR sky130_fd_sc_hd__decap_3
XFILLER_0_32 VGND VGND VPWR VPWR sky130_fd_sc_hd__decap_3
XFILLER_19_564 VGND VGND VPWR VPWR sky130_fd_sc_hd__fill_1
XFILLER_46_361 VGND VGND VPWR VPWR sky130_fd_sc_hd__decap_3
XFILLER_61_320 VGND VGND VPWR VPWR sky130_fd_sc_hd__decap_3
XFILLER_80_128 VGND VGND VPWR VPWR sky130_fd_sc_hd__decap_3
X_4800_ _4799_/X _7523_/Q _4820_/S VGND VGND VPWR VPWR _4801_/A sky130_fd_sc_hd__mux2_2
XFILLER_15_781 VGND VGND VPWR VPWR sky130_fd_sc_hd__decap_3
XFILLER_21_228 VGND VGND VPWR VPWR sky130_fd_sc_hd__decap_3
XFILLER_34_578 VGND VGND VPWR VPWR sky130_fd_sc_hd__fill_1
XFILLER_34_589 VGND VGND VPWR VPWR sky130_fd_sc_hd__decap_3
XFILLER_61_386 VGND VGND VPWR VPWR sky130_fd_sc_hd__decap_3
XFILLER_9_30 VGND VGND VPWR VPWR sky130_fd_sc_hd__decap_3
X_5780_ _7929_/Q _4803_/A _5784_/S VGND VGND VPWR VPWR _5781_/A sky130_fd_sc_hd__mux2_2
XFILLER_14_280 VGND VGND VPWR VPWR sky130_fd_sc_hd__decap_3
XFILLER_9_63 VGND VGND VPWR VPWR sky130_fd_sc_hd__decap_3
XTAP_TAPCELL_ROW_122_1996 VGND VPWR sky130_fd_sc_hd__tapvpwrvgnd_1
XTAP_TAPCELL_ROW_32_735 VGND VPWR sky130_fd_sc_hd__tapvpwrvgnd_1
XTAP_TAPCELL_ROW_32_746 VGND VPWR sky130_fd_sc_hd__tapvpwrvgnd_1
X_4731_ _4731_/A VGND VGND VPWR VPWR _4731_/X sky130_fd_sc_hd__buf_1
XFILLER_9_96 VGND VGND VPWR VPWR sky130_fd_sc_hd__fill_2
X_7450_ _7450_/A VGND VGND VPWR VPWR _8781_/D sky130_fd_sc_hd__buf_1
X_4662_ _8132_/Q _8213_/Q _4662_/S VGND VGND VPWR VPWR _4662_/X sky130_fd_sc_hd__mux2_2
X_6401_ _4773_/X hold929/X _6419_/S VGND VGND VPWR VPWR _6402_/A sky130_fd_sc_hd__mux2_1
XFILLER_128_672 VGND VGND VPWR VPWR sky130_fd_sc_hd__decap_3
Xhold903 _8001_/Q VGND VGND VPWR VPWR hold903/X sky130_fd_sc_hd__dlygate4sd3_1
X_7381_ _7381_/A VGND VGND VPWR VPWR _8748_/D sky130_fd_sc_hd__buf_1
X_4593_ _7793_/Q _7874_/Q _4630_/S VGND VGND VPWR VPWR _4593_/X sky130_fd_sc_hd__mux2_2
XFILLER_127_193 VGND VGND VPWR VPWR sky130_fd_sc_hd__decap_3
Xhold914 _8043_/Q VGND VGND VPWR VPWR hold914/X sky130_fd_sc_hd__dlygate4sd3_1
Xhold925 _8568_/Q VGND VGND VPWR VPWR hold925/X sky130_fd_sc_hd__dlygate4sd3_1
Xhold936 _8228_/Q VGND VGND VPWR VPWR hold936/X sky130_fd_sc_hd__dlygate4sd3_1
X_6332_ _6332_/A VGND VGND VPWR VPWR _8223_/D sky130_fd_sc_hd__buf_2
XFILLER_103_517 VGND VGND VPWR VPWR sky130_fd_sc_hd__decap_3
XFILLER_89_729 VGND VGND VPWR VPWR sky130_fd_sc_hd__decap_3
XTAP_TAPCELL_ROW_73_1317 VGND VPWR sky130_fd_sc_hd__tapvpwrvgnd_1
Xhold947 _8544_/Q VGND VGND VPWR VPWR hold947/X sky130_fd_sc_hd__dlygate4sd3_1
Xhold958 _7624_/Q VGND VGND VPWR VPWR hold958/X sky130_fd_sc_hd__dlygate4sd3_1
Xhold969 _7587_/Q VGND VGND VPWR VPWR hold969/X sky130_fd_sc_hd__dlygate4sd3_1
X_6263_ _6263_/A VGND VGND VPWR VPWR _8191_/D sky130_fd_sc_hd__buf_6
XFILLER_115_388 VGND VGND VPWR VPWR sky130_fd_sc_hd__fill_1
X_8002_ _8734_/CLK _8002_/D load_slew524/X VGND VGND VPWR VPWR _8002_/Q sky130_fd_sc_hd__dfrtp_2
X_5214_ _7662_/Q _4703_/X _5226_/S VGND VGND VPWR VPWR _5215_/A sky130_fd_sc_hd__mux2_2
X_6194_ _6194_/A VGND VGND VPWR VPWR _8158_/D sky130_fd_sc_hd__buf_6
XFILLER_29_317 VGND VGND VPWR VPWR sky130_fd_sc_hd__fill_1
XFILLER_29_328 VGND VGND VPWR VPWR sky130_fd_sc_hd__decap_3
XFILLER_57_604 VGND VGND VPWR VPWR sky130_fd_sc_hd__decap_3
XFILLER_69_464 VGND VGND VPWR VPWR sky130_fd_sc_hd__decap_3
X_5145_ _5145_/A VGND VGND VPWR VPWR _7630_/D sky130_fd_sc_hd__buf_1
X_5076_ _5160_/S VGND VGND VPWR VPWR _5095_/S sky130_fd_sc_hd__buf_2
XFILLER_44_309 VGND VGND VPWR VPWR sky130_fd_sc_hd__fill_1
X_4027_ _8723_/Q _8804_/Q _7579_/Q _7660_/Q _4098_/S0 _4036_/A VGND VGND VPWR VPWR
+ _4027_/X sky130_fd_sc_hd__mux4_2
XFILLER_65_670 VGND VGND VPWR VPWR sky130_fd_sc_hd__fill_2
XFILLER_25_556 VGND VGND VPWR VPWR sky130_fd_sc_hd__decap_3
XTAP_TAPCELL_ROW_84_1468 VGND VPWR sky130_fd_sc_hd__tapvpwrvgnd_1
XFILLER_12_206 VGND VGND VPWR VPWR sky130_fd_sc_hd__decap_3
X_8766_ _8766_/CLK _8766_/D fanout575/X VGND VGND VPWR VPWR _8766_/Q sky130_fd_sc_hd__dfrtp_2
X_5978_ _5978_/A0 _4960_/A _5990_/S VGND VGND VPWR VPWR _5979_/A sky130_fd_sc_hd__mux2_2
XFILLER_100_22 VGND VGND VPWR VPWR sky130_fd_sc_hd__decap_3
XFILLER_21_740 VGND VGND VPWR VPWR sky130_fd_sc_hd__decap_3
X_8697_ _8697_/CLK _8697_/D load_slew729/X VGND VGND VPWR VPWR _8697_/Q sky130_fd_sc_hd__dfrtp_2
X_7717_ _8780_/CLK _7717_/D load_slew722/X VGND VGND VPWR VPWR _7717_/Q sky130_fd_sc_hd__dfrtp_2
X_4929_ _4929_/A VGND VGND VPWR VPWR _4929_/X sky130_fd_sc_hd__buf_1
XFILLER_100_88 VGND VGND VPWR VPWR sky130_fd_sc_hd__decap_3
XFILLER_60_37 VGND VGND VPWR VPWR sky130_fd_sc_hd__decap_3
X_7648_ _8622_/CLK _7648_/D load_slew655/X VGND VGND VPWR VPWR _7648_/Q sky130_fd_sc_hd__dfrtp_2
XFILLER_20_283 VGND VGND VPWR VPWR sky130_fd_sc_hd__decap_3
XTAP_TAPCELL_ROW_10_429 VGND VPWR sky130_fd_sc_hd__tapvpwrvgnd_1
XFILLER_109_31 VGND VGND VPWR VPWR sky130_fd_sc_hd__decap_3
XFILLER_119_661 VGND VGND VPWR VPWR sky130_fd_sc_hd__decap_3
XFILLER_125_119 VGND VGND VPWR VPWR sky130_fd_sc_hd__fill_1
X_7579_ _8729_/CLK _7579_/D wire476/X VGND VGND VPWR VPWR _7579_/Q sky130_fd_sc_hd__dfrtp_2
XFILLER_134_620 VGND VGND VPWR VPWR sky130_fd_sc_hd__decap_3
XFILLER_133_152 VGND VGND VPWR VPWR sky130_fd_sc_hd__decap_3
XFILLER_134_675 VGND VGND VPWR VPWR sky130_fd_sc_hd__decap_3
XFILLER_69_35 VGND VGND VPWR VPWR sky130_fd_sc_hd__decap_3
XFILLER_69_57 VGND VGND VPWR VPWR sky130_fd_sc_hd__decap_3
XFILLER_0_600 VGND VGND VPWR VPWR sky130_fd_sc_hd__decap_3
XFILLER_79_228 VGND VGND VPWR VPWR sky130_fd_sc_hd__decap_3
XFILLER_0_633 VGND VGND VPWR VPWR sky130_fd_sc_hd__decap_3
XFILLER_125_30 VGND VGND VPWR VPWR sky130_fd_sc_hd__decap_3
XFILLER_133_196 VGND VGND VPWR VPWR sky130_fd_sc_hd__decap_3
XFILLER_88_751 VGND VGND VPWR VPWR sky130_fd_sc_hd__decap_3
XFILLER_0_666 VGND VGND VPWR VPWR sky130_fd_sc_hd__decap_3
XFILLER_0_688 VGND VGND VPWR VPWR sky130_fd_sc_hd__decap_3
XFILLER_102_572 VGND VGND VPWR VPWR sky130_fd_sc_hd__decap_3
XFILLER_125_96 VGND VGND VPWR VPWR sky130_fd_sc_hd__decap_3
XFILLER_75_445 VGND VGND VPWR VPWR sky130_fd_sc_hd__decap_3
XFILLER_18_50 VGND VGND VPWR VPWR sky130_fd_sc_hd__decap_3
XFILLER_47_169 VGND VGND VPWR VPWR sky130_fd_sc_hd__decap_3
XFILLER_85_78 VGND VGND VPWR VPWR sky130_fd_sc_hd__decap_3
XTAP_TAPCELL_ROW_126_2052 VGND VPWR sky130_fd_sc_hd__tapvpwrvgnd_1
XTAP_TAPCELL_ROW_126_2063 VGND VPWR sky130_fd_sc_hd__tapvpwrvgnd_1
XFILLER_18_83 VGND VGND VPWR VPWR sky130_fd_sc_hd__fill_1
XFILLER_16_556 VGND VGND VPWR VPWR sky130_fd_sc_hd__decap_3
XFILLER_71_640 VGND VGND VPWR VPWR sky130_fd_sc_hd__fill_1
XFILLER_90_459 VGND VGND VPWR VPWR sky130_fd_sc_hd__decap_3
XFILLER_16_589 VGND VGND VPWR VPWR sky130_fd_sc_hd__decap_3
XFILLER_43_386 VGND VGND VPWR VPWR sky130_fd_sc_hd__decap_3
XFILLER_71_673 VGND VGND VPWR VPWR sky130_fd_sc_hd__decap_3
XFILLER_43_397 VGND VGND VPWR VPWR sky130_fd_sc_hd__decap_3
XFILLER_70_183 VGND VGND VPWR VPWR sky130_fd_sc_hd__decap_3
XFILLER_129_414 VGND VGND VPWR VPWR sky130_fd_sc_hd__decap_3
XFILLER_8_722 VGND VGND VPWR VPWR sky130_fd_sc_hd__decap_3
XFILLER_11_272 VGND VGND VPWR VPWR sky130_fd_sc_hd__decap_3
XFILLER_129_447 VGND VGND VPWR VPWR sky130_fd_sc_hd__fill_1
XFILLER_129_458 VGND VGND VPWR VPWR sky130_fd_sc_hd__decap_3
XFILLER_12_784 VGND VGND VPWR VPWR sky130_fd_sc_hd__decap_3
XFILLER_7_210 VGND VGND VPWR VPWR sky130_fd_sc_hd__decap_3
XFILLER_7_221 VGND VGND VPWR VPWR sky130_fd_sc_hd__decap_3
XFILLER_8_755 VGND VGND VPWR VPWR sky130_fd_sc_hd__fill_1
XFILLER_7_254 VGND VGND VPWR VPWR sky130_fd_sc_hd__decap_3
XFILLER_8_766 VGND VGND VPWR VPWR sky130_fd_sc_hd__decap_3
XFILLER_8_799 VGND VGND VPWR VPWR sky130_fd_sc_hd__decap_3
Xwire196 _5291_/A VGND VGND VPWR VPWR _5333_/S sky130_fd_sc_hd__buf_2
XFILLER_124_141 VGND VGND VPWR VPWR sky130_fd_sc_hd__decap_3
XFILLER_112_303 VGND VGND VPWR VPWR sky130_fd_sc_hd__fill_1
XTAP_TAPCELL_ROW_55_1058 VGND VPWR sky130_fd_sc_hd__tapvpwrvgnd_1
XFILLER_112_347 VGND VGND VPWR VPWR sky130_fd_sc_hd__decap_3
XFILLER_79_740 VGND VGND VPWR VPWR sky130_fd_sc_hd__fill_2
XTAP_TAPCELL_ROW_55_1069 VGND VPWR sky130_fd_sc_hd__tapvpwrvgnd_1
XFILLER_39_626 VGND VGND VPWR VPWR sky130_fd_sc_hd__decap_3
XFILLER_66_401 VGND VGND VPWR VPWR sky130_fd_sc_hd__fill_1
XFILLER_120_380 VGND VGND VPWR VPWR sky130_fd_sc_hd__decap_3
XFILLER_15_3 VGND VGND VPWR VPWR sky130_fd_sc_hd__decap_3
XFILLER_26_309 VGND VGND VPWR VPWR sky130_fd_sc_hd__decap_3
XFILLER_66_467 VGND VGND VPWR VPWR sky130_fd_sc_hd__decap_3
XFILLER_93_242 VGND VGND VPWR VPWR sky130_fd_sc_hd__fill_1
XFILLER_94_776 VGND VGND VPWR VPWR sky130_fd_sc_hd__decap_3
XTAP_TAPCELL_ROW_37_805 VGND VPWR sky130_fd_sc_hd__tapvpwrvgnd_1
XTAP_TAPCELL_ROW_37_816 VGND VPWR sky130_fd_sc_hd__tapvpwrvgnd_1
X_6950_ _4837_/X _8514_/Q _6958_/S VGND VGND VPWR VPWR _6951_/A sky130_fd_sc_hd__mux2_4
XFILLER_47_670 VGND VGND VPWR VPWR sky130_fd_sc_hd__fill_2
X_5901_ _5906_/A1 _5906_/A2 _4749_/X _5906_/B1 hold884/X VGND VGND VPWR VPWR _7997_/D
+ sky130_fd_sc_hd__a32o_2
XFILLER_34_320 VGND VGND VPWR VPWR sky130_fd_sc_hd__decap_3
XFILLER_62_651 VGND VGND VPWR VPWR sky130_fd_sc_hd__decap_3
X_6881_ _4691_/X _8481_/Q _6895_/S VGND VGND VPWR VPWR _6882_/A sky130_fd_sc_hd__mux2_4
XFILLER_62_684 VGND VGND VPWR VPWR sky130_fd_sc_hd__decap_3
X_8620_ _8701_/CLK _8620_/D load_slew647/X VGND VGND VPWR VPWR _8620_/Q sky130_fd_sc_hd__dfrtp_2
X_5832_ _5832_/A VGND VGND VPWR VPWR _7953_/D sky130_fd_sc_hd__buf_1
XFILLER_61_194 VGND VGND VPWR VPWR sky130_fd_sc_hd__decap_3
X_8551_ _8794_/CLK _8551_/D load_slew584/X VGND VGND VPWR VPWR _8551_/Q sky130_fd_sc_hd__dfrtp_2
X_5763_ _7921_/Q _4769_/A _5763_/S VGND VGND VPWR VPWR _5764_/A sky130_fd_sc_hd__mux2_2
X_7502_ _8646_/CLK _7502_/D wire531/X VGND VGND VPWR VPWR _7502_/Q sky130_fd_sc_hd__dfrtp_2
X_4714_ _4714_/A _4726_/B VGND VGND VPWR VPWR _4715_/A sky130_fd_sc_hd__and2_2
X_8482_ _8725_/CLK _8482_/D fanout493/X VGND VGND VPWR VPWR _8482_/Q sky130_fd_sc_hd__dfrtp_2
X_5694_ _7888_/Q _4973_/A _5700_/S VGND VGND VPWR VPWR _5695_/A sky130_fd_sc_hd__mux2_2
XFILLER_30_18 VGND VGND VPWR VPWR sky130_fd_sc_hd__fill_1
XFILLER_30_29 VGND VGND VPWR VPWR sky130_fd_sc_hd__decap_3
X_7433_ _8773_/Q _4902_/A _7449_/S VGND VGND VPWR VPWR _7434_/A sky130_fd_sc_hd__mux2_2
X_4645_ _8374_/Q _3774_/X _4645_/B1 _8293_/Q _4677_/C1 VGND VGND VPWR VPWR _4645_/X
+ sky130_fd_sc_hd__o221a_2
XFILLER_128_480 VGND VGND VPWR VPWR sky130_fd_sc_hd__decap_3
X_7364_ _7364_/A VGND VGND VPWR VPWR _8740_/D sky130_fd_sc_hd__buf_1
X_4576_ _8125_/Q _8206_/Q _4579_/S VGND VGND VPWR VPWR _4576_/X sky130_fd_sc_hd__mux2_2
XFILLER_116_675 VGND VGND VPWR VPWR sky130_fd_sc_hd__decap_3
Xclkbuf_5_20__f_CLK clkbuf_4_10_0_CLK/X VGND VGND VPWR VPWR clkbuf_5_20__f_CLK/X sky130_fd_sc_hd__clkbuf_16
X_6315_ _6315_/A VGND VGND VPWR VPWR _6484_/S sky130_fd_sc_hd__buf_2
XFILLER_130_100 VGND VGND VPWR VPWR sky130_fd_sc_hd__decap_3
XFILLER_131_612 VGND VGND VPWR VPWR sky130_fd_sc_hd__decap_3
XFILLER_131_623 VGND VGND VPWR VPWR sky130_fd_sc_hd__decap_3
Xhold766 _7965_/Q VGND VGND VPWR VPWR hold766/X sky130_fd_sc_hd__dlygate4sd3_1
Xhold777 _8631_/Q VGND VGND VPWR VPWR hold777/X sky130_fd_sc_hd__dlygate4sd3_1
Xhold788 _8651_/Q VGND VGND VPWR VPWR hold788/X sky130_fd_sc_hd__dlygate4sd3_1
X_7295_ _7295_/A VGND VGND VPWR VPWR _8707_/D sky130_fd_sc_hd__buf_1
XFILLER_115_196 VGND VGND VPWR VPWR sky130_fd_sc_hd__decap_3
XFILLER_130_133 VGND VGND VPWR VPWR sky130_fd_sc_hd__decap_3
XFILLER_130_144 VGND VGND VPWR VPWR sky130_fd_sc_hd__decap_3
XFILLER_131_656 VGND VGND VPWR VPWR sky130_fd_sc_hd__decap_3
XFILLER_89_559 VGND VGND VPWR VPWR sky130_fd_sc_hd__fill_1
Xhold799 _8660_/Q VGND VGND VPWR VPWR hold799/X sky130_fd_sc_hd__dlygate4sd3_1
X_6246_ _6246_/A VGND VGND VPWR VPWR _8183_/D sky130_fd_sc_hd__buf_6
XFILLER_130_177 VGND VGND VPWR VPWR sky130_fd_sc_hd__decap_3
XFILLER_76_209 VGND VGND VPWR VPWR sky130_fd_sc_hd__decap_3
XFILLER_85_710 VGND VGND VPWR VPWR sky130_fd_sc_hd__decap_3
X_6177_ _6177_/A VGND VGND VPWR VPWR _8150_/D sky130_fd_sc_hd__buf_6
Xload_slew691 fanout690/X VGND VGND VPWR VPWR load_slew691/X sky130_fd_sc_hd__buf_2
X_5128_ _5128_/A VGND VGND VPWR VPWR _7622_/D sky130_fd_sc_hd__buf_1
XFILLER_29_169 VGND VGND VPWR VPWR sky130_fd_sc_hd__decap_3
XFILLER_84_253 VGND VGND VPWR VPWR sky130_fd_sc_hd__decap_3
XFILLER_45_629 VGND VGND VPWR VPWR sky130_fd_sc_hd__decap_3
XFILLER_55_48 VGND VGND VPWR VPWR sky130_fd_sc_hd__decap_3
XFILLER_84_286 VGND VGND VPWR VPWR sky130_fd_sc_hd__decap_3
X_5059_ _5059_/A VGND VGND VPWR VPWR _7589_/D sky130_fd_sc_hd__buf_1
XFILLER_25_331 VGND VGND VPWR VPWR sky130_fd_sc_hd__decap_3
XFILLER_13_526 VGND VGND VPWR VPWR sky130_fd_sc_hd__decap_3
XFILLER_53_684 VGND VGND VPWR VPWR sky130_fd_sc_hd__decap_3
XFILLER_13_559 VGND VGND VPWR VPWR sky130_fd_sc_hd__fill_1
XFILLER_52_194 VGND VGND VPWR VPWR sky130_fd_sc_hd__fill_2
XFILLER_9_508 VGND VGND VPWR VPWR sky130_fd_sc_hd__fill_1
XFILLER_40_345 VGND VGND VPWR VPWR sky130_fd_sc_hd__decap_3
X_8749_ _8749_/CLK _8749_/D load_slew633/X VGND VGND VPWR VPWR _8749_/Q sky130_fd_sc_hd__dfrtp_2
XPHY_EDGE_ROW_109_Right_109 VGND VGND VPWR VPWR sky130_fd_sc_hd__decap_3
XFILLER_126_417 VGND VGND VPWR VPWR sky130_fd_sc_hd__decap_3
XFILLER_5_703 VGND VGND VPWR VPWR sky130_fd_sc_hd__decap_3
XTAP_TAPCELL_ROW_97_1648 VGND VPWR sky130_fd_sc_hd__tapvpwrvgnd_1
XFILLER_126_439 VGND VGND VPWR VPWR sky130_fd_sc_hd__decap_3
XFILLER_5_747 VGND VGND VPWR VPWR sky130_fd_sc_hd__decap_3
XFILLER_134_483 VGND VGND VPWR VPWR sky130_fd_sc_hd__decap_3
XFILLER_20_62 VGND VGND VPWR VPWR sky130_fd_sc_hd__decap_3
XFILLER_4_268 VGND VGND VPWR VPWR sky130_fd_sc_hd__fill_2
XFILLER_122_645 VGND VGND VPWR VPWR sky130_fd_sc_hd__decap_3
XFILLER_121_155 VGND VGND VPWR VPWR sky130_fd_sc_hd__decap_3
XFILLER_76_710 VGND VGND VPWR VPWR sky130_fd_sc_hd__decap_3
XFILLER_48_412 VGND VGND VPWR VPWR sky130_fd_sc_hd__decap_3
XFILLER_96_99 VGND VGND VPWR VPWR sky130_fd_sc_hd__decap_3
XFILLER_48_456 VGND VGND VPWR VPWR sky130_fd_sc_hd__fill_2
XFILLER_75_231 VGND VGND VPWR VPWR sky130_fd_sc_hd__fill_2
XFILLER_29_670 VGND VGND VPWR VPWR sky130_fd_sc_hd__fill_2
XFILLER_48_489 VGND VGND VPWR VPWR sky130_fd_sc_hd__fill_1
XFILLER_28_191 VGND VGND VPWR VPWR sky130_fd_sc_hd__fill_1
XFILLER_35_139 VGND VGND VPWR VPWR sky130_fd_sc_hd__decap_3
XFILLER_90_256 VGND VGND VPWR VPWR sky130_fd_sc_hd__decap_3
XTAP_TAPCELL_ROW_106_1777 VGND VPWR sky130_fd_sc_hd__tapvpwrvgnd_1
XFILLER_16_397 VGND VGND VPWR VPWR sky130_fd_sc_hd__fill_2
XFILLER_43_172 VGND VGND VPWR VPWR sky130_fd_sc_hd__fill_2
XFILLER_31_345 VGND VGND VPWR VPWR sky130_fd_sc_hd__decap_3
XFILLER_31_378 VGND VGND VPWR VPWR sky130_fd_sc_hd__fill_1
XTAP_TAPCELL_ROW_42_874 VGND VPWR sky130_fd_sc_hd__tapvpwrvgnd_1
XFILLER_129_211 VGND VGND VPWR VPWR sky130_fd_sc_hd__decap_3
XFILLER_8_530 VGND VGND VPWR VPWR sky130_fd_sc_hd__fill_2
XTAP_TAPCELL_ROW_42_885 VGND VPWR sky130_fd_sc_hd__tapvpwrvgnd_1
XFILLER_129_255 VGND VGND VPWR VPWR sky130_fd_sc_hd__decap_3
XFILLER_12_592 VGND VGND VPWR VPWR sky130_fd_sc_hd__decap_3
XFILLER_61_91 VGND VGND VPWR VPWR sky130_fd_sc_hd__decap_3
XFILLER_8_563 VGND VGND VPWR VPWR sky130_fd_sc_hd__decap_3
XANTENNA_2 _3735_/X VGND VGND VPWR VPWR sky130_fd_sc_hd__diode_2
X_4430_ _4456_/C1 _4429_/X _4617_/B1 VGND VGND VPWR VPWR _4430_/X sky130_fd_sc_hd__a21o_2
XFILLER_132_409 VGND VGND VPWR VPWR sky130_fd_sc_hd__decap_3
XFILLER_6_53 VGND VGND VPWR VPWR sky130_fd_sc_hd__decap_3
XFILLER_113_623 VGND VGND VPWR VPWR sky130_fd_sc_hd__decap_3
X_6100_ _6100_/A0 _4860_/A _6116_/S VGND VGND VPWR VPWR _6101_/A sky130_fd_sc_hd__mux2_2
X_4361_ _8430_/Q _8511_/Q _8592_/Q _8673_/Q _4367_/S _4368_/A VGND VGND VPWR VPWR
+ _4361_/X sky130_fd_sc_hd__mux4_2
XFILLER_112_111 VGND VGND VPWR VPWR sky130_fd_sc_hd__decap_3
XFILLER_98_345 VGND VGND VPWR VPWR sky130_fd_sc_hd__decap_3
X_7080_ _4753_/X _8575_/Q _7088_/S VGND VGND VPWR VPWR _7081_/A sky130_fd_sc_hd__mux2_1
X_4292_ _3739_/B _4290_/X _4291_/X VGND VGND VPWR VPWR _4292_/X sky130_fd_sc_hd__o21a_2
XFILLER_58_209 VGND VGND VPWR VPWR sky130_fd_sc_hd__fill_1
XFILLER_98_389 VGND VGND VPWR VPWR sky130_fd_sc_hd__fill_1
X_6031_ _6031_/A VGND VGND VPWR VPWR _8082_/D sky130_fd_sc_hd__buf_2
XFILLER_66_242 VGND VGND VPWR VPWR sky130_fd_sc_hd__fill_1
XFILLER_66_253 VGND VGND VPWR VPWR sky130_fd_sc_hd__fill_2
XFILLER_26_106 VGND VGND VPWR VPWR sky130_fd_sc_hd__fill_2
XFILLER_94_584 VGND VGND VPWR VPWR sky130_fd_sc_hd__decap_3
XFILLER_94_595 VGND VGND VPWR VPWR sky130_fd_sc_hd__fill_2
XTAP_TAPCELL_ROW_68_1238 VGND VPWR sky130_fd_sc_hd__tapvpwrvgnd_1
X_7982_ _8802_/CLK _7982_/D fanout594/X VGND VGND VPWR VPWR _7982_/Q sky130_fd_sc_hd__dfrtp_2
XFILLER_25_18 VGND VGND VPWR VPWR sky130_fd_sc_hd__decap_3
XFILLER_26_139 VGND VGND VPWR VPWR sky130_fd_sc_hd__fill_1
XTAP_TAPCELL_ROW_68_1249 VGND VPWR sky130_fd_sc_hd__tapvpwrvgnd_1
X_6933_ _4803_/X _8506_/Q _6937_/S VGND VGND VPWR VPWR _6934_/A sky130_fd_sc_hd__mux2_4
X_6864_ _5007_/X _8473_/Q _6874_/S VGND VGND VPWR VPWR _6865_/A sky130_fd_sc_hd__mux2_4
XFILLER_22_334 VGND VGND VPWR VPWR sky130_fd_sc_hd__decap_3
XFILLER_34_183 VGND VGND VPWR VPWR sky130_fd_sc_hd__decap_3
XFILLER_62_492 VGND VGND VPWR VPWR sky130_fd_sc_hd__fill_1
XTAP_TAPCELL_ROW_81_1427 VGND VPWR sky130_fd_sc_hd__tapvpwrvgnd_1
X_8603_ _8684_/CLK _8603_/D fanout561/X VGND VGND VPWR VPWR _8603_/Q sky130_fd_sc_hd__dfrtp_2
X_5815_ _5815_/A VGND VGND VPWR VPWR _7945_/D sky130_fd_sc_hd__buf_1
X_6795_ _8441_/Q _4870_/A _6807_/S VGND VGND VPWR VPWR _6796_/A sky130_fd_sc_hd__mux2_2
XFILLER_22_378 VGND VGND VPWR VPWR sky130_fd_sc_hd__fill_1
X_8534_ _8693_/CLK _8534_/D fanout743/X VGND VGND VPWR VPWR _8534_/Q sky130_fd_sc_hd__dfrtp_2
X_5746_ _5746_/A VGND VGND VPWR VPWR _7912_/D sky130_fd_sc_hd__buf_1
XFILLER_108_417 VGND VGND VPWR VPWR sky130_fd_sc_hd__decap_3
X_8465_ _8709_/CLK _8465_/D load_slew671/X VGND VGND VPWR VPWR _8465_/Q sky130_fd_sc_hd__dfrtp_2
X_5677_ _7881_/Q _4941_/A _5677_/S VGND VGND VPWR VPWR _5678_/A sky130_fd_sc_hd__mux2_2
XFILLER_135_225 VGND VGND VPWR VPWR sky130_fd_sc_hd__decap_3
XTAP_TAPCELL_ROW_20_568 VGND VPWR sky130_fd_sc_hd__tapvpwrvgnd_1
XTAP_TAPCELL_ROW_20_579 VGND VPWR sky130_fd_sc_hd__tapvpwrvgnd_1
X_7416_ _8765_/Q _4870_/A _7428_/S VGND VGND VPWR VPWR _7417_/A sky130_fd_sc_hd__mux2_2
X_4628_ _4685_/A1 _4623_/X _4625_/X _4627_/X VGND VGND VPWR VPWR _4628_/X sky130_fd_sc_hd__a22o_2
X_8396_ _8477_/CLK _8396_/D fanout607/A VGND VGND VPWR VPWR _8396_/Q sky130_fd_sc_hd__dfrtp_2
XFILLER_2_728 VGND VGND VPWR VPWR sky130_fd_sc_hd__decap_3
Xmax_cap271 _3763_/A VGND VGND VPWR VPWR _3889_/A sky130_fd_sc_hd__buf_2
Xmax_cap260 _3865_/S VGND VGND VPWR VPWR _4112_/S sky130_fd_sc_hd__buf_8
X_7347_ _8732_/Q _4730_/A _7365_/S VGND VGND VPWR VPWR _7348_/A sky130_fd_sc_hd__mux2_2
X_4559_ _7790_/Q _7871_/Q _4559_/S VGND VGND VPWR VPWR _4559_/X sky130_fd_sc_hd__mux2_2
XFILLER_103_111 VGND VGND VPWR VPWR sky130_fd_sc_hd__fill_1
XFILLER_131_442 VGND VGND VPWR VPWR sky130_fd_sc_hd__decap_3
XFILLER_1_249 VGND VGND VPWR VPWR sky130_fd_sc_hd__fill_2
XFILLER_89_356 VGND VGND VPWR VPWR sky130_fd_sc_hd__decap_3
XTAP_TAPCELL_ROW_92_1578 VGND VPWR sky130_fd_sc_hd__tapvpwrvgnd_1
X_7278_ _7267_/X _4929_/X _7280_/A3 _7280_/B1 hold867/X VGND VGND VPWR VPWR _8698_/D
+ sky130_fd_sc_hd__a32o_2
XFILLER_106_32 VGND VGND VPWR VPWR sky130_fd_sc_hd__decap_3
XFILLER_106_54 VGND VGND VPWR VPWR sky130_fd_sc_hd__decap_3
XFILLER_131_464 VGND VGND VPWR VPWR sky130_fd_sc_hd__decap_3
X_6229_ _4773_/X _8175_/Q _6247_/S VGND VGND VPWR VPWR _6230_/A sky130_fd_sc_hd__mux2_4
XFILLER_131_497 VGND VGND VPWR VPWR sky130_fd_sc_hd__decap_3
XFILLER_122_20 VGND VGND VPWR VPWR sky130_fd_sc_hd__decap_3
XFILLER_45_426 VGND VGND VPWR VPWR sky130_fd_sc_hd__decap_3
XFILLER_58_787 VGND VGND VPWR VPWR sky130_fd_sc_hd__fill_1
XFILLER_73_724 VGND VGND VPWR VPWR sky130_fd_sc_hd__decap_3
XFILLER_85_573 VGND VGND VPWR VPWR sky130_fd_sc_hd__decap_3
XFILLER_85_595 VGND VGND VPWR VPWR sky130_fd_sc_hd__fill_2
XTAP_TAPCELL_ROW_123_2011 VGND VPWR sky130_fd_sc_hd__tapvpwrvgnd_1
XFILLER_72_234 VGND VGND VPWR VPWR sky130_fd_sc_hd__fill_2
XFILLER_72_256 VGND VGND VPWR VPWR sky130_fd_sc_hd__decap_3
XFILLER_72_278 VGND VGND VPWR VPWR sky130_fd_sc_hd__decap_3
XFILLER_82_24 VGND VGND VPWR VPWR sky130_fd_sc_hd__decap_3
XTAP_TAPCELL_ROW_28_679 VGND VPWR sky130_fd_sc_hd__tapvpwrvgnd_1
XFILLER_13_323 VGND VGND VPWR VPWR sky130_fd_sc_hd__decap_3
XTAP_TAPCELL_ROW_0_282 VGND VPWR sky130_fd_sc_hd__tapvpwrvgnd_1
XTAP_TAPCELL_ROW_0_293 VGND VPWR sky130_fd_sc_hd__tapvpwrvgnd_1
XFILLER_15_51 VGND VGND VPWR VPWR sky130_fd_sc_hd__decap_3
XFILLER_15_84 VGND VGND VPWR VPWR sky130_fd_sc_hd__decap_3
XFILLER_41_676 VGND VGND VPWR VPWR sky130_fd_sc_hd__decap_3
XFILLER_127_715 VGND VGND VPWR VPWR sky130_fd_sc_hd__decap_3
XFILLER_40_197 VGND VGND VPWR VPWR sky130_fd_sc_hd__decap_3
XFILLER_127_759 VGND VGND VPWR VPWR sky130_fd_sc_hd__decap_3
XFILLER_126_247 VGND VGND VPWR VPWR sky130_fd_sc_hd__decap_3
XTAP_TAPCELL_ROW_134_2162 VGND VPWR sky130_fd_sc_hd__tapvpwrvgnd_1
XTAP_TAPCELL_ROW_134_2173 VGND VPWR sky130_fd_sc_hd__tapvpwrvgnd_1
XFILLER_107_461 VGND VGND VPWR VPWR sky130_fd_sc_hd__decap_3
XFILLER_135_781 VGND VGND VPWR VPWR sky130_fd_sc_hd__decap_3
XFILLER_5_599 VGND VGND VPWR VPWR sky130_fd_sc_hd__decap_3
XFILLER_134_280 VGND VGND VPWR VPWR sky130_fd_sc_hd__fill_1
XFILLER_1_750 VGND VGND VPWR VPWR sky130_fd_sc_hd__decap_3
XTAP_TAPCELL_ROW_52_1017 VGND VPWR sky130_fd_sc_hd__tapvpwrvgnd_1
Xoutput94 _3979_/X VGND VGND VPWR VPWR rdata[16] sky130_fd_sc_hd__clkdlybuf4s25_1
XFILLER_110_648 VGND VGND VPWR VPWR sky130_fd_sc_hd__decap_3
XFILLER_1_783 VGND VGND VPWR VPWR sky130_fd_sc_hd__fill_1
XFILLER_1_794 VGND VGND VPWR VPWR sky130_fd_sc_hd__decap_3
XFILLER_49_732 VGND VGND VPWR VPWR sky130_fd_sc_hd__decap_3
XFILLER_95_337 VGND VGND VPWR VPWR sky130_fd_sc_hd__decap_3
XFILLER_76_551 VGND VGND VPWR VPWR sky130_fd_sc_hd__decap_3
XTAP_TAPCELL_ROW_108_1806 VGND VPWR sky130_fd_sc_hd__tapvpwrvgnd_1
XFILLER_48_264 VGND VGND VPWR VPWR sky130_fd_sc_hd__decap_3
XFILLER_63_212 VGND VGND VPWR VPWR sky130_fd_sc_hd__decap_3
XFILLER_64_735 VGND VGND VPWR VPWR sky130_fd_sc_hd__decap_3
XFILLER_76_584 VGND VGND VPWR VPWR sky130_fd_sc_hd__decap_3
XFILLER_76_595 VGND VGND VPWR VPWR sky130_fd_sc_hd__decap_3
XFILLER_64_757 VGND VGND VPWR VPWR sky130_fd_sc_hd__decap_3
XTAP_TAPCELL_ROW_47_944 VGND VPWR sky130_fd_sc_hd__tapvpwrvgnd_1
XTAP_TAPCELL_ROW_47_955 VGND VPWR sky130_fd_sc_hd__tapvpwrvgnd_1
XFILLER_17_651 VGND VGND VPWR VPWR sky130_fd_sc_hd__decap_3
XFILLER_17_673 VGND VGND VPWR VPWR sky130_fd_sc_hd__decap_3
XFILLER_63_278 VGND VGND VPWR VPWR sky130_fd_sc_hd__fill_2
X_3930_ _7976_/Q _3816_/X _4551_/B1 _7895_/Q _3900_/S VGND VGND VPWR VPWR _3930_/X
+ sky130_fd_sc_hd__o221a_2
XFILLER_17_695 VGND VGND VPWR VPWR sky130_fd_sc_hd__decap_3
XFILLER_32_610 VGND VGND VPWR VPWR sky130_fd_sc_hd__decap_3
XFILLER_32_643 VGND VGND VPWR VPWR sky130_fd_sc_hd__fill_1
XFILLER_32_654 VGND VGND VPWR VPWR sky130_fd_sc_hd__fill_1
XTAP_TAPCELL_ROW_63_1168 VGND VPWR sky130_fd_sc_hd__tapvpwrvgnd_1
X_3861_ _8061_/Q _8142_/Q _3861_/S VGND VGND VPWR VPWR _3862_/B sky130_fd_sc_hd__mux2_2
XFILLER_32_687 VGND VGND VPWR VPWR sky130_fd_sc_hd__decap_3
XTAP_TAPCELL_ROW_63_1179 VGND VPWR sky130_fd_sc_hd__tapvpwrvgnd_1
X_3792_ _8380_/Q _8461_/Q _8542_/Q _8623_/Q _3824_/S _3825_/A VGND VGND VPWR VPWR
+ _3793_/B sky130_fd_sc_hd__mux4_2
X_6580_ _6580_/A VGND VGND VPWR VPWR _8340_/D sky130_fd_sc_hd__buf_2
X_5600_ _7844_/Q _4787_/A _5612_/S VGND VGND VPWR VPWR _5601_/A sky130_fd_sc_hd__mux2_2
XFILLER_118_704 VGND VGND VPWR VPWR sky130_fd_sc_hd__fill_2
XFILLER_118_715 VGND VGND VPWR VPWR sky130_fd_sc_hd__decap_3
X_5531_ _7811_/Q _4989_/A _5549_/S VGND VGND VPWR VPWR _5532_/A sky130_fd_sc_hd__mux2_2
XFILLER_117_225 VGND VGND VPWR VPWR sky130_fd_sc_hd__decap_3
XFILLER_8_360 VGND VGND VPWR VPWR sky130_fd_sc_hd__decap_3
XFILLER_8_371 VGND VGND VPWR VPWR sky130_fd_sc_hd__decap_3
XFILLER_8_382 VGND VGND VPWR VPWR sky130_fd_sc_hd__decap_3
XTAP_TAPCELL_ROW_119_1957 VGND VPWR sky130_fd_sc_hd__tapvpwrvgnd_1
X_8250_ _8493_/CLK _8250_/D fanout477/X VGND VGND VPWR VPWR _8250_/Q sky130_fd_sc_hd__dfrtp_2
XFILLER_133_718 VGND VGND VPWR VPWR sky130_fd_sc_hd__decap_3
X_7201_ _7189_/X _5023_/X _7201_/A3 wire207/X hold899/X VGND VGND VPWR VPWR _8639_/D
+ sky130_fd_sc_hd__a32o_2
X_5462_ _5462_/A VGND VGND VPWR VPWR _7779_/D sky130_fd_sc_hd__buf_1
XFILLER_126_781 VGND VGND VPWR VPWR sky130_fd_sc_hd__decap_3
XFILLER_132_206 VGND VGND VPWR VPWR sky130_fd_sc_hd__decap_3
XFILLER_133_729 VGND VGND VPWR VPWR sky130_fd_sc_hd__decap_3
X_8181_ _8793_/CLK _8181_/D fanout639/X VGND VGND VPWR VPWR _8181_/Q sky130_fd_sc_hd__dfrtp_2
X_5393_ _5393_/A VGND VGND VPWR VPWR _7746_/D sky130_fd_sc_hd__buf_1
X_4413_ _8596_/Q _4660_/A2 _4412_/X VGND VGND VPWR VPWR _4413_/X sky130_fd_sc_hd__o21a_2
XFILLER_132_239 VGND VGND VPWR VPWR sky130_fd_sc_hd__decap_3
XFILLER_99_632 VGND VGND VPWR VPWR sky130_fd_sc_hd__decap_3
X_7132_ _7174_/S VGND VGND VPWR VPWR _7151_/S sky130_fd_sc_hd__buf_4
X_4344_ _4344_/A _4344_/B VGND VGND VPWR VPWR _4344_/X sky130_fd_sc_hd__or2_2
XFILLER_101_615 VGND VGND VPWR VPWR sky130_fd_sc_hd__fill_1
XFILLER_113_475 VGND VGND VPWR VPWR sky130_fd_sc_hd__decap_3
XFILLER_99_676 VGND VGND VPWR VPWR sky130_fd_sc_hd__decap_3
Xfanout339 _4096_/A VGND VGND VPWR VPWR _4198_/A sky130_fd_sc_hd__clkdlybuf4s25_1
X_7063_ _7063_/A0 hold953/X _7067_/S VGND VGND VPWR VPWR _7064_/A sky130_fd_sc_hd__mux2_1
XFILLER_101_626 VGND VGND VPWR VPWR sky130_fd_sc_hd__decap_3
XFILLER_98_197 VGND VGND VPWR VPWR sky130_fd_sc_hd__decap_3
X_6014_ _8074_/Q _5030_/A _6032_/S VGND VGND VPWR VPWR _6015_/A sky130_fd_sc_hd__mux2_2
X_4275_ _8746_/Q _7521_/Q _7602_/Q _7683_/Q _4272_/S _4096_/A VGND VGND VPWR VPWR
+ _4275_/X sky130_fd_sc_hd__mux4_2
XFILLER_55_735 VGND VGND VPWR VPWR sky130_fd_sc_hd__fill_2
XFILLER_54_223 VGND VGND VPWR VPWR sky130_fd_sc_hd__decap_3
XFILLER_55_768 VGND VGND VPWR VPWR sky130_fd_sc_hd__decap_3
XFILLER_14_109 VGND VGND VPWR VPWR sky130_fd_sc_hd__decap_3
XFILLER_54_256 VGND VGND VPWR VPWR sky130_fd_sc_hd__decap_3
XFILLER_70_716 VGND VGND VPWR VPWR sky130_fd_sc_hd__decap_3
XFILLER_82_587 VGND VGND VPWR VPWR sky130_fd_sc_hd__fill_1
X_7965_ _8621_/CLK _7965_/D load_slew676/X VGND VGND VPWR VPWR _7965_/Q sky130_fd_sc_hd__dfrtp_2
XFILLER_35_481 VGND VGND VPWR VPWR sky130_fd_sc_hd__decap_3
XTAP_TAPCELL_ROW_25_638 VGND VPWR sky130_fd_sc_hd__tapvpwrvgnd_1
XTAP_TAPCELL_ROW_25_649 VGND VPWR sky130_fd_sc_hd__tapvpwrvgnd_1
X_7896_ _8800_/CLK _7896_/D fanout592/X VGND VGND VPWR VPWR _7896_/Q sky130_fd_sc_hd__dfrtp_2
X_6916_ _4769_/X _8498_/Q _6916_/S VGND VGND VPWR VPWR _6917_/A sky130_fd_sc_hd__mux2_4
XFILLER_52_27 VGND VGND VPWR VPWR sky130_fd_sc_hd__fill_1
X_6847_ _4973_/X _8465_/Q _6853_/S VGND VGND VPWR VPWR _6848_/A sky130_fd_sc_hd__mux2_4
XFILLER_10_304 VGND VGND VPWR VPWR sky130_fd_sc_hd__decap_3
XFILLER_10_315 VGND VGND VPWR VPWR sky130_fd_sc_hd__decap_3
Xwire707 wire707/A VGND VGND VPWR VPWR wire707/X sky130_fd_sc_hd__clkbuf_4
X_6778_ _8433_/Q _4836_/A _6786_/S VGND VGND VPWR VPWR _6779_/A sky130_fd_sc_hd__mux2_2
XFILLER_109_715 VGND VGND VPWR VPWR sky130_fd_sc_hd__fill_2
XFILLER_22_186 VGND VGND VPWR VPWR sky130_fd_sc_hd__decap_3
X_8517_ _8760_/CLK _8517_/D fanout697/X VGND VGND VPWR VPWR _8517_/Q sky130_fd_sc_hd__dfrtp_2
X_5729_ _5729_/A VGND VGND VPWR VPWR _7904_/D sky130_fd_sc_hd__buf_1
XFILLER_108_203 VGND VGND VPWR VPWR sky130_fd_sc_hd__fill_1
XFILLER_109_726 VGND VGND VPWR VPWR sky130_fd_sc_hd__fill_2
XFILLER_108_247 VGND VGND VPWR VPWR sky130_fd_sc_hd__fill_1
XTAP_TAPCELL_ROW_94_1607 VGND VPWR sky130_fd_sc_hd__tapvpwrvgnd_1
X_8448_ _8772_/CLK _8448_/D fanout717/X VGND VGND VPWR VPWR _8448_/Q sky130_fd_sc_hd__dfrtp_2
XFILLER_123_206 VGND VGND VPWR VPWR sky130_fd_sc_hd__fill_2
XFILLER_124_729 VGND VGND VPWR VPWR sky130_fd_sc_hd__decap_3
X_8379_ _8545_/CLK _8379_/D wire657/X VGND VGND VPWR VPWR _8379_/Q sky130_fd_sc_hd__dfrtp_2
XFILLER_132_740 VGND VGND VPWR VPWR sky130_fd_sc_hd__decap_3
XFILLER_104_453 VGND VGND VPWR VPWR sky130_fd_sc_hd__decap_3
XFILLER_2_569 VGND VGND VPWR VPWR sky130_fd_sc_hd__fill_1
XFILLER_89_164 VGND VGND VPWR VPWR sky130_fd_sc_hd__decap_3
XFILLER_131_261 VGND VGND VPWR VPWR sky130_fd_sc_hd__decap_3
XFILLER_132_784 VGND VGND VPWR VPWR sky130_fd_sc_hd__decap_3
XFILLER_77_337 VGND VGND VPWR VPWR sky130_fd_sc_hd__decap_3
XFILLER_77_57 VGND VGND VPWR VPWR sky130_fd_sc_hd__decap_3
XFILLER_133_30 VGND VGND VPWR VPWR sky130_fd_sc_hd__decap_3
XTAP_TAPCELL_ROW_5_363 VGND VPWR sky130_fd_sc_hd__tapvpwrvgnd_1
XFILLER_133_63 VGND VGND VPWR VPWR sky130_fd_sc_hd__decap_3
XFILLER_58_573 VGND VGND VPWR VPWR sky130_fd_sc_hd__decap_3
XFILLER_92_329 VGND VGND VPWR VPWR sky130_fd_sc_hd__decap_3
Xhold1060 _8094_/Q VGND VGND VPWR VPWR _6056_/A0 sky130_fd_sc_hd__dlygate4sd3_1
XFILLER_133_96 VGND VGND VPWR VPWR sky130_fd_sc_hd__decap_3
XFILLER_45_212 VGND VGND VPWR VPWR sky130_fd_sc_hd__decap_3
XFILLER_73_532 VGND VGND VPWR VPWR sky130_fd_sc_hd__decap_3
XFILLER_26_50 VGND VGND VPWR VPWR sky130_fd_sc_hd__decap_3
XFILLER_33_418 VGND VGND VPWR VPWR sky130_fd_sc_hd__decap_3
XFILLER_45_256 VGND VGND VPWR VPWR sky130_fd_sc_hd__decap_3
XTAP_TAPCELL_ROW_44_903 VGND VPWR sky130_fd_sc_hd__tapvpwrvgnd_1
XTAP_TAPCELL_ROW_44_914 VGND VPWR sky130_fd_sc_hd__tapvpwrvgnd_1
XFILLER_26_83 VGND VGND VPWR VPWR sky130_fd_sc_hd__fill_1
XFILLER_45_289 VGND VGND VPWR VPWR sky130_fd_sc_hd__fill_1
XTAP_TAPCELL_ROW_103_1736 VGND VPWR sky130_fd_sc_hd__tapvpwrvgnd_1
XFILLER_13_142 VGND VGND VPWR VPWR sky130_fd_sc_hd__fill_1
XFILLER_41_440 VGND VGND VPWR VPWR sky130_fd_sc_hd__decap_3
XFILLER_13_164 VGND VGND VPWR VPWR sky130_fd_sc_hd__decap_3
XFILLER_9_113 VGND VGND VPWR VPWR sky130_fd_sc_hd__fill_1
XFILLER_9_135 VGND VGND VPWR VPWR sky130_fd_sc_hd__decap_3
XFILLER_127_523 VGND VGND VPWR VPWR sky130_fd_sc_hd__decap_3
XFILLER_42_82 VGND VGND VPWR VPWR sky130_fd_sc_hd__fill_2
XFILLER_127_556 VGND VGND VPWR VPWR sky130_fd_sc_hd__decap_3
XFILLER_127_567 VGND VGND VPWR VPWR sky130_fd_sc_hd__decap_3
XFILLER_114_217 VGND VGND VPWR VPWR sky130_fd_sc_hd__decap_3
XFILLER_115_729 VGND VGND VPWR VPWR sky130_fd_sc_hd__decap_3
XFILLER_47_6 VGND VGND VPWR VPWR sky130_fd_sc_hd__fill_1
XFILLER_123_762 VGND VGND VPWR VPWR sky130_fd_sc_hd__decap_3
XFILLER_3_21 VGND VGND VPWR VPWR sky130_fd_sc_hd__decap_3
XFILLER_96_613 VGND VGND VPWR VPWR sky130_fd_sc_hd__decap_3
XTAP_TAPCELL_ROW_114_1887 VGND VPWR sky130_fd_sc_hd__tapvpwrvgnd_1
XFILLER_3_54 VGND VGND VPWR VPWR sky130_fd_sc_hd__fill_2
XFILLER_95_101 VGND VGND VPWR VPWR sky130_fd_sc_hd__decap_3
XFILLER_96_635 VGND VGND VPWR VPWR sky130_fd_sc_hd__decap_3
XFILLER_3_87 VGND VGND VPWR VPWR sky130_fd_sc_hd__decap_3
X_4060_ _4030_/S _4053_/X _4055_/X _4059_/X VGND VGND VPWR VPWR _4060_/X sky130_fd_sc_hd__a31o_2
XFILLER_95_178 VGND VGND VPWR VPWR sky130_fd_sc_hd__decap_3
XFILLER_49_595 VGND VGND VPWR VPWR sky130_fd_sc_hd__decap_3
XFILLER_24_407 VGND VGND VPWR VPWR sky130_fd_sc_hd__decap_3
XFILLER_64_576 VGND VGND VPWR VPWR sky130_fd_sc_hd__decap_3
XTAP_TAPCELL_ROW_65_1208 VGND VPWR sky130_fd_sc_hd__tapvpwrvgnd_1
X_7750_ _8495_/CLK _7750_/D load_slew513/X VGND VGND VPWR VPWR _7750_/Q sky130_fd_sc_hd__dfrtp_2
X_4962_ _4961_/X _7561_/Q _4986_/S VGND VGND VPWR VPWR _4963_/A sky130_fd_sc_hd__mux2_2
X_3913_ _3732_/A _3912_/X _4460_/A VGND VGND VPWR VPWR _3913_/X sky130_fd_sc_hd__a21o_2
X_7681_ _8744_/CLK _7681_/D fanout627/X VGND VGND VPWR VPWR _7681_/Q sky130_fd_sc_hd__dfrtp_2
X_6701_ _6701_/A VGND VGND VPWR VPWR _8396_/D sky130_fd_sc_hd__buf_2
X_4893_ _4893_/A VGND VGND VPWR VPWR _7545_/D sky130_fd_sc_hd__buf_1
XFILLER_32_473 VGND VGND VPWR VPWR sky130_fd_sc_hd__decap_3
X_3844_ _7888_/Q _4660_/A2 _3843_/X VGND VGND VPWR VPWR _3844_/X sky130_fd_sc_hd__o21a_2
X_6632_ _6632_/A VGND VGND VPWR VPWR _8365_/D sky130_fd_sc_hd__buf_2
XFILLER_32_495 VGND VGND VPWR VPWR sky130_fd_sc_hd__decap_3
XFILLER_118_501 VGND VGND VPWR VPWR sky130_fd_sc_hd__decap_3
XFILLER_118_523 VGND VGND VPWR VPWR sky130_fd_sc_hd__decap_3
XFILLER_20_668 VGND VGND VPWR VPWR sky130_fd_sc_hd__decap_3
X_3775_ _3880_/A VGND VGND VPWR VPWR _3775_/X sky130_fd_sc_hd__clkbuf_2
X_6563_ _6563_/A VGND VGND VPWR VPWR _8332_/D sky130_fd_sc_hd__buf_2
XFILLER_106_707 VGND VGND VPWR VPWR sky130_fd_sc_hd__decap_3
XFILLER_9_691 VGND VGND VPWR VPWR sky130_fd_sc_hd__decap_3
X_8302_ _8710_/CLK _8302_/D fanout665/X VGND VGND VPWR VPWR _8302_/Q sky130_fd_sc_hd__dfrtp_2
X_6494_ _6494_/A VGND VGND VPWR VPWR _8299_/D sky130_fd_sc_hd__buf_2
X_5514_ _7803_/Q _4957_/A _5528_/S VGND VGND VPWR VPWR _5515_/A sky130_fd_sc_hd__mux2_2
XFILLER_118_589 VGND VGND VPWR VPWR sky130_fd_sc_hd__fill_2
XFILLER_133_526 VGND VGND VPWR VPWR sky130_fd_sc_hd__decap_3
X_8233_ _8794_/CLK _8233_/D load_slew584/X VGND VGND VPWR VPWR _8233_/Q sky130_fd_sc_hd__dfrtp_2
X_5445_ _7771_/Q _4818_/A _5461_/S VGND VGND VPWR VPWR _5446_/A sky130_fd_sc_hd__mux2_2
XFILLER_133_559 VGND VGND VPWR VPWR sky130_fd_sc_hd__fill_1
XTAP_TAPCELL_ROW_76_1359 VGND VPWR sky130_fd_sc_hd__tapvpwrvgnd_1
X_8164_ _8569_/CLK _8164_/D load_slew494/X VGND VGND VPWR VPWR _8164_/Q sky130_fd_sc_hd__dfrtp_2
XFILLER_114_751 VGND VGND VPWR VPWR sky130_fd_sc_hd__decap_3
X_7115_ _7115_/A VGND VGND VPWR VPWR _8591_/D sky130_fd_sc_hd__buf_2
X_5376_ _5376_/A VGND VGND VPWR VPWR _7738_/D sky130_fd_sc_hd__buf_1
XFILLER_101_412 VGND VGND VPWR VPWR sky130_fd_sc_hd__decap_3
XFILLER_99_473 VGND VGND VPWR VPWR sky130_fd_sc_hd__decap_3
X_8095_ _8742_/CLK _8095_/D load_slew521/X VGND VGND VPWR VPWR _8095_/Q sky130_fd_sc_hd__dfrtp_2
X_4327_ _8427_/Q _8508_/Q _4327_/S VGND VGND VPWR VPWR _4327_/X sky130_fd_sc_hd__mux2_2
XFILLER_86_134 VGND VGND VPWR VPWR sky130_fd_sc_hd__decap_3
XFILLER_86_156 VGND VGND VPWR VPWR sky130_fd_sc_hd__decap_3
XFILLER_87_657 VGND VGND VPWR VPWR sky130_fd_sc_hd__decap_3
XFILLER_87_679 VGND VGND VPWR VPWR sky130_fd_sc_hd__decap_3
X_7046_ _5027_/X _8559_/Q _7046_/S VGND VGND VPWR VPWR _7047_/A sky130_fd_sc_hd__mux2_2
X_4258_ _8097_/Q _8178_/Q _8259_/Q _8340_/Q _4260_/S _4261_/A VGND VGND VPWR VPWR
+ _4258_/X sky130_fd_sc_hd__mux4_2
XFILLER_101_478 VGND VGND VPWR VPWR sky130_fd_sc_hd__decap_3
XFILLER_27_201 VGND VGND VPWR VPWR sky130_fd_sc_hd__fill_2
XFILLER_47_49 VGND VGND VPWR VPWR sky130_fd_sc_hd__decap_3
XTAP_TAPCELL_ROW_2_322 VGND VPWR sky130_fd_sc_hd__tapvpwrvgnd_1
XFILLER_103_22 VGND VGND VPWR VPWR sky130_fd_sc_hd__decap_3
XFILLER_27_212 VGND VGND VPWR VPWR sky130_fd_sc_hd__decap_3
XFILLER_95_690 VGND VGND VPWR VPWR sky130_fd_sc_hd__decap_3
X_4189_ _4231_/A _4189_/B VGND VGND VPWR VPWR _4189_/X sky130_fd_sc_hd__or2_2
XFILLER_103_55 VGND VGND VPWR VPWR sky130_fd_sc_hd__fill_1
XFILLER_103_66 VGND VGND VPWR VPWR sky130_fd_sc_hd__decap_3
XFILLER_15_418 VGND VGND VPWR VPWR sky130_fd_sc_hd__decap_3
XFILLER_55_576 VGND VGND VPWR VPWR sky130_fd_sc_hd__decap_3
XFILLER_63_37 VGND VGND VPWR VPWR sky130_fd_sc_hd__decap_3
X_7948_ _8768_/CLK _7948_/D load_slew565/X VGND VGND VPWR VPWR _7948_/Q sky130_fd_sc_hd__dfrtp_2
XFILLER_42_248 VGND VGND VPWR VPWR sky130_fd_sc_hd__decap_3
XFILLER_70_579 VGND VGND VPWR VPWR sky130_fd_sc_hd__fill_2
XFILLER_11_613 VGND VGND VPWR VPWR sky130_fd_sc_hd__decap_3
X_7879_ _8780_/CLK _7879_/D fanout723/X VGND VGND VPWR VPWR _7879_/Q sky130_fd_sc_hd__dfrtp_2
XFILLER_11_635 VGND VGND VPWR VPWR sky130_fd_sc_hd__decap_3
XFILLER_11_679 VGND VGND VPWR VPWR sky130_fd_sc_hd__decap_3
XFILLER_7_617 VGND VGND VPWR VPWR sky130_fd_sc_hd__decap_3
XFILLER_109_567 VGND VGND VPWR VPWR sky130_fd_sc_hd__decap_3
XFILLER_12_41 VGND VGND VPWR VPWR sky130_fd_sc_hd__decap_3
XFILLER_6_138 VGND VGND VPWR VPWR sky130_fd_sc_hd__fill_2
XFILLER_109_589 VGND VGND VPWR VPWR sky130_fd_sc_hd__decap_3
XFILLER_128_41 VGND VGND VPWR VPWR sky130_fd_sc_hd__decap_3
XFILLER_12_74 VGND VGND VPWR VPWR sky130_fd_sc_hd__decap_3
XFILLER_12_85 VGND VGND VPWR VPWR sky130_fd_sc_hd__fill_2
XTAP_TAPCELL_ROW_131_2121 VGND VPWR sky130_fd_sc_hd__tapvpwrvgnd_1
XTAP_TAPCELL_ROW_131_2132 VGND VPWR sky130_fd_sc_hd__tapvpwrvgnd_1
XFILLER_128_74 VGND VGND VPWR VPWR sky130_fd_sc_hd__decap_3
XFILLER_128_85 VGND VGND VPWR VPWR sky130_fd_sc_hd__decap_3
Xload_slew509 fanout508/X VGND VGND VPWR VPWR load_slew509/X sky130_fd_sc_hd__clkbuf_2
XFILLER_120_710 VGND VGND VPWR VPWR sky130_fd_sc_hd__fill_1
XFILLER_120_732 VGND VGND VPWR VPWR sky130_fd_sc_hd__decap_3
XFILLER_132_581 VGND VGND VPWR VPWR sky130_fd_sc_hd__decap_3
XFILLER_132_592 VGND VGND VPWR VPWR sky130_fd_sc_hd__decap_3
XFILLER_77_178 VGND VGND VPWR VPWR sky130_fd_sc_hd__decap_3
Xfanout670 fanout674/X VGND VGND VPWR VPWR fanout670/X sky130_fd_sc_hd__clkdlybuf4s25_1
Xfanout681 fanout683/X VGND VGND VPWR VPWR fanout681/X sky130_fd_sc_hd__clkdlybuf4s25_1
Xfanout692 fanout694/X VGND VGND VPWR VPWR wire693/A sky130_fd_sc_hd__clkdlybuf4s25_1
XFILLER_37_60 VGND VGND VPWR VPWR sky130_fd_sc_hd__decap_3
XTAP_TAPCELL_ROW_129_2094 VGND VPWR sky130_fd_sc_hd__tapvpwrvgnd_1
XFILLER_37_82 VGND VGND VPWR VPWR sky130_fd_sc_hd__decap_3
XFILLER_73_340 VGND VGND VPWR VPWR sky130_fd_sc_hd__decap_3
XFILLER_92_159 VGND VGND VPWR VPWR sky130_fd_sc_hd__fill_2
XPHY_EDGE_ROW_16_Right_16 VGND VGND VPWR VPWR sky130_fd_sc_hd__decap_3
XFILLER_18_278 VGND VGND VPWR VPWR sky130_fd_sc_hd__decap_3
XFILLER_34_727 VGND VGND VPWR VPWR sky130_fd_sc_hd__decap_3
XFILLER_34_749 VGND VGND VPWR VPWR sky130_fd_sc_hd__decap_3
XFILLER_61_557 VGND VGND VPWR VPWR sky130_fd_sc_hd__decap_3
XFILLER_53_70 VGND VGND VPWR VPWR sky130_fd_sc_hd__decap_3
XFILLER_14_495 VGND VGND VPWR VPWR sky130_fd_sc_hd__fill_1
XFILLER_42_793 VGND VGND VPWR VPWR sky130_fd_sc_hd__decap_3
XTAP_TAPCELL_ROW_60_1127 VGND VPWR sky130_fd_sc_hd__tapvpwrvgnd_1
XTAP_TAPCELL_ROW_60_1138 VGND VPWR sky130_fd_sc_hd__tapvpwrvgnd_1
XFILLER_10_690 VGND VGND VPWR VPWR sky130_fd_sc_hd__decap_3
XPHY_EDGE_ROW_25_Right_25 VGND VGND VPWR VPWR sky130_fd_sc_hd__decap_3
XTAP_TAPCELL_ROW_116_1916 VGND VPWR sky130_fd_sc_hd__tapvpwrvgnd_1
Xclkbuf_5_1__f_CLK clkbuf_4_0_0_CLK/X VGND VGND VPWR VPWR clkbuf_leaf_1_CLK/A sky130_fd_sc_hd__clkbuf_16
XFILLER_6_672 VGND VGND VPWR VPWR sky130_fd_sc_hd__decap_3
X_5230_ _5230_/A VGND VGND VPWR VPWR _7669_/D sky130_fd_sc_hd__buf_1
XFILLER_130_507 VGND VGND VPWR VPWR sky130_fd_sc_hd__decap_3
XFILLER_69_613 VGND VGND VPWR VPWR sky130_fd_sc_hd__decap_3
XFILLER_96_421 VGND VGND VPWR VPWR sky130_fd_sc_hd__decap_3
X_5161_ _5161_/A VGND VGND VPWR VPWR _7638_/D sky130_fd_sc_hd__buf_1
XFILLER_96_454 VGND VGND VPWR VPWR sky130_fd_sc_hd__decap_3
X_5092_ _5092_/A VGND VGND VPWR VPWR _7605_/D sky130_fd_sc_hd__buf_1
X_4112_ _4108_/X _4111_/X _4112_/S VGND VGND VPWR VPWR _4113_/A sky130_fd_sc_hd__mux2_2
XFILLER_56_307 VGND VGND VPWR VPWR sky130_fd_sc_hd__fill_1
XFILLER_56_318 VGND VGND VPWR VPWR sky130_fd_sc_hd__decap_3
XFILLER_68_156 VGND VGND VPWR VPWR sky130_fd_sc_hd__fill_1
XTAP_TAPCELL_ROW_71_1289 VGND VPWR sky130_fd_sc_hd__tapvpwrvgnd_1
X_4043_ _4462_/A _4038_/X _4040_/X _4042_/X VGND VGND VPWR VPWR _4043_/X sky130_fd_sc_hd__a22o_2
XFILLER_77_690 VGND VGND VPWR VPWR sky130_fd_sc_hd__fill_2
XPHY_EDGE_ROW_34_Right_34 VGND VGND VPWR VPWR sky130_fd_sc_hd__decap_3
XFILLER_24_215 VGND VGND VPWR VPWR sky130_fd_sc_hd__decap_3
XFILLER_25_738 VGND VGND VPWR VPWR sky130_fd_sc_hd__decap_3
XFILLER_37_587 VGND VGND VPWR VPWR sky130_fd_sc_hd__decap_3
XFILLER_91_181 VGND VGND VPWR VPWR sky130_fd_sc_hd__decap_3
XFILLER_92_693 VGND VGND VPWR VPWR sky130_fd_sc_hd__decap_3
X_8782_ _8782_/CLK _8782_/D fanout648/A VGND VGND VPWR VPWR _8782_/Q sky130_fd_sc_hd__dfrtp_2
X_7802_ _8792_/CLK _7802_/D wire657/X VGND VGND VPWR VPWR _7802_/Q sky130_fd_sc_hd__dfrtp_2
X_5994_ _5994_/A VGND VGND VPWR VPWR _8064_/D sky130_fd_sc_hd__buf_1
XFILLER_24_237 VGND VGND VPWR VPWR sky130_fd_sc_hd__fill_1
XFILLER_52_557 VGND VGND VPWR VPWR sky130_fd_sc_hd__decap_3
X_7733_ _8759_/CLK _7733_/D wire707/X VGND VGND VPWR VPWR _7733_/Q sky130_fd_sc_hd__dfrtp_2
X_4945_ _4945_/A VGND VGND VPWR VPWR _4945_/X sky130_fd_sc_hd__buf_1
XTAP_TAPCELL_ROW_35_777 VGND VPWR sky130_fd_sc_hd__tapvpwrvgnd_1
XTAP_TAPCELL_ROW_35_788 VGND VPWR sky130_fd_sc_hd__tapvpwrvgnd_1
XFILLER_20_410 VGND VGND VPWR VPWR sky130_fd_sc_hd__decap_3
XFILLER_20_421 VGND VGND VPWR VPWR sky130_fd_sc_hd__decap_3
X_7664_ _8645_/CLK _7664_/D load_slew501/X VGND VGND VPWR VPWR _7664_/Q sky130_fd_sc_hd__dfrtp_2
X_4876_ _4875_/X _7541_/Q _4896_/S VGND VGND VPWR VPWR _4877_/A sky130_fd_sc_hd__mux2_2
XFILLER_20_454 VGND VGND VPWR VPWR sky130_fd_sc_hd__fill_1
XPHY_EDGE_ROW_43_Right_43 VGND VGND VPWR VPWR sky130_fd_sc_hd__decap_3
X_3827_ _3827_/A1 _3823_/X _3825_/X _3826_/X VGND VGND VPWR VPWR _3827_/X sky130_fd_sc_hd__a22o_2
X_7595_ _8736_/CLK _7595_/D fanout479/A VGND VGND VPWR VPWR _7595_/Q sky130_fd_sc_hd__dfrtp_2
X_6615_ _4857_/X _8357_/Q _6633_/S VGND VGND VPWR VPWR _6616_/A sky130_fd_sc_hd__mux2_2
X_3758_ _3758_/A VGND VGND VPWR VPWR _3955_/A sky130_fd_sc_hd__clkbuf_2
X_6546_ _6546_/A VGND VGND VPWR VPWR _8324_/D sky130_fd_sc_hd__buf_2
XFILLER_106_515 VGND VGND VPWR VPWR sky130_fd_sc_hd__fill_1
XFILLER_116_9 VGND VGND VPWR VPWR sky130_fd_sc_hd__decap_3
XFILLER_134_802 VGND VGND VPWR VPWR sky130_fd_sc_hd__fill_2
XFILLER_3_108 VGND VGND VPWR VPWR sky130_fd_sc_hd__decap_3
XFILLER_106_548 VGND VGND VPWR VPWR sky130_fd_sc_hd__decap_3
XFILLER_133_323 VGND VGND VPWR VPWR sky130_fd_sc_hd__decap_3
X_6477_ _6477_/A VGND VGND VPWR VPWR _8292_/D sky130_fd_sc_hd__buf_2
XFILLER_133_367 VGND VGND VPWR VPWR sky130_fd_sc_hd__decap_3
X_8216_ _8709_/CLK _8216_/D load_slew671/X VGND VGND VPWR VPWR _8216_/Q sky130_fd_sc_hd__dfrtp_2
X_5428_ _7763_/Q _4786_/A _5440_/S VGND VGND VPWR VPWR _5429_/A sky130_fd_sc_hd__mux2_2
XFILLER_99_281 VGND VGND VPWR VPWR sky130_fd_sc_hd__fill_2
X_8147_ _8801_/CLK _8147_/D load_slew608/X VGND VGND VPWR VPWR _8147_/Q sky130_fd_sc_hd__dfrtp_2
X_5359_ _7730_/Q input4/X _5377_/S VGND VGND VPWR VPWR _5360_/A sky130_fd_sc_hd__mux2_2
XFILLER_114_592 VGND VGND VPWR VPWR sky130_fd_sc_hd__decap_3
XFILLER_87_432 VGND VGND VPWR VPWR sky130_fd_sc_hd__decap_3
X_8078_ _8645_/CLK _8078_/D load_slew501/X VGND VGND VPWR VPWR _8078_/Q sky130_fd_sc_hd__dfrtp_2
XFILLER_101_242 VGND VGND VPWR VPWR sky130_fd_sc_hd__fill_1
XFILLER_114_21 VGND VGND VPWR VPWR sky130_fd_sc_hd__fill_1
XFILLER_47_307 VGND VGND VPWR VPWR sky130_fd_sc_hd__fill_2
XFILLER_59_156 VGND VGND VPWR VPWR sky130_fd_sc_hd__decap_3
XPHY_EDGE_ROW_52_Right_52 VGND VGND VPWR VPWR sky130_fd_sc_hd__decap_3
XTAP_TAPCELL_ROW_89_1539 VGND VPWR sky130_fd_sc_hd__tapvpwrvgnd_1
X_7029_ _7029_/A VGND VGND VPWR VPWR _8550_/D sky130_fd_sc_hd__buf_2
XFILLER_75_649 VGND VGND VPWR VPWR sky130_fd_sc_hd__decap_3
XFILLER_28_565 VGND VGND VPWR VPWR sky130_fd_sc_hd__decap_3
XFILLER_55_340 VGND VGND VPWR VPWR sky130_fd_sc_hd__decap_3
XFILLER_28_598 VGND VGND VPWR VPWR sky130_fd_sc_hd__decap_3
XFILLER_43_535 VGND VGND VPWR VPWR sky130_fd_sc_hd__fill_2
XFILLER_55_384 VGND VGND VPWR VPWR sky130_fd_sc_hd__decap_3
XFILLER_130_53 VGND VGND VPWR VPWR sky130_fd_sc_hd__decap_3
XFILLER_43_546 VGND VGND VPWR VPWR sky130_fd_sc_hd__decap_3
XFILLER_70_354 VGND VGND VPWR VPWR sky130_fd_sc_hd__decap_3
XFILLER_130_97 VGND VGND VPWR VPWR sky130_fd_sc_hd__decap_3
XFILLER_70_365 VGND VGND VPWR VPWR sky130_fd_sc_hd__fill_1
XFILLER_90_35 VGND VGND VPWR VPWR sky130_fd_sc_hd__decap_3
XFILLER_23_281 VGND VGND VPWR VPWR sky130_fd_sc_hd__decap_3
XFILLER_70_398 VGND VGND VPWR VPWR sky130_fd_sc_hd__decap_3
XPHY_EDGE_ROW_61_Right_61 VGND VGND VPWR VPWR sky130_fd_sc_hd__decap_3
XFILLER_128_106 VGND VGND VPWR VPWR sky130_fd_sc_hd__decap_3
XFILLER_129_629 VGND VGND VPWR VPWR sky130_fd_sc_hd__decap_3
XFILLER_128_139 VGND VGND VPWR VPWR sky130_fd_sc_hd__fill_1
XFILLER_23_84 VGND VGND VPWR VPWR sky130_fd_sc_hd__decap_3
XFILLER_7_436 VGND VGND VPWR VPWR sky130_fd_sc_hd__decap_3
XFILLER_99_11 VGND VGND VPWR VPWR sky130_fd_sc_hd__decap_3
XFILLER_109_342 VGND VGND VPWR VPWR sky130_fd_sc_hd__decap_3
XFILLER_109_364 VGND VGND VPWR VPWR sky130_fd_sc_hd__decap_3
XFILLER_99_55 VGND VGND VPWR VPWR sky130_fd_sc_hd__fill_1
XFILLER_124_312 VGND VGND VPWR VPWR sky130_fd_sc_hd__decap_3
XFILLER_3_620 VGND VGND VPWR VPWR sky130_fd_sc_hd__decap_3
XFILLER_99_66 VGND VGND VPWR VPWR sky130_fd_sc_hd__decap_3
XFILLER_112_507 VGND VGND VPWR VPWR sky130_fd_sc_hd__fill_2
XFILLER_3_653 VGND VGND VPWR VPWR sky130_fd_sc_hd__decap_3
XFILLER_99_99 VGND VGND VPWR VPWR sky130_fd_sc_hd__decap_3
XFILLER_105_570 VGND VGND VPWR VPWR sky130_fd_sc_hd__decap_3
XFILLER_31_9 VGND VGND VPWR VPWR sky130_fd_sc_hd__decap_3
XFILLER_3_697 VGND VGND VPWR VPWR sky130_fd_sc_hd__decap_3
XPHY_EDGE_ROW_70_Right_70 VGND VGND VPWR VPWR sky130_fd_sc_hd__decap_3
XTAP_TAPCELL_ROW_111_1846 VGND VPWR sky130_fd_sc_hd__tapvpwrvgnd_1
Xload_slew328 _4637_/A VGND VGND VPWR VPWR _4669_/S sky130_fd_sc_hd__clkbuf_4
Xload_slew317 _4328_/C1 VGND VGND VPWR VPWR _4252_/A sky130_fd_sc_hd__buf_4
Xload_slew306 _4104_/B2 VGND VGND VPWR VPWR _3726_/A sky130_fd_sc_hd__buf_4
XFILLER_66_605 VGND VGND VPWR VPWR sky130_fd_sc_hd__decap_3
XFILLER_120_595 VGND VGND VPWR VPWR sky130_fd_sc_hd__fill_2
XFILLER_66_638 VGND VGND VPWR VPWR sky130_fd_sc_hd__decap_3
XFILLER_93_424 VGND VGND VPWR VPWR sky130_fd_sc_hd__decap_3
XFILLER_0_44 VGND VGND VPWR VPWR sky130_fd_sc_hd__decap_3
XFILLER_19_554 VGND VGND VPWR VPWR sky130_fd_sc_hd__decap_3
XFILLER_74_660 VGND VGND VPWR VPWR sky130_fd_sc_hd__fill_2
XFILLER_0_66 VGND VGND VPWR VPWR sky130_fd_sc_hd__decap_3
XFILLER_74_693 VGND VGND VPWR VPWR sky130_fd_sc_hd__decap_3
XFILLER_0_88 VGND VGND VPWR VPWR sky130_fd_sc_hd__decap_3
XFILLER_61_332 VGND VGND VPWR VPWR sky130_fd_sc_hd__decap_3
Xclkbuf_4_7_0_CLK clkbuf_0_CLK/X VGND VGND VPWR VPWR clkbuf_4_7_0_CLK/X sky130_fd_sc_hd__clkbuf_8
XFILLER_9_42 VGND VGND VPWR VPWR sky130_fd_sc_hd__decap_3
XTAP_TAPCELL_ROW_122_1997 VGND VPWR sky130_fd_sc_hd__tapvpwrvgnd_1
XTAP_TAPCELL_ROW_32_736 VGND VPWR sky130_fd_sc_hd__tapvpwrvgnd_1
XTAP_TAPCELL_ROW_32_747 VGND VPWR sky130_fd_sc_hd__tapvpwrvgnd_1
X_4730_ _4730_/A _4734_/B VGND VGND VPWR VPWR _4731_/A sky130_fd_sc_hd__and2_2
XFILLER_119_106 VGND VGND VPWR VPWR sky130_fd_sc_hd__decap_3
XFILLER_119_117 VGND VGND VPWR VPWR sky130_fd_sc_hd__decap_3
XFILLER_30_752 VGND VGND VPWR VPWR sky130_fd_sc_hd__fill_1
XFILLER_9_75 VGND VGND VPWR VPWR sky130_fd_sc_hd__decap_3
X_4661_ _8456_/Q _8537_/Q _8618_/Q _8699_/Q _4662_/S _4569_/A VGND VGND VPWR VPWR
+ _4661_/X sky130_fd_sc_hd__mux4_2
XFILLER_128_640 VGND VGND VPWR VPWR sky130_fd_sc_hd__decap_3
XTAP_TAPCELL_ROW_12_460 VGND VPWR sky130_fd_sc_hd__tapvpwrvgnd_1
X_7380_ _7380_/A0 _4798_/A _7386_/S VGND VGND VPWR VPWR _7381_/A sky130_fd_sc_hd__mux2_2
X_6400_ _6484_/S VGND VGND VPWR VPWR _6419_/S sky130_fd_sc_hd__buf_4
XFILLER_127_150 VGND VGND VPWR VPWR sky130_fd_sc_hd__decap_3
XFILLER_128_651 VGND VGND VPWR VPWR sky130_fd_sc_hd__decap_3
XFILLER_134_109 VGND VGND VPWR VPWR sky130_fd_sc_hd__decap_3
Xhold904 _8622_/Q VGND VGND VPWR VPWR hold904/X sky130_fd_sc_hd__dlygate4sd3_1
X_6331_ _4977_/X _8223_/Q _6335_/S VGND VGND VPWR VPWR _6332_/A sky130_fd_sc_hd__mux2_2
X_4592_ _4592_/A VGND VGND VPWR VPWR _4592_/X sky130_fd_sc_hd__buf_1
XFILLER_115_312 VGND VGND VPWR VPWR sky130_fd_sc_hd__decap_3
XFILLER_127_172 VGND VGND VPWR VPWR sky130_fd_sc_hd__decap_3
XFILLER_128_684 VGND VGND VPWR VPWR sky130_fd_sc_hd__decap_3
Xhold915 _8700_/Q VGND VGND VPWR VPWR hold915/X sky130_fd_sc_hd__dlygate4sd3_1
Xhold926 _8221_/Q VGND VGND VPWR VPWR hold926/X sky130_fd_sc_hd__dlygate4sd3_1
Xhold937 _8545_/Q VGND VGND VPWR VPWR hold937/X sky130_fd_sc_hd__dlygate4sd3_1
XTAP_TAPCELL_ROW_73_1318 VGND VPWR sky130_fd_sc_hd__tapvpwrvgnd_1
Xhold948 _8552_/Q VGND VGND VPWR VPWR hold948/X sky130_fd_sc_hd__dlygate4sd3_1
Xhold959 _7633_/Q VGND VGND VPWR VPWR hold959/X sky130_fd_sc_hd__dlygate4sd3_1
X_6262_ _4841_/X _8191_/Q _6268_/S VGND VGND VPWR VPWR _6263_/A sky130_fd_sc_hd__mux2_4
XFILLER_103_529 VGND VGND VPWR VPWR sky130_fd_sc_hd__decap_3
XFILLER_130_315 VGND VGND VPWR VPWR sky130_fd_sc_hd__decap_3
X_8001_ _8586_/CLK _8001_/D fanout539/X VGND VGND VPWR VPWR _8001_/Q sky130_fd_sc_hd__dfrtp_2
X_6193_ _4703_/X _8158_/Q _6205_/S VGND VGND VPWR VPWR _6194_/A sky130_fd_sc_hd__mux2_4
X_5213_ _5213_/A VGND VGND VPWR VPWR _7661_/D sky130_fd_sc_hd__buf_1
XFILLER_111_540 VGND VGND VPWR VPWR sky130_fd_sc_hd__decap_3
X_5144_ _4908_/X _5144_/A1 _5158_/S VGND VGND VPWR VPWR _5145_/A sky130_fd_sc_hd__mux2_2
XFILLER_28_18 VGND VGND VPWR VPWR sky130_fd_sc_hd__decap_3
XFILLER_28_29 VGND VGND VPWR VPWR sky130_fd_sc_hd__decap_3
XFILLER_96_251 VGND VGND VPWR VPWR sky130_fd_sc_hd__fill_1
XFILLER_97_785 VGND VGND VPWR VPWR sky130_fd_sc_hd__decap_3
XFILLER_57_649 VGND VGND VPWR VPWR sky130_fd_sc_hd__decap_3
XFILLER_96_284 VGND VGND VPWR VPWR sky130_fd_sc_hd__decap_3
X_5075_ _5075_/A VGND VGND VPWR VPWR _7597_/D sky130_fd_sc_hd__buf_1
X_4026_ _4024_/X _4025_/X _4129_/A VGND VGND VPWR VPWR _4026_/X sky130_fd_sc_hd__mux2_2
XFILLER_71_107 VGND VGND VPWR VPWR sky130_fd_sc_hd__decap_3
XFILLER_64_192 VGND VGND VPWR VPWR sky130_fd_sc_hd__decap_3
XTAP_TAPCELL_ROW_84_1469 VGND VPWR sky130_fd_sc_hd__tapvpwrvgnd_1
XFILLER_100_12 VGND VGND VPWR VPWR sky130_fd_sc_hd__fill_1
XFILLER_12_218 VGND VGND VPWR VPWR sky130_fd_sc_hd__decap_3
XFILLER_40_527 VGND VGND VPWR VPWR sky130_fd_sc_hd__decap_3
XFILLER_52_365 VGND VGND VPWR VPWR sky130_fd_sc_hd__decap_3
X_8765_ _8765_/CLK _8765_/D fanout585/X VGND VGND VPWR VPWR _8765_/Q sky130_fd_sc_hd__dfrtp_2
X_5977_ _5977_/A VGND VGND VPWR VPWR _8056_/D sky130_fd_sc_hd__buf_1
X_8696_ _8698_/CLK _8696_/D fanout744/X VGND VGND VPWR VPWR _8696_/Q sky130_fd_sc_hd__dfrtp_2
X_7716_ _8698_/CLK _7716_/D fanout747/X VGND VGND VPWR VPWR _7716_/Q sky130_fd_sc_hd__dfrtp_2
X_4928_ _4928_/A _4936_/B VGND VGND VPWR VPWR _4929_/A sky130_fd_sc_hd__and2_2
X_7647_ _8622_/CLK _7647_/D load_slew661/X VGND VGND VPWR VPWR _7647_/Q sky130_fd_sc_hd__dfrtp_2
XFILLER_21_785 VGND VGND VPWR VPWR sky130_fd_sc_hd__fill_1
X_4859_ _4859_/A VGND VGND VPWR VPWR _7537_/D sky130_fd_sc_hd__buf_1
XFILLER_114_6 VGND VGND VPWR VPWR sky130_fd_sc_hd__decap_3
XFILLER_119_673 VGND VGND VPWR VPWR sky130_fd_sc_hd__decap_3
X_7578_ _8803_/CLK _7578_/D wire547/X VGND VGND VPWR VPWR _7578_/Q sky130_fd_sc_hd__dfrtp_2
XFILLER_106_312 VGND VGND VPWR VPWR sky130_fd_sc_hd__fill_1
XFILLER_109_43 VGND VGND VPWR VPWR sky130_fd_sc_hd__decap_3
XFILLER_118_172 VGND VGND VPWR VPWR sky130_fd_sc_hd__decap_3
XFILLER_134_610 VGND VGND VPWR VPWR sky130_fd_sc_hd__decap_3
XFILLER_134_632 VGND VGND VPWR VPWR sky130_fd_sc_hd__decap_3
X_6529_ _6529_/A VGND VGND VPWR VPWR _8316_/D sky130_fd_sc_hd__buf_2
XFILLER_133_131 VGND VGND VPWR VPWR sky130_fd_sc_hd__decap_3
XFILLER_134_654 VGND VGND VPWR VPWR sky130_fd_sc_hd__decap_3
XFILLER_121_315 VGND VGND VPWR VPWR sky130_fd_sc_hd__decap_3
XFILLER_133_164 VGND VGND VPWR VPWR sky130_fd_sc_hd__decap_3
XFILLER_133_175 VGND VGND VPWR VPWR sky130_fd_sc_hd__decap_3
XFILLER_134_687 VGND VGND VPWR VPWR sky130_fd_sc_hd__decap_3
XFILLER_69_69 VGND VGND VPWR VPWR sky130_fd_sc_hd__decap_3
XFILLER_0_645 VGND VGND VPWR VPWR sky130_fd_sc_hd__decap_3
XFILLER_121_337 VGND VGND VPWR VPWR sky130_fd_sc_hd__decap_3
XFILLER_125_42 VGND VGND VPWR VPWR sky130_fd_sc_hd__decap_3
XFILLER_125_75 VGND VGND VPWR VPWR sky130_fd_sc_hd__decap_3
XFILLER_47_104 VGND VGND VPWR VPWR sky130_fd_sc_hd__decap_3
XFILLER_85_24 VGND VGND VPWR VPWR sky130_fd_sc_hd__decap_3
XFILLER_87_240 VGND VGND VPWR VPWR sky130_fd_sc_hd__decap_3
XFILLER_88_763 VGND VGND VPWR VPWR sky130_fd_sc_hd__decap_3
XFILLER_102_584 VGND VGND VPWR VPWR sky130_fd_sc_hd__decap_3
XFILLER_48_649 VGND VGND VPWR VPWR sky130_fd_sc_hd__decap_3
XFILLER_85_46 VGND VGND VPWR VPWR sky130_fd_sc_hd__fill_2
XFILLER_18_62 VGND VGND VPWR VPWR sky130_fd_sc_hd__decap_3
XFILLER_75_457 VGND VGND VPWR VPWR sky130_fd_sc_hd__decap_3
XFILLER_90_405 VGND VGND VPWR VPWR sky130_fd_sc_hd__fill_1
XTAP_TAPCELL_ROW_126_2053 VGND VPWR sky130_fd_sc_hd__tapvpwrvgnd_1
XFILLER_28_373 VGND VGND VPWR VPWR sky130_fd_sc_hd__decap_3
XFILLER_62_107 VGND VGND VPWR VPWR sky130_fd_sc_hd__decap_3
XFILLER_90_438 VGND VGND VPWR VPWR sky130_fd_sc_hd__decap_3
XFILLER_31_505 VGND VGND VPWR VPWR sky130_fd_sc_hd__fill_1
XFILLER_70_195 VGND VGND VPWR VPWR sky130_fd_sc_hd__fill_1
XFILLER_129_426 VGND VGND VPWR VPWR sky130_fd_sc_hd__decap_3
XFILLER_12_763 VGND VGND VPWR VPWR sky130_fd_sc_hd__decap_3
XFILLER_8_701 VGND VGND VPWR VPWR sky130_fd_sc_hd__decap_3
XFILLER_11_251 VGND VGND VPWR VPWR sky130_fd_sc_hd__decap_3
XFILLER_11_284 VGND VGND VPWR VPWR sky130_fd_sc_hd__fill_1
XFILLER_12_796 VGND VGND VPWR VPWR sky130_fd_sc_hd__decap_3
XFILLER_8_734 VGND VGND VPWR VPWR sky130_fd_sc_hd__decap_3
XFILLER_7_233 VGND VGND VPWR VPWR sky130_fd_sc_hd__decap_3
XFILLER_8_778 VGND VGND VPWR VPWR sky130_fd_sc_hd__decap_3
Xwire175 _7217_/X VGND VGND VPWR VPWR wire175/X sky130_fd_sc_hd__clkbuf_4
XFILLER_98_505 VGND VGND VPWR VPWR sky130_fd_sc_hd__decap_3
XFILLER_112_315 VGND VGND VPWR VPWR sky130_fd_sc_hd__decap_3
XFILLER_124_164 VGND VGND VPWR VPWR sky130_fd_sc_hd__fill_1
XFILLER_125_676 VGND VGND VPWR VPWR sky130_fd_sc_hd__fill_2
XFILLER_125_687 VGND VGND VPWR VPWR sky130_fd_sc_hd__decap_3
XFILLER_124_197 VGND VGND VPWR VPWR sky130_fd_sc_hd__decap_3
XTAP_TAPCELL_ROW_55_1059 VGND VPWR sky130_fd_sc_hd__tapvpwrvgnd_1
XFILLER_79_763 VGND VGND VPWR VPWR sky130_fd_sc_hd__decap_3
XFILLER_38_115 VGND VGND VPWR VPWR sky130_fd_sc_hd__decap_3
XFILLER_38_137 VGND VGND VPWR VPWR sky130_fd_sc_hd__decap_3
XFILLER_93_221 VGND VGND VPWR VPWR sky130_fd_sc_hd__decap_3
XFILLER_94_755 VGND VGND VPWR VPWR sky130_fd_sc_hd__fill_1
XFILLER_19_340 VGND VGND VPWR VPWR sky130_fd_sc_hd__fill_1
XFILLER_35_800 VGND VGND VPWR VPWR sky130_fd_sc_hd__decap_3
XTAP_TAPCELL_ROW_37_806 VGND VPWR sky130_fd_sc_hd__tapvpwrvgnd_1
XFILLER_19_362 VGND VGND VPWR VPWR sky130_fd_sc_hd__decap_3
XTAP_TAPCELL_ROW_37_817 VGND VPWR sky130_fd_sc_hd__tapvpwrvgnd_1
X_5900_ _5894_/X _5895_/X _4745_/X _5896_/X hold905/X VGND VGND VPWR VPWR _7996_/D
+ sky130_fd_sc_hd__a32o_2
XFILLER_34_332 VGND VGND VPWR VPWR sky130_fd_sc_hd__decap_3
XFILLER_46_192 VGND VGND VPWR VPWR sky130_fd_sc_hd__decap_3
XFILLER_81_449 VGND VGND VPWR VPWR sky130_fd_sc_hd__decap_3
XTAP_TAPCELL_ROW_17_530 VGND VPWR sky130_fd_sc_hd__tapvpwrvgnd_1
X_6880_ _6880_/A VGND VGND VPWR VPWR _8480_/D sky130_fd_sc_hd__buf_6
XFILLER_34_365 VGND VGND VPWR VPWR sky130_fd_sc_hd__decap_3
XFILLER_61_140 VGND VGND VPWR VPWR sky130_fd_sc_hd__fill_2
XFILLER_61_162 VGND VGND VPWR VPWR sky130_fd_sc_hd__decap_3
X_5831_ _7953_/Q _4903_/A _5847_/S VGND VGND VPWR VPWR _5832_/A sky130_fd_sc_hd__mux2_2
XFILLER_62_696 VGND VGND VPWR VPWR sky130_fd_sc_hd__decap_3
X_8550_ _8721_/CLK _8550_/D fanout588/X VGND VGND VPWR VPWR _8550_/Q sky130_fd_sc_hd__dfrtp_2
X_5762_ _5762_/A VGND VGND VPWR VPWR _7920_/D sky130_fd_sc_hd__buf_1
X_7501_ _8730_/CLK _7501_/D load_slew484/X VGND VGND VPWR VPWR _7501_/Q sky130_fd_sc_hd__dfrtp_2
X_4713_ _4713_/A VGND VGND VPWR VPWR _7502_/D sky130_fd_sc_hd__buf_1
X_8481_ _8724_/CLK _8481_/D load_slew503/X VGND VGND VPWR VPWR _8481_/Q sky130_fd_sc_hd__dfrtp_2
X_5693_ _5693_/A VGND VGND VPWR VPWR _7887_/D sky130_fd_sc_hd__buf_1
XFILLER_107_109 VGND VGND VPWR VPWR sky130_fd_sc_hd__decap_3
X_7432_ _7432_/A VGND VGND VPWR VPWR _8772_/D sky130_fd_sc_hd__buf_1
X_4644_ _8131_/Q _8212_/Q _4650_/S VGND VGND VPWR VPWR _4644_/X sky130_fd_sc_hd__mux2_2
XFILLER_128_492 VGND VGND VPWR VPWR sky130_fd_sc_hd__decap_3
XFILLER_135_429 VGND VGND VPWR VPWR sky130_fd_sc_hd__decap_3
X_7363_ _8740_/Q _4764_/A _7365_/S VGND VGND VPWR VPWR _7364_/A sky130_fd_sc_hd__mux2_2
X_4575_ _7710_/Q _3969_/X _4574_/X VGND VGND VPWR VPWR _4575_/X sky130_fd_sc_hd__o21a_2
XFILLER_89_505 VGND VGND VPWR VPWR sky130_fd_sc_hd__decap_3
X_7294_ _8707_/Q _4968_/A _7302_/S VGND VGND VPWR VPWR _7295_/A sky130_fd_sc_hd__mux2_2
X_6314_ _6314_/A _7004_/B _6314_/C _7004_/D VGND VGND VPWR VPWR _6315_/A sky130_fd_sc_hd__or4_4
XFILLER_115_175 VGND VGND VPWR VPWR sky130_fd_sc_hd__decap_3
Xhold756 _8646_/Q VGND VGND VPWR VPWR hold756/X sky130_fd_sc_hd__dlygate4sd3_1
Xhold767 _8661_/Q VGND VGND VPWR VPWR hold767/X sky130_fd_sc_hd__dlygate4sd3_1
Xhold778 _7971_/Q VGND VGND VPWR VPWR hold778/X sky130_fd_sc_hd__dlygate4sd3_1
X_6245_ _4807_/X _8183_/Q _6247_/S VGND VGND VPWR VPWR _6246_/A sky130_fd_sc_hd__mux2_4
XFILLER_103_337 VGND VGND VPWR VPWR sky130_fd_sc_hd__decap_3
XFILLER_130_112 VGND VGND VPWR VPWR sky130_fd_sc_hd__decap_3
XFILLER_131_635 VGND VGND VPWR VPWR sky130_fd_sc_hd__decap_3
XFILLER_131_668 VGND VGND VPWR VPWR sky130_fd_sc_hd__decap_3
Xhold789 _8025_/Q VGND VGND VPWR VPWR hold789/X sky130_fd_sc_hd__dlygate4sd3_1
XFILLER_130_156 VGND VGND VPWR VPWR sky130_fd_sc_hd__decap_3
XFILLER_131_679 VGND VGND VPWR VPWR sky130_fd_sc_hd__decap_3
XFILLER_57_402 VGND VGND VPWR VPWR sky130_fd_sc_hd__decap_3
XFILLER_69_240 VGND VGND VPWR VPWR sky130_fd_sc_hd__decap_3
X_6176_ _5011_/X _8150_/Q _6184_/S VGND VGND VPWR VPWR _6177_/A sky130_fd_sc_hd__mux2_4
XFILLER_111_381 VGND VGND VPWR VPWR sky130_fd_sc_hd__decap_3
XFILLER_130_189 VGND VGND VPWR VPWR sky130_fd_sc_hd__decap_3
XFILLER_85_722 VGND VGND VPWR VPWR sky130_fd_sc_hd__decap_3
X_5127_ _4875_/X _5127_/A1 _5137_/S VGND VGND VPWR VPWR _5128_/A sky130_fd_sc_hd__mux2_2
XPHY_EDGE_ROW_2_Right_2 VGND VGND VPWR VPWR sky130_fd_sc_hd__decap_3
X_5058_ _4735_/X _7589_/Q _5074_/S VGND VGND VPWR VPWR _5059_/A sky130_fd_sc_hd__mux2_2
XFILLER_38_660 VGND VGND VPWR VPWR sky130_fd_sc_hd__fill_2
XFILLER_72_427 VGND VGND VPWR VPWR sky130_fd_sc_hd__decap_3
X_4009_ _7901_/Q _3805_/X _4008_/X VGND VGND VPWR VPWR _4009_/X sky130_fd_sc_hd__o21a_2
XFILLER_111_11 VGND VGND VPWR VPWR sky130_fd_sc_hd__fill_2
XFILLER_37_181 VGND VGND VPWR VPWR sky130_fd_sc_hd__decap_3
XFILLER_65_490 VGND VGND VPWR VPWR sky130_fd_sc_hd__decap_3
XFILLER_13_505 VGND VGND VPWR VPWR sky130_fd_sc_hd__decap_3
XFILLER_111_66 VGND VGND VPWR VPWR sky130_fd_sc_hd__decap_3
XFILLER_13_538 VGND VGND VPWR VPWR sky130_fd_sc_hd__decap_3
XFILLER_71_15 VGND VGND VPWR VPWR sky130_fd_sc_hd__decap_3
X_8748_ _8748_/CLK _8748_/D fanout542/X VGND VGND VPWR VPWR _8748_/Q sky130_fd_sc_hd__dfrtp_2
XFILLER_111_99 VGND VGND VPWR VPWR sky130_fd_sc_hd__decap_3
X_8679_ _8679_/CLK _8679_/D load_slew696/X VGND VGND VPWR VPWR _8679_/Q sky130_fd_sc_hd__dfrtp_2
XTAP_TAPCELL_ROW_97_1649 VGND VPWR sky130_fd_sc_hd__tapvpwrvgnd_1
XFILLER_107_632 VGND VGND VPWR VPWR sky130_fd_sc_hd__fill_2
XFILLER_5_715 VGND VGND VPWR VPWR sky130_fd_sc_hd__decap_3
XFILLER_134_451 VGND VGND VPWR VPWR sky130_fd_sc_hd__decap_3
XFILLER_20_41 VGND VGND VPWR VPWR sky130_fd_sc_hd__decap_3
XFILLER_5_759 VGND VGND VPWR VPWR sky130_fd_sc_hd__decap_3
XFILLER_106_153 VGND VGND VPWR VPWR sky130_fd_sc_hd__fill_1
XFILLER_106_175 VGND VGND VPWR VPWR sky130_fd_sc_hd__decap_3
XFILLER_20_74 VGND VGND VPWR VPWR sky130_fd_sc_hd__decap_3
XFILLER_20_85 VGND VGND VPWR VPWR sky130_fd_sc_hd__decap_3
XFILLER_106_197 VGND VGND VPWR VPWR sky130_fd_sc_hd__fill_1
XFILLER_134_495 VGND VGND VPWR VPWR sky130_fd_sc_hd__decap_3
XFILLER_96_23 VGND VGND VPWR VPWR sky130_fd_sc_hd__decap_3
XFILLER_121_167 VGND VGND VPWR VPWR sky130_fd_sc_hd__fill_1
XFILLER_102_381 VGND VGND VPWR VPWR sky130_fd_sc_hd__decap_3
XFILLER_121_178 VGND VGND VPWR VPWR sky130_fd_sc_hd__fill_1
XFILLER_121_189 VGND VGND VPWR VPWR sky130_fd_sc_hd__decap_3
XFILLER_130_690 VGND VGND VPWR VPWR sky130_fd_sc_hd__decap_3
XFILLER_48_424 VGND VGND VPWR VPWR sky130_fd_sc_hd__decap_3
XFILLER_75_210 VGND VGND VPWR VPWR sky130_fd_sc_hd__decap_3
XFILLER_76_722 VGND VGND VPWR VPWR sky130_fd_sc_hd__decap_3
XFILLER_76_744 VGND VGND VPWR VPWR sky130_fd_sc_hd__fill_2
XFILLER_76_755 VGND VGND VPWR VPWR sky130_fd_sc_hd__fill_1
XFILLER_76_766 VGND VGND VPWR VPWR sky130_fd_sc_hd__fill_2
XFILLER_63_427 VGND VGND VPWR VPWR sky130_fd_sc_hd__decap_3
XFILLER_75_276 VGND VGND VPWR VPWR sky130_fd_sc_hd__fill_1
XFILLER_91_758 VGND VGND VPWR VPWR sky130_fd_sc_hd__fill_1
XFILLER_16_365 VGND VGND VPWR VPWR sky130_fd_sc_hd__decap_3
XFILLER_44_674 VGND VGND VPWR VPWR sky130_fd_sc_hd__decap_3
XFILLER_45_82 VGND VGND VPWR VPWR sky130_fd_sc_hd__decap_3
XTAP_TAPCELL_ROW_106_1778 VGND VPWR sky130_fd_sc_hd__tapvpwrvgnd_1
XFILLER_44_696 VGND VGND VPWR VPWR sky130_fd_sc_hd__decap_3
XFILLER_129_223 VGND VGND VPWR VPWR sky130_fd_sc_hd__fill_1
XFILLER_129_234 VGND VGND VPWR VPWR sky130_fd_sc_hd__decap_3
XFILLER_12_560 VGND VGND VPWR VPWR sky130_fd_sc_hd__decap_3
XFILLER_12_582 VGND VGND VPWR VPWR sky130_fd_sc_hd__decap_3
XTAP_TAPCELL_ROW_42_875 VGND VPWR sky130_fd_sc_hd__tapvpwrvgnd_1
XTAP_TAPCELL_ROW_42_886 VGND VPWR sky130_fd_sc_hd__tapvpwrvgnd_1
XFILLER_117_418 VGND VGND VPWR VPWR sky130_fd_sc_hd__decap_3
XFILLER_129_267 VGND VGND VPWR VPWR sky130_fd_sc_hd__decap_3
XFILLER_8_542 VGND VGND VPWR VPWR sky130_fd_sc_hd__decap_3
XANTENNA_3 _4313_/A1 VGND VGND VPWR VPWR sky130_fd_sc_hd__diode_2
XFILLER_6_21 VGND VGND VPWR VPWR sky130_fd_sc_hd__decap_3
XFILLER_6_32 VGND VGND VPWR VPWR sky130_fd_sc_hd__decap_3
XFILLER_6_65 VGND VGND VPWR VPWR sky130_fd_sc_hd__decap_3
X_4360_ _3795_/X _4351_/X _4354_/X _4359_/X VGND VGND VPWR VPWR _4360_/X sky130_fd_sc_hd__o31a_2
XFILLER_6_98 VGND VGND VPWR VPWR sky130_fd_sc_hd__fill_2
XFILLER_4_781 VGND VGND VPWR VPWR sky130_fd_sc_hd__decap_3
X_4291_ _8009_/Q _4350_/A2 _4436_/B1 _7928_/Q _4300_/A1 VGND VGND VPWR VPWR _4291_/X
+ sky130_fd_sc_hd__o221a_2
XFILLER_113_668 VGND VGND VPWR VPWR sky130_fd_sc_hd__decap_3
XFILLER_86_519 VGND VGND VPWR VPWR sky130_fd_sc_hd__decap_3
XFILLER_98_368 VGND VGND VPWR VPWR sky130_fd_sc_hd__decap_3
X_6030_ _8082_/Q _4722_/A _6032_/S VGND VGND VPWR VPWR _6031_/A sky130_fd_sc_hd__mux2_2
XFILLER_100_318 VGND VGND VPWR VPWR sky130_fd_sc_hd__decap_3
XFILLER_94_552 VGND VGND VPWR VPWR sky130_fd_sc_hd__fill_1
XFILLER_54_405 VGND VGND VPWR VPWR sky130_fd_sc_hd__decap_3
XFILLER_66_265 VGND VGND VPWR VPWR sky130_fd_sc_hd__decap_3
XFILLER_67_788 VGND VGND VPWR VPWR sky130_fd_sc_hd__fill_1
XFILLER_81_213 VGND VGND VPWR VPWR sky130_fd_sc_hd__decap_3
XFILLER_94_574 VGND VGND VPWR VPWR sky130_fd_sc_hd__decap_3
XTAP_TAPCELL_ROW_68_1239 VGND VPWR sky130_fd_sc_hd__tapvpwrvgnd_1
X_7981_ _8634_/CLK _7981_/D fanout604/X VGND VGND VPWR VPWR _7981_/Q sky130_fd_sc_hd__dfrtp_2
XFILLER_47_490 VGND VGND VPWR VPWR sky130_fd_sc_hd__decap_3
XFILLER_54_438 VGND VGND VPWR VPWR sky130_fd_sc_hd__decap_3
X_6932_ _6932_/A VGND VGND VPWR VPWR _8505_/D sky130_fd_sc_hd__buf_6
XFILLER_62_460 VGND VGND VPWR VPWR sky130_fd_sc_hd__decap_3
X_6863_ _6863_/A VGND VGND VPWR VPWR _8472_/D sky130_fd_sc_hd__buf_6
XFILLER_22_324 VGND VGND VPWR VPWR sky130_fd_sc_hd__fill_1
XTAP_TAPCELL_ROW_81_1428 VGND VPWR sky130_fd_sc_hd__tapvpwrvgnd_1
X_8602_ _8683_/CLK _8602_/D fanout566/X VGND VGND VPWR VPWR _8602_/Q sky130_fd_sc_hd__dfrtp_2
X_5814_ _7945_/Q _4871_/A _5826_/S VGND VGND VPWR VPWR _5815_/A sky130_fd_sc_hd__mux2_2
XFILLER_22_368 VGND VGND VPWR VPWR sky130_fd_sc_hd__decap_3
XFILLER_34_195 VGND VGND VPWR VPWR sky130_fd_sc_hd__fill_1
X_6794_ _6794_/A VGND VGND VPWR VPWR _8440_/D sky130_fd_sc_hd__buf_2
X_8533_ _8776_/CLK _8533_/D load_slew731/X VGND VGND VPWR VPWR _8533_/Q sky130_fd_sc_hd__dfrtp_2
X_5745_ _5745_/A0 _4731_/A _5763_/S VGND VGND VPWR VPWR _5746_/A sky130_fd_sc_hd__mux2_2
X_8464_ _8545_/CLK _8464_/D load_slew663/X VGND VGND VPWR VPWR _8464_/Q sky130_fd_sc_hd__dfrtp_2
X_5676_ _5676_/A VGND VGND VPWR VPWR _7880_/D sky130_fd_sc_hd__buf_1
XTAP_TAPCELL_ROW_20_569 VGND VPWR sky130_fd_sc_hd__tapvpwrvgnd_1
X_7415_ _7415_/A VGND VGND VPWR VPWR _8764_/D sky130_fd_sc_hd__buf_1
X_4627_ _4639_/A1 _4626_/X _4673_/S VGND VGND VPWR VPWR _4627_/X sky130_fd_sc_hd__o21a_2
XFILLER_135_237 VGND VGND VPWR VPWR sky130_fd_sc_hd__decap_3
XFILLER_135_259 VGND VGND VPWR VPWR sky130_fd_sc_hd__decap_3
X_8395_ _8719_/CLK _8395_/D load_slew591/X VGND VGND VPWR VPWR _8395_/Q sky130_fd_sc_hd__dfrtp_2
XFILLER_116_451 VGND VGND VPWR VPWR sky130_fd_sc_hd__decap_3
XFILLER_2_707 VGND VGND VPWR VPWR sky130_fd_sc_hd__decap_3
Xmax_cap261 _3750_/X VGND VGND VPWR VPWR _4682_/A2 sky130_fd_sc_hd__buf_6
Xmax_cap250 _3800_/X VGND VGND VPWR VPWR _4424_/A2 sky130_fd_sc_hd__buf_6
X_7346_ _7451_/S VGND VGND VPWR VPWR _7365_/S sky130_fd_sc_hd__clkbuf_2
X_4558_ _3795_/X _4549_/X _4552_/X _4557_/X VGND VGND VPWR VPWR _4558_/X sky130_fd_sc_hd__o31a_2
XFILLER_104_635 VGND VGND VPWR VPWR sky130_fd_sc_hd__fill_1
XFILLER_131_421 VGND VGND VPWR VPWR sky130_fd_sc_hd__decap_3
XFILLER_89_324 VGND VGND VPWR VPWR sky130_fd_sc_hd__decap_3
XFILLER_89_346 VGND VGND VPWR VPWR sky130_fd_sc_hd__decap_3
XFILLER_9_9 VGND VGND VPWR VPWR sky130_fd_sc_hd__decap_3
XTAP_TAPCELL_ROW_92_1579 VGND VPWR sky130_fd_sc_hd__tapvpwrvgnd_1
Xmax_cap272 _3762_/A VGND VGND VPWR VPWR _3921_/A sky130_fd_sc_hd__clkbuf_2
X_7277_ _7267_/X _4925_/X _7280_/A3 _7280_/B1 hold809/X VGND VGND VPWR VPWR _8697_/D
+ sky130_fd_sc_hd__a32o_2
X_4489_ _8360_/Q _4560_/A2 _4622_/B1 _8279_/Q _4120_/A VGND VGND VPWR VPWR _4489_/X
+ sky130_fd_sc_hd__o221a_2
XFILLER_103_167 VGND VGND VPWR VPWR sky130_fd_sc_hd__fill_1
XFILLER_106_44 VGND VGND VPWR VPWR sky130_fd_sc_hd__fill_1
XFILLER_131_476 VGND VGND VPWR VPWR sky130_fd_sc_hd__decap_3
XFILLER_77_508 VGND VGND VPWR VPWR sky130_fd_sc_hd__fill_2
XFILLER_89_368 VGND VGND VPWR VPWR sky130_fd_sc_hd__decap_3
X_6228_ _6312_/S VGND VGND VPWR VPWR _6247_/S sky130_fd_sc_hd__buf_6
XFILLER_103_178 VGND VGND VPWR VPWR sky130_fd_sc_hd__decap_3
XFILLER_58_733 VGND VGND VPWR VPWR sky130_fd_sc_hd__decap_3
X_6159_ _4977_/X _8142_/Q _6163_/S VGND VGND VPWR VPWR _6160_/A sky130_fd_sc_hd__mux2_4
XTAP_TAPCELL_ROW_123_2012 VGND VPWR sky130_fd_sc_hd__tapvpwrvgnd_1
XFILLER_45_449 VGND VGND VPWR VPWR sky130_fd_sc_hd__decap_3
XFILLER_73_747 VGND VGND VPWR VPWR sky130_fd_sc_hd__decap_3
XFILLER_122_76 VGND VGND VPWR VPWR sky130_fd_sc_hd__decap_3
XFILLER_26_663 VGND VGND VPWR VPWR sky130_fd_sc_hd__decap_3
XFILLER_82_47 VGND VGND VPWR VPWR sky130_fd_sc_hd__decap_3
XTAP_TAPCELL_ROW_0_272 VGND VPWR sky130_fd_sc_hd__tapvpwrvgnd_1
XFILLER_13_302 VGND VGND VPWR VPWR sky130_fd_sc_hd__decap_3
XFILLER_15_30 VGND VGND VPWR VPWR sky130_fd_sc_hd__decap_3
XTAP_TAPCELL_ROW_0_283 VGND VPWR sky130_fd_sc_hd__tapvpwrvgnd_1
XTAP_TAPCELL_ROW_0_294 VGND VPWR sky130_fd_sc_hd__tapvpwrvgnd_1
XFILLER_13_335 VGND VGND VPWR VPWR sky130_fd_sc_hd__fill_1
XFILLER_13_368 VGND VGND VPWR VPWR sky130_fd_sc_hd__decap_3
XFILLER_15_63 VGND VGND VPWR VPWR sky130_fd_sc_hd__decap_3
XFILLER_40_132 VGND VGND VPWR VPWR sky130_fd_sc_hd__decap_3
XFILLER_41_655 VGND VGND VPWR VPWR sky130_fd_sc_hd__decap_3
XFILLER_41_688 VGND VGND VPWR VPWR sky130_fd_sc_hd__decap_3
XFILLER_9_317 VGND VGND VPWR VPWR sky130_fd_sc_hd__decap_3
XFILLER_21_390 VGND VGND VPWR VPWR sky130_fd_sc_hd__fill_2
XFILLER_127_727 VGND VGND VPWR VPWR sky130_fd_sc_hd__fill_1
XFILLER_127_738 VGND VGND VPWR VPWR sky130_fd_sc_hd__decap_3
XFILLER_5_534 VGND VGND VPWR VPWR sky130_fd_sc_hd__decap_3
XTAP_TAPCELL_ROW_134_2163 VGND VPWR sky130_fd_sc_hd__tapvpwrvgnd_1
XTAP_TAPCELL_ROW_134_2174 VGND VPWR sky130_fd_sc_hd__tapvpwrvgnd_1
XFILLER_135_760 VGND VGND VPWR VPWR sky130_fd_sc_hd__decap_3
XFILLER_122_432 VGND VGND VPWR VPWR sky130_fd_sc_hd__decap_3
XFILLER_134_292 VGND VGND VPWR VPWR sky130_fd_sc_hd__decap_3
XFILLER_110_605 VGND VGND VPWR VPWR sky130_fd_sc_hd__decap_3
XFILLER_1_762 VGND VGND VPWR VPWR sky130_fd_sc_hd__decap_3
XFILLER_49_700 VGND VGND VPWR VPWR sky130_fd_sc_hd__decap_3
XTAP_TAPCELL_ROW_52_1018 VGND VPWR sky130_fd_sc_hd__tapvpwrvgnd_1
XFILLER_49_722 VGND VGND VPWR VPWR sky130_fd_sc_hd__decap_3
Xoutput95 _3991_/X VGND VGND VPWR VPWR rdata[17] sky130_fd_sc_hd__clkdlybuf4s25_1
XFILLER_48_276 VGND VGND VPWR VPWR sky130_fd_sc_hd__decap_3
XFILLER_76_563 VGND VGND VPWR VPWR sky130_fd_sc_hd__decap_3
XTAP_TAPCELL_ROW_108_1807 VGND VPWR sky130_fd_sc_hd__tapvpwrvgnd_1
XFILLER_17_630 VGND VGND VPWR VPWR sky130_fd_sc_hd__decap_3
XFILLER_63_235 VGND VGND VPWR VPWR sky130_fd_sc_hd__fill_1
XTAP_TAPCELL_ROW_47_945 VGND VPWR sky130_fd_sc_hd__tapvpwrvgnd_1
XTAP_TAPCELL_ROW_47_956 VGND VPWR sky130_fd_sc_hd__tapvpwrvgnd_1
XFILLER_17_663 VGND VGND VPWR VPWR sky130_fd_sc_hd__decap_3
XFILLER_63_268 VGND VGND VPWR VPWR sky130_fd_sc_hd__decap_3
XFILLER_17_685 VGND VGND VPWR VPWR sky130_fd_sc_hd__decap_3
XFILLER_31_110 VGND VGND VPWR VPWR sky130_fd_sc_hd__fill_2
XFILLER_44_471 VGND VGND VPWR VPWR sky130_fd_sc_hd__decap_3
XFILLER_71_290 VGND VGND VPWR VPWR sky130_fd_sc_hd__decap_3
XTAP_TAPCELL_ROW_63_1169 VGND VPWR sky130_fd_sc_hd__tapvpwrvgnd_1
X_3860_ _8385_/Q _8466_/Q _8547_/Q _8628_/Q _3861_/S _3862_/A VGND VGND VPWR VPWR
+ _3860_/X sky130_fd_sc_hd__mux4_2
XFILLER_31_165 VGND VGND VPWR VPWR sky130_fd_sc_hd__decap_3
XFILLER_72_91 VGND VGND VPWR VPWR sky130_fd_sc_hd__fill_1
X_3791_ _3791_/A VGND VGND VPWR VPWR _4221_/A sky130_fd_sc_hd__clkbuf_2
X_5530_ _5677_/S VGND VGND VPWR VPWR _5549_/S sky130_fd_sc_hd__buf_2
XFILLER_118_727 VGND VGND VPWR VPWR sky130_fd_sc_hd__decap_3
XFILLER_118_749 VGND VGND VPWR VPWR sky130_fd_sc_hd__fill_1
XTAP_TAPCELL_ROW_119_1958 VGND VPWR sky130_fd_sc_hd__tapvpwrvgnd_1
X_5461_ _7779_/Q _4852_/A _5461_/S VGND VGND VPWR VPWR _5462_/A sky130_fd_sc_hd__mux2_2
X_7200_ _7189_/X _5019_/X _7201_/A3 wire207/X hold812/X VGND VGND VPWR VPWR _8638_/D
+ sky130_fd_sc_hd__a32o_2
X_4412_ _8677_/Q _3816_/X _4411_/X _4412_/B2 _4456_/C1 VGND VGND VPWR VPWR _4412_/X
+ sky130_fd_sc_hd__o221a_2
XFILLER_132_218 VGND VGND VPWR VPWR sky130_fd_sc_hd__decap_3
XFILLER_99_600 VGND VGND VPWR VPWR sky130_fd_sc_hd__decap_3
XTAP_TAPCELL_ROW_78_1390 VGND VPWR sky130_fd_sc_hd__tapvpwrvgnd_1
X_8180_ _8462_/CLK _8180_/D fanout646/X VGND VGND VPWR VPWR _8180_/Q sky130_fd_sc_hd__dfrtp_2
X_5392_ _7746_/Q _4714_/A _5398_/S VGND VGND VPWR VPWR _5393_/A sky130_fd_sc_hd__mux2_2
XFILLER_125_270 VGND VGND VPWR VPWR sky130_fd_sc_hd__decap_3
XFILLER_125_281 VGND VGND VPWR VPWR sky130_fd_sc_hd__decap_3
XFILLER_126_793 VGND VGND VPWR VPWR sky130_fd_sc_hd__decap_3
XFILLER_98_121 VGND VGND VPWR VPWR sky130_fd_sc_hd__decap_3
XFILLER_99_644 VGND VGND VPWR VPWR sky130_fd_sc_hd__decap_3
XPHY_EDGE_ROW_99_Right_99 VGND VGND VPWR VPWR sky130_fd_sc_hd__decap_3
X_7131_ _7131_/A VGND VGND VPWR VPWR _8599_/D sky130_fd_sc_hd__buf_2
X_4343_ _8752_/Q _7527_/Q _4675_/S VGND VGND VPWR VPWR _4344_/B sky130_fd_sc_hd__mux2_2
Xfanout307 _4557_/A1 VGND VGND VPWR VPWR _4522_/S sky130_fd_sc_hd__clkdlybuf4s25_1
Xfanout318 _4672_/S VGND VGND VPWR VPWR _4684_/B2 sky130_fd_sc_hd__clkdlybuf4s25_1
Xfanout329 _8046_/Q VGND VGND VPWR VPWR wire330/A sky130_fd_sc_hd__clkdlybuf4s25_1
X_7062_ _7062_/A VGND VGND VPWR VPWR _8566_/D sky130_fd_sc_hd__buf_2
X_4274_ _8341_/Q _4286_/A2 _3889_/X _8260_/Q _4315_/C1 VGND VGND VPWR VPWR _4274_/X
+ sky130_fd_sc_hd__o221a_2
X_6013_ _6097_/A VGND VGND VPWR VPWR _6032_/S sky130_fd_sc_hd__clkbuf_2
XFILLER_67_541 VGND VGND VPWR VPWR sky130_fd_sc_hd__decap_3
XFILLER_79_390 VGND VGND VPWR VPWR sky130_fd_sc_hd__fill_2
XFILLER_39_254 VGND VGND VPWR VPWR sky130_fd_sc_hd__fill_1
XFILLER_54_202 VGND VGND VPWR VPWR sky130_fd_sc_hd__decap_3
XFILLER_55_703 VGND VGND VPWR VPWR sky130_fd_sc_hd__fill_2
XFILLER_94_371 VGND VGND VPWR VPWR sky130_fd_sc_hd__decap_3
XFILLER_27_427 VGND VGND VPWR VPWR sky130_fd_sc_hd__fill_2
XFILLER_36_29 VGND VGND VPWR VPWR sky130_fd_sc_hd__decap_3
XFILLER_54_235 VGND VGND VPWR VPWR sky130_fd_sc_hd__decap_3
X_7964_ _8387_/CLK _7964_/D wire657/X VGND VGND VPWR VPWR _7964_/Q sky130_fd_sc_hd__dfrtp_2
XFILLER_54_246 VGND VGND VPWR VPWR sky130_fd_sc_hd__decap_3
XFILLER_54_268 VGND VGND VPWR VPWR sky130_fd_sc_hd__decap_3
XFILLER_70_728 VGND VGND VPWR VPWR sky130_fd_sc_hd__decap_3
X_6915_ _6915_/A VGND VGND VPWR VPWR _8497_/D sky130_fd_sc_hd__buf_6
XFILLER_23_600 VGND VGND VPWR VPWR sky130_fd_sc_hd__decap_3
XFILLER_70_739 VGND VGND VPWR VPWR sky130_fd_sc_hd__decap_3
XTAP_TAPCELL_ROW_25_639 VGND VPWR sky130_fd_sc_hd__tapvpwrvgnd_1
X_7895_ _8634_/CLK _7895_/D fanout606/X VGND VGND VPWR VPWR _7895_/Q sky130_fd_sc_hd__dfrtp_2
X_6846_ _6846_/A VGND VGND VPWR VPWR _8464_/D sky130_fd_sc_hd__buf_6
XFILLER_22_154 VGND VGND VPWR VPWR sky130_fd_sc_hd__decap_3
XFILLER_50_463 VGND VGND VPWR VPWR sky130_fd_sc_hd__fill_2
XFILLER_50_474 VGND VGND VPWR VPWR sky130_fd_sc_hd__fill_2
X_6777_ _6777_/A VGND VGND VPWR VPWR _8432_/D sky130_fd_sc_hd__buf_2
XFILLER_10_349 VGND VGND VPWR VPWR sky130_fd_sc_hd__decap_3
X_3989_ _8395_/Q _8476_/Q _8557_/Q _8638_/Q _3906_/S _3910_/A VGND VGND VPWR VPWR
+ _3989_/X sky130_fd_sc_hd__mux4_2
X_8516_ _8597_/CLK _8516_/D load_slew710/X VGND VGND VPWR VPWR _8516_/Q sky130_fd_sc_hd__dfrtp_2
X_5728_ _7904_/Q _4691_/A _5742_/S VGND VGND VPWR VPWR _5729_/A sky130_fd_sc_hd__mux2_2
XFILLER_6_309 VGND VGND VPWR VPWR sky130_fd_sc_hd__decap_3
XFILLER_108_226 VGND VGND VPWR VPWR sky130_fd_sc_hd__decap_3
XTAP_TAPCELL_ROW_94_1608 VGND VPWR sky130_fd_sc_hd__tapvpwrvgnd_1
X_8447_ _8688_/CLK _8447_/D load_slew570/X VGND VGND VPWR VPWR _8447_/Q sky130_fd_sc_hd__dfrtp_2
X_5659_ _7872_/Q _4903_/A _5675_/S VGND VGND VPWR VPWR _5660_/A sky130_fd_sc_hd__mux2_2
XFILLER_117_782 VGND VGND VPWR VPWR sky130_fd_sc_hd__fill_2
X_8378_ _8783_/CLK _8378_/D load_slew682/X VGND VGND VPWR VPWR _8378_/Q sky130_fd_sc_hd__dfrtp_2
XFILLER_104_421 VGND VGND VPWR VPWR sky130_fd_sc_hd__decap_3
XFILLER_116_270 VGND VGND VPWR VPWR sky130_fd_sc_hd__fill_2
XFILLER_116_292 VGND VGND VPWR VPWR sky130_fd_sc_hd__decap_3
XFILLER_7_6 VGND VGND VPWR VPWR sky130_fd_sc_hd__decap_3
X_7329_ _7329_/A VGND VGND VPWR VPWR _8723_/D sky130_fd_sc_hd__buf_1
XFILLER_104_465 VGND VGND VPWR VPWR sky130_fd_sc_hd__decap_3
XFILLER_131_240 VGND VGND VPWR VPWR sky130_fd_sc_hd__decap_3
XFILLER_132_752 VGND VGND VPWR VPWR sky130_fd_sc_hd__decap_3
XFILLER_132_763 VGND VGND VPWR VPWR sky130_fd_sc_hd__decap_3
XFILLER_131_284 VGND VGND VPWR VPWR sky130_fd_sc_hd__decap_3
XFILLER_132_796 VGND VGND VPWR VPWR sky130_fd_sc_hd__decap_3
XTAP_TAPCELL_ROW_5_364 VGND VPWR sky130_fd_sc_hd__tapvpwrvgnd_1
XFILLER_133_42 VGND VGND VPWR VPWR sky130_fd_sc_hd__decap_3
XFILLER_133_75 VGND VGND VPWR VPWR sky130_fd_sc_hd__decap_3
XFILLER_46_725 VGND VGND VPWR VPWR sky130_fd_sc_hd__decap_3
XFILLER_58_585 VGND VGND VPWR VPWR sky130_fd_sc_hd__decap_3
Xclkbuf_leaf_100_CLK clkload8/A VGND VGND VPWR VPWR _8783_/CLK sky130_fd_sc_hd__clkbuf_8
Xhold1050 _7515_/Q VGND VGND VPWR VPWR _4766_/A1 sky130_fd_sc_hd__dlygate4sd3_1
XFILLER_18_427 VGND VGND VPWR VPWR sky130_fd_sc_hd__fill_1
XFILLER_46_769 VGND VGND VPWR VPWR sky130_fd_sc_hd__fill_1
XFILLER_93_57 VGND VGND VPWR VPWR sky130_fd_sc_hd__decap_3
Xhold1061 _7815_/Q VGND VGND VPWR VPWR _5539_/A0 sky130_fd_sc_hd__dlygate4sd3_1
XFILLER_45_268 VGND VGND VPWR VPWR sky130_fd_sc_hd__decap_3
XFILLER_61_706 VGND VGND VPWR VPWR sky130_fd_sc_hd__decap_3
XTAP_TAPCELL_ROW_44_904 VGND VPWR sky130_fd_sc_hd__tapvpwrvgnd_1
XTAP_TAPCELL_ROW_44_915 VGND VPWR sky130_fd_sc_hd__tapvpwrvgnd_1
XFILLER_26_62 VGND VGND VPWR VPWR sky130_fd_sc_hd__decap_3
XTAP_TAPCELL_ROW_103_1737 VGND VPWR sky130_fd_sc_hd__tapvpwrvgnd_1
XFILLER_41_463 VGND VGND VPWR VPWR sky130_fd_sc_hd__decap_3
XFILLER_9_169 VGND VGND VPWR VPWR sky130_fd_sc_hd__decap_3
XFILLER_5_331 VGND VGND VPWR VPWR sky130_fd_sc_hd__decap_3
XFILLER_127_579 VGND VGND VPWR VPWR sky130_fd_sc_hd__decap_3
XFILLER_5_364 VGND VGND VPWR VPWR sky130_fd_sc_hd__fill_2
XFILLER_5_375 VGND VGND VPWR VPWR sky130_fd_sc_hd__decap_3
XPHY_EDGE_ROW_39_Left_175 VGND VGND VPWR VPWR sky130_fd_sc_hd__decap_3
XFILLER_123_741 VGND VGND VPWR VPWR sky130_fd_sc_hd__decap_3
XFILLER_123_774 VGND VGND VPWR VPWR sky130_fd_sc_hd__decap_3
XTAP_TAPCELL_ROW_114_1888 VGND VPWR sky130_fd_sc_hd__tapvpwrvgnd_1
XFILLER_123_785 VGND VGND VPWR VPWR sky130_fd_sc_hd__decap_3
XFILLER_3_33 VGND VGND VPWR VPWR sky130_fd_sc_hd__decap_3
XFILLER_1_592 VGND VGND VPWR VPWR sky130_fd_sc_hd__decap_3
XFILLER_3_66 VGND VGND VPWR VPWR sky130_fd_sc_hd__decap_3
XFILLER_37_725 VGND VGND VPWR VPWR sky130_fd_sc_hd__decap_3
XFILLER_3_99 VGND VGND VPWR VPWR sky130_fd_sc_hd__decap_3
XFILLER_37_747 VGND VGND VPWR VPWR sky130_fd_sc_hd__decap_3
XFILLER_64_533 VGND VGND VPWR VPWR sky130_fd_sc_hd__decap_3
XFILLER_64_544 VGND VGND VPWR VPWR sky130_fd_sc_hd__decap_3
XPHY_EDGE_ROW_48_Left_184 VGND VGND VPWR VPWR sky130_fd_sc_hd__decap_3
XTAP_TAPCELL_ROW_65_1209 VGND VPWR sky130_fd_sc_hd__tapvpwrvgnd_1
XFILLER_17_482 VGND VGND VPWR VPWR sky130_fd_sc_hd__decap_3
XFILLER_91_396 VGND VGND VPWR VPWR sky130_fd_sc_hd__decap_3
X_4961_ _4961_/A VGND VGND VPWR VPWR _4961_/X sky130_fd_sc_hd__buf_1
X_3912_ _8713_/Q _8794_/Q _7569_/Q _7650_/Q _3906_/S _3910_/A VGND VGND VPWR VPWR
+ _3912_/X sky130_fd_sc_hd__mux4_2
X_7680_ _8743_/CLK _7680_/D load_slew521/X VGND VGND VPWR VPWR _7680_/Q sky130_fd_sc_hd__dfrtp_2
X_6700_ _8396_/Q _5022_/A _6702_/S VGND VGND VPWR VPWR _6701_/A sky130_fd_sc_hd__mux2_2
X_4892_ _4891_/X _7545_/Q _4896_/S VGND VGND VPWR VPWR _4893_/A sky130_fd_sc_hd__mux2_2
XFILLER_20_625 VGND VGND VPWR VPWR sky130_fd_sc_hd__decap_3
XFILLER_32_463 VGND VGND VPWR VPWR sky130_fd_sc_hd__fill_2
X_3843_ _7969_/Q _4629_/B _3842_/X _3849_/S1 _3831_/A VGND VGND VPWR VPWR _3843_/X
+ sky130_fd_sc_hd__o221a_2
X_6631_ _4891_/X _8365_/Q _6633_/S VGND VGND VPWR VPWR _6632_/A sky130_fd_sc_hd__mux2_2
XFILLER_118_513 VGND VGND VPWR VPWR sky130_fd_sc_hd__fill_1
X_3774_ _3939_/A VGND VGND VPWR VPWR _3774_/X sky130_fd_sc_hd__clkbuf_2
X_8301_ _8623_/CLK _8301_/D fanout675/X VGND VGND VPWR VPWR _8301_/Q sky130_fd_sc_hd__dfrtp_2
X_6562_ _4753_/X _8332_/Q _6570_/S VGND VGND VPWR VPWR _6563_/A sky130_fd_sc_hd__mux2_2
X_6493_ _4957_/X _8299_/Q _6507_/S VGND VGND VPWR VPWR _6494_/A sky130_fd_sc_hd__mux2_2
X_5513_ _5513_/A VGND VGND VPWR VPWR _7802_/D sky130_fd_sc_hd__buf_1
XFILLER_133_505 VGND VGND VPWR VPWR sky130_fd_sc_hd__decap_3
XPHY_EDGE_ROW_57_Left_193 VGND VGND VPWR VPWR sky130_fd_sc_hd__decap_3
X_8232_ _8638_/CLK _8232_/D fanout595/A VGND VGND VPWR VPWR _8232_/Q sky130_fd_sc_hd__dfrtp_2
X_5444_ _5444_/A VGND VGND VPWR VPWR _7770_/D sky130_fd_sc_hd__buf_1
XFILLER_133_538 VGND VGND VPWR VPWR sky130_fd_sc_hd__decap_3
X_8163_ _8658_/CLK _8163_/D wire531/X VGND VGND VPWR VPWR _8163_/Q sky130_fd_sc_hd__dfrtp_2
XFILLER_87_603 VGND VGND VPWR VPWR sky130_fd_sc_hd__decap_3
XFILLER_99_452 VGND VGND VPWR VPWR sky130_fd_sc_hd__decap_3
X_7114_ _4819_/X _8591_/Q _7130_/S VGND VGND VPWR VPWR _7115_/A sky130_fd_sc_hd__mux2_2
X_5375_ _7738_/Q _5022_/A _5377_/S VGND VGND VPWR VPWR _5376_/A sky130_fd_sc_hd__mux2_2
XFILLER_101_424 VGND VGND VPWR VPWR sky130_fd_sc_hd__fill_1
XFILLER_99_485 VGND VGND VPWR VPWR sky130_fd_sc_hd__decap_3
X_8094_ _8662_/CLK _8094_/D load_slew621/X VGND VGND VPWR VPWR _8094_/Q sky130_fd_sc_hd__dfrtp_2
X_4326_ _8670_/Q _4326_/B VGND VGND VPWR VPWR _4326_/X sky130_fd_sc_hd__or2_2
XFILLER_113_284 VGND VGND VPWR VPWR sky130_fd_sc_hd__decap_3
XFILLER_59_349 VGND VGND VPWR VPWR sky130_fd_sc_hd__decap_3
X_7045_ _7045_/A VGND VGND VPWR VPWR _8558_/D sky130_fd_sc_hd__buf_2
X_4257_ _8664_/Q _3939_/X _3916_/B _8583_/Q _4252_/A VGND VGND VPWR VPWR _4257_/X
+ sky130_fd_sc_hd__o221a_2
XFILLER_74_319 VGND VGND VPWR VPWR sky130_fd_sc_hd__decap_3
XFILLER_86_168 VGND VGND VPWR VPWR sky130_fd_sc_hd__decap_3
XTAP_TAPCELL_ROW_2_323 VGND VPWR sky130_fd_sc_hd__tapvpwrvgnd_1
X_4188_ _8738_/Q _7513_/Q _7594_/Q _7675_/Q _4183_/S _4198_/A VGND VGND VPWR VPWR
+ _4189_/B sky130_fd_sc_hd__mux4_2
XFILLER_103_12 VGND VGND VPWR VPWR sky130_fd_sc_hd__fill_1
XFILLER_15_408 VGND VGND VPWR VPWR sky130_fd_sc_hd__fill_2
XFILLER_27_257 VGND VGND VPWR VPWR sky130_fd_sc_hd__decap_3
XFILLER_82_363 VGND VGND VPWR VPWR sky130_fd_sc_hd__fill_1
XFILLER_103_78 VGND VGND VPWR VPWR sky130_fd_sc_hd__decap_3
X_7947_ _8608_/CLK _7947_/D wire552/X VGND VGND VPWR VPWR _7947_/Q sky130_fd_sc_hd__dfrtp_2
XFILLER_35_290 VGND VGND VPWR VPWR sky130_fd_sc_hd__fill_1
X_7878_ _8779_/CLK _7878_/D wire746/X VGND VGND VPWR VPWR _7878_/Q sky130_fd_sc_hd__dfrtp_2
XFILLER_50_260 VGND VGND VPWR VPWR sky130_fd_sc_hd__decap_3
X_6829_ _6829_/A VGND VGND VPWR VPWR _8457_/D sky130_fd_sc_hd__buf_2
XFILLER_7_629 VGND VGND VPWR VPWR sky130_fd_sc_hd__decap_3
XFILLER_12_53 VGND VGND VPWR VPWR sky130_fd_sc_hd__decap_3
XFILLER_128_53 VGND VGND VPWR VPWR sky130_fd_sc_hd__decap_3
XFILLER_3_802 VGND VGND VPWR VPWR sky130_fd_sc_hd__fill_2
XTAP_TAPCELL_ROW_131_2122 VGND VPWR sky130_fd_sc_hd__tapvpwrvgnd_1
XTAP_TAPCELL_ROW_131_2133 VGND VPWR sky130_fd_sc_hd__tapvpwrvgnd_1
XFILLER_128_97 VGND VGND VPWR VPWR sky130_fd_sc_hd__decap_3
XFILLER_5_3 VGND VGND VPWR VPWR sky130_fd_sc_hd__decap_3
XFILLER_104_251 VGND VGND VPWR VPWR sky130_fd_sc_hd__fill_1
XFILLER_104_262 VGND VGND VPWR VPWR sky130_fd_sc_hd__decap_3
XFILLER_105_785 VGND VGND VPWR VPWR sky130_fd_sc_hd__decap_3
XFILLER_132_560 VGND VGND VPWR VPWR sky130_fd_sc_hd__decap_3
XFILLER_104_295 VGND VGND VPWR VPWR sky130_fd_sc_hd__decap_3
XFILLER_78_669 VGND VGND VPWR VPWR sky130_fd_sc_hd__decap_3
Xfanout660 fanout664/X VGND VGND VPWR VPWR fanout660/X sky130_fd_sc_hd__clkdlybuf4s25_1
XFILLER_93_617 VGND VGND VPWR VPWR sky130_fd_sc_hd__decap_3
XFILLER_46_533 VGND VGND VPWR VPWR sky130_fd_sc_hd__fill_2
XFILLER_86_691 VGND VGND VPWR VPWR sky130_fd_sc_hd__decap_3
XTAP_TAPCELL_ROW_129_2095 VGND VPWR sky130_fd_sc_hd__tapvpwrvgnd_1
XFILLER_37_94 VGND VGND VPWR VPWR sky130_fd_sc_hd__fill_2
XFILLER_46_566 VGND VGND VPWR VPWR sky130_fd_sc_hd__decap_3
XFILLER_61_503 VGND VGND VPWR VPWR sky130_fd_sc_hd__fill_1
XFILLER_73_352 VGND VGND VPWR VPWR sky130_fd_sc_hd__decap_3
XFILLER_34_739 VGND VGND VPWR VPWR sky130_fd_sc_hd__fill_1
XFILLER_73_396 VGND VGND VPWR VPWR sky130_fd_sc_hd__fill_1
XFILLER_14_430 VGND VGND VPWR VPWR sky130_fd_sc_hd__decap_3
XFILLER_41_271 VGND VGND VPWR VPWR sky130_fd_sc_hd__fill_1
XFILLER_41_293 VGND VGND VPWR VPWR sky130_fd_sc_hd__decap_3
XTAP_TAPCELL_ROW_60_1128 VGND VPWR sky130_fd_sc_hd__tapvpwrvgnd_1
XTAP_TAPCELL_ROW_60_1139 VGND VPWR sky130_fd_sc_hd__tapvpwrvgnd_1
XTAP_TAPCELL_ROW_116_1917 VGND VPWR sky130_fd_sc_hd__tapvpwrvgnd_1
XFILLER_115_505 VGND VGND VPWR VPWR sky130_fd_sc_hd__fill_1
XFILLER_127_365 VGND VGND VPWR VPWR sky130_fd_sc_hd__decap_3
XFILLER_6_640 VGND VGND VPWR VPWR sky130_fd_sc_hd__decap_3
XFILLER_6_651 VGND VGND VPWR VPWR sky130_fd_sc_hd__decap_3
XFILLER_115_527 VGND VGND VPWR VPWR sky130_fd_sc_hd__fill_2
XFILLER_6_684 VGND VGND VPWR VPWR sky130_fd_sc_hd__decap_3
XFILLER_123_582 VGND VGND VPWR VPWR sky130_fd_sc_hd__decap_3
XFILLER_130_519 VGND VGND VPWR VPWR sky130_fd_sc_hd__decap_3
X_5160_ _4941_/X _7638_/Q _5160_/S VGND VGND VPWR VPWR _5161_/A sky130_fd_sc_hd__mux2_2
XFILLER_68_135 VGND VGND VPWR VPWR sky130_fd_sc_hd__decap_3
XFILLER_69_669 VGND VGND VPWR VPWR sky130_fd_sc_hd__decap_3
X_5091_ _4803_/X _5091_/A1 _5095_/S VGND VGND VPWR VPWR _5092_/A sky130_fd_sc_hd__mux2_2
X_4111_ _4109_/X _4110_/X _4525_/S VGND VGND VPWR VPWR _4111_/X sky130_fd_sc_hd__mux2_2
XFILLER_111_788 VGND VGND VPWR VPWR sky130_fd_sc_hd__decap_3
XFILLER_84_617 VGND VGND VPWR VPWR sky130_fd_sc_hd__decap_3
X_4042_ _3828_/X _4041_/X _4545_/B1 VGND VGND VPWR VPWR _4042_/X sky130_fd_sc_hd__o21a_2
XFILLER_84_639 VGND VGND VPWR VPWR sky130_fd_sc_hd__decap_3
XFILLER_37_544 VGND VGND VPWR VPWR sky130_fd_sc_hd__decap_3
XFILLER_64_341 VGND VGND VPWR VPWR sky130_fd_sc_hd__decap_3
XFILLER_52_514 VGND VGND VPWR VPWR sky130_fd_sc_hd__decap_3
X_8781_ _8781_/CLK _8781_/D fanout749/A VGND VGND VPWR VPWR _8781_/Q sky130_fd_sc_hd__dfrtp_2
X_7801_ _8621_/CLK _7801_/D load_slew682/X VGND VGND VPWR VPWR _7801_/Q sky130_fd_sc_hd__dfrtp_2
X_5993_ _8064_/Q input4/X _6011_/S VGND VGND VPWR VPWR _5994_/A sky130_fd_sc_hd__mux2_2
XFILLER_40_709 VGND VGND VPWR VPWR sky130_fd_sc_hd__fill_2
XFILLER_52_569 VGND VGND VPWR VPWR sky130_fd_sc_hd__decap_3
XFILLER_91_193 VGND VGND VPWR VPWR sky130_fd_sc_hd__decap_3
X_7732_ _8477_/CLK _7732_/D wire603/X VGND VGND VPWR VPWR _7732_/Q sky130_fd_sc_hd__dfrtp_2
X_4944_ input3/X _4944_/B VGND VGND VPWR VPWR _4945_/A sky130_fd_sc_hd__and2_2
XTAP_TAPCELL_ROW_35_778 VGND VPWR sky130_fd_sc_hd__tapvpwrvgnd_1
XTAP_TAPCELL_ROW_35_789 VGND VPWR sky130_fd_sc_hd__tapvpwrvgnd_1
XFILLER_20_433 VGND VGND VPWR VPWR sky130_fd_sc_hd__decap_3
XFILLER_60_580 VGND VGND VPWR VPWR sky130_fd_sc_hd__decap_3
X_7663_ _8730_/CLK _7663_/D fanout498/X VGND VGND VPWR VPWR _7663_/Q sky130_fd_sc_hd__dfrtp_2
X_4875_ _4875_/A VGND VGND VPWR VPWR _4875_/X sky130_fd_sc_hd__buf_1
X_3826_ _8301_/Q _4629_/B _4600_/A2 _8220_/Q _4335_/A VGND VGND VPWR VPWR _3826_/X
+ sky130_fd_sc_hd__o221a_2
X_7594_ _8739_/CLK _7594_/D fanout508/X VGND VGND VPWR VPWR _7594_/Q sky130_fd_sc_hd__dfrtp_2
X_6614_ _6656_/S VGND VGND VPWR VPWR _6633_/S sky130_fd_sc_hd__buf_6
XPHY_EDGE_ROW_65_Left_201 VGND VGND VPWR VPWR sky130_fd_sc_hd__decap_3
X_3757_ _4313_/A1 _3746_/X _3756_/X VGND VGND VPWR VPWR _3757_/X sky130_fd_sc_hd__o21a_2
X_6545_ _7063_/A0 _8324_/Q _6549_/S VGND VGND VPWR VPWR _6546_/A sky130_fd_sc_hd__mux2_2
XFILLER_118_365 VGND VGND VPWR VPWR sky130_fd_sc_hd__decap_3
XFILLER_133_302 VGND VGND VPWR VPWR sky130_fd_sc_hd__decap_3
XFILLER_133_335 VGND VGND VPWR VPWR sky130_fd_sc_hd__fill_1
X_8215_ _8547_/CLK _8215_/D fanout648/A VGND VGND VPWR VPWR _8215_/Q sky130_fd_sc_hd__dfrtp_2
X_6476_ _4925_/X _8292_/Q _6482_/S VGND VGND VPWR VPWR _6477_/A sky130_fd_sc_hd__mux2_2
XFILLER_133_346 VGND VGND VPWR VPWR sky130_fd_sc_hd__decap_3
X_5427_ _5427_/A VGND VGND VPWR VPWR _7762_/D sky130_fd_sc_hd__buf_1
XFILLER_114_571 VGND VGND VPWR VPWR sky130_fd_sc_hd__fill_1
XFILLER_121_519 VGND VGND VPWR VPWR sky130_fd_sc_hd__decap_3
XFILLER_133_379 VGND VGND VPWR VPWR sky130_fd_sc_hd__decap_3
XFILLER_58_27 VGND VGND VPWR VPWR sky130_fd_sc_hd__fill_1
XFILLER_99_271 VGND VGND VPWR VPWR sky130_fd_sc_hd__decap_3
X_8146_ _8802_/CLK _8146_/D load_slew579/X VGND VGND VPWR VPWR _8146_/Q sky130_fd_sc_hd__dfrtp_2
X_5358_ _5505_/S VGND VGND VPWR VPWR _5377_/S sky130_fd_sc_hd__buf_2
XFILLER_101_221 VGND VGND VPWR VPWR sky130_fd_sc_hd__decap_3
XFILLER_59_124 VGND VGND VPWR VPWR sky130_fd_sc_hd__decap_3
XFILLER_87_444 VGND VGND VPWR VPWR sky130_fd_sc_hd__decap_3
XFILLER_99_293 VGND VGND VPWR VPWR sky130_fd_sc_hd__decap_3
X_8077_ _8648_/CLK _8077_/D fanout488/X VGND VGND VPWR VPWR _8077_/Q sky130_fd_sc_hd__dfrtp_2
X_4309_ _8344_/Q _3774_/X _4645_/B1 _8263_/Q _3955_/A VGND VGND VPWR VPWR _4309_/X
+ sky130_fd_sc_hd__o221a_2
XFILLER_102_788 VGND VGND VPWR VPWR sky130_fd_sc_hd__fill_2
XFILLER_87_466 VGND VGND VPWR VPWR sky130_fd_sc_hd__fill_2
XPHY_EDGE_ROW_74_Left_210 VGND VGND VPWR VPWR sky130_fd_sc_hd__decap_3
X_7028_ _4989_/X _8550_/Q _7046_/S VGND VGND VPWR VPWR _7029_/A sky130_fd_sc_hd__mux2_2
X_5289_ _7698_/Q _4853_/X _5289_/S VGND VGND VPWR VPWR _5290_/A sky130_fd_sc_hd__mux2_2
XFILLER_28_533 VGND VGND VPWR VPWR sky130_fd_sc_hd__decap_3
XFILLER_74_116 VGND VGND VPWR VPWR sky130_fd_sc_hd__decap_3
XFILLER_114_88 VGND VGND VPWR VPWR sky130_fd_sc_hd__fill_2
XFILLER_130_21 VGND VGND VPWR VPWR sky130_fd_sc_hd__decap_3
XFILLER_15_205 VGND VGND VPWR VPWR sky130_fd_sc_hd__decap_3
XFILLER_28_577 VGND VGND VPWR VPWR sky130_fd_sc_hd__decap_3
XFILLER_43_503 VGND VGND VPWR VPWR sky130_fd_sc_hd__fill_1
XFILLER_83_694 VGND VGND VPWR VPWR sky130_fd_sc_hd__fill_1
XFILLER_130_32 VGND VGND VPWR VPWR sky130_fd_sc_hd__decap_3
XFILLER_43_558 VGND VGND VPWR VPWR sky130_fd_sc_hd__fill_2
XFILLER_55_396 VGND VGND VPWR VPWR sky130_fd_sc_hd__decap_3
XFILLER_130_65 VGND VGND VPWR VPWR sky130_fd_sc_hd__decap_3
XFILLER_90_47 VGND VGND VPWR VPWR sky130_fd_sc_hd__decap_3
XFILLER_128_118 VGND VGND VPWR VPWR sky130_fd_sc_hd__decap_3
XFILLER_23_41 VGND VGND VPWR VPWR sky130_fd_sc_hd__decap_3
XFILLER_23_63 VGND VGND VPWR VPWR sky130_fd_sc_hd__decap_3
XFILLER_7_415 VGND VGND VPWR VPWR sky130_fd_sc_hd__decap_3
Xwire302 wire302/A VGND VGND VPWR VPWR _4129_/A sky130_fd_sc_hd__clkbuf_4
XFILLER_109_321 VGND VGND VPWR VPWR sky130_fd_sc_hd__decap_3
XFILLER_125_803 VGND VGND VPWR VPWR sky130_fd_sc_hd__fill_1
XFILLER_109_376 VGND VGND VPWR VPWR sky130_fd_sc_hd__decap_3
XFILLER_3_610 VGND VGND VPWR VPWR sky130_fd_sc_hd__decap_3
XFILLER_124_346 VGND VGND VPWR VPWR sky130_fd_sc_hd__decap_3
XFILLER_124_368 VGND VGND VPWR VPWR sky130_fd_sc_hd__decap_3
XFILLER_3_632 VGND VGND VPWR VPWR sky130_fd_sc_hd__decap_3
XFILLER_3_665 VGND VGND VPWR VPWR sky130_fd_sc_hd__decap_3
XFILLER_3_676 VGND VGND VPWR VPWR sky130_fd_sc_hd__decap_3
XTAP_TAPCELL_ROW_111_1847 VGND VPWR sky130_fd_sc_hd__tapvpwrvgnd_1
XTAP_TAPCELL_ROW_57_1090 VGND VPWR sky130_fd_sc_hd__tapvpwrvgnd_1
XFILLER_24_9 VGND VGND VPWR VPWR sky130_fd_sc_hd__decap_3
XFILLER_48_60 VGND VGND VPWR VPWR sky130_fd_sc_hd__decap_3
XFILLER_66_617 VGND VGND VPWR VPWR sky130_fd_sc_hd__fill_2
XFILLER_66_628 VGND VGND VPWR VPWR sky130_fd_sc_hd__decap_3
XFILLER_78_477 VGND VGND VPWR VPWR sky130_fd_sc_hd__decap_3
XFILLER_93_403 VGND VGND VPWR VPWR sky130_fd_sc_hd__decap_3
XFILLER_65_116 VGND VGND VPWR VPWR sky130_fd_sc_hd__fill_2
Xfanout490 fanout492/X VGND VGND VPWR VPWR fanout490/X sky130_fd_sc_hd__clkdlybuf4s25_1
XFILLER_0_12 VGND VGND VPWR VPWR sky130_fd_sc_hd__decap_3
XFILLER_0_78 VGND VGND VPWR VPWR sky130_fd_sc_hd__decap_3
XFILLER_74_672 VGND VGND VPWR VPWR sky130_fd_sc_hd__decap_3
XFILLER_80_108 VGND VGND VPWR VPWR sky130_fd_sc_hd__fill_2
XFILLER_9_21 VGND VGND VPWR VPWR sky130_fd_sc_hd__decap_3
XFILLER_14_271 VGND VGND VPWR VPWR sky130_fd_sc_hd__decap_3
XFILLER_15_794 VGND VGND VPWR VPWR sky130_fd_sc_hd__fill_2
XFILLER_9_54 VGND VGND VPWR VPWR sky130_fd_sc_hd__fill_2
XTAP_TAPCELL_ROW_122_1998 VGND VPWR sky130_fd_sc_hd__tapvpwrvgnd_1
XTAP_TAPCELL_ROW_32_737 VGND VPWR sky130_fd_sc_hd__tapvpwrvgnd_1
XFILLER_9_87 VGND VGND VPWR VPWR sky130_fd_sc_hd__decap_3
X_4660_ _7636_/Q _4660_/A2 _4659_/X VGND VGND VPWR VPWR _4660_/X sky130_fd_sc_hd__o21a_2
XTAP_TAPCELL_ROW_12_461 VGND VPWR sky130_fd_sc_hd__tapvpwrvgnd_1
XFILLER_128_663 VGND VGND VPWR VPWR sky130_fd_sc_hd__decap_3
X_6330_ _6330_/A VGND VGND VPWR VPWR _8222_/D sky130_fd_sc_hd__buf_2
X_4591_ _4587_/X _4590_/X _4591_/S VGND VGND VPWR VPWR _4592_/A sky130_fd_sc_hd__mux2_2
XFILLER_127_162 VGND VGND VPWR VPWR sky130_fd_sc_hd__decap_3
XFILLER_127_184 VGND VGND VPWR VPWR sky130_fd_sc_hd__decap_3
XFILLER_128_696 VGND VGND VPWR VPWR sky130_fd_sc_hd__decap_3
XFILLER_6_470 VGND VGND VPWR VPWR sky130_fd_sc_hd__decap_3
Xhold905 _7996_/Q VGND VGND VPWR VPWR hold905/X sky130_fd_sc_hd__dlygate4sd3_1
Xhold916 _7978_/Q VGND VGND VPWR VPWR hold916/X sky130_fd_sc_hd__dlygate4sd3_1
Xhold927 _8554_/Q VGND VGND VPWR VPWR hold927/X sky130_fd_sc_hd__dlygate4sd3_1
XFILLER_115_335 VGND VGND VPWR VPWR sky130_fd_sc_hd__fill_1
XTAP_TAPCELL_ROW_73_1308 VGND VPWR sky130_fd_sc_hd__tapvpwrvgnd_1
XTAP_TAPCELL_ROW_73_1319 VGND VPWR sky130_fd_sc_hd__tapvpwrvgnd_1
Xhold938 _8264_/Q VGND VGND VPWR VPWR hold938/X sky130_fd_sc_hd__dlygate4sd3_1
Xhold949 _8579_/Q VGND VGND VPWR VPWR hold949/X sky130_fd_sc_hd__dlygate4sd3_1
X_6261_ _6261_/A VGND VGND VPWR VPWR _8190_/D sky130_fd_sc_hd__buf_6
XFILLER_130_305 VGND VGND VPWR VPWR sky130_fd_sc_hd__decap_3
X_8000_ _8657_/CLK _8000_/D fanout512/X VGND VGND VPWR VPWR _8000_/Q sky130_fd_sc_hd__dfrtp_2
X_6192_ _6192_/A VGND VGND VPWR VPWR _8157_/D sky130_fd_sc_hd__buf_6
X_5212_ _7661_/Q _4691_/X _5226_/S VGND VGND VPWR VPWR _5213_/A sky130_fd_sc_hd__mux2_2
XFILLER_130_338 VGND VGND VPWR VPWR sky130_fd_sc_hd__decap_3
XFILLER_69_422 VGND VGND VPWR VPWR sky130_fd_sc_hd__fill_2
XFILLER_97_753 VGND VGND VPWR VPWR sky130_fd_sc_hd__decap_3
X_5143_ _5143_/A VGND VGND VPWR VPWR _7629_/D sky130_fd_sc_hd__buf_1
XFILLER_111_552 VGND VGND VPWR VPWR sky130_fd_sc_hd__decap_3
XFILLER_29_308 VGND VGND VPWR VPWR sky130_fd_sc_hd__decap_3
XFILLER_57_617 VGND VGND VPWR VPWR sky130_fd_sc_hd__fill_1
XFILLER_69_455 VGND VGND VPWR VPWR sky130_fd_sc_hd__fill_1
XFILLER_69_488 VGND VGND VPWR VPWR sky130_fd_sc_hd__fill_2
XFILLER_84_414 VGND VGND VPWR VPWR sky130_fd_sc_hd__decap_3
XFILLER_96_296 VGND VGND VPWR VPWR sky130_fd_sc_hd__decap_3
X_5074_ _4769_/X _7597_/Q _5074_/S VGND VGND VPWR VPWR _5075_/A sky130_fd_sc_hd__mux2_2
X_4025_ _8399_/Q _8480_/Q _8561_/Q _8642_/Q _4090_/S0 _4091_/S1 VGND VGND VPWR VPWR
+ _4025_/X sky130_fd_sc_hd__mux4_2
XFILLER_44_29 VGND VGND VPWR VPWR sky130_fd_sc_hd__fill_1
XFILLER_92_480 VGND VGND VPWR VPWR sky130_fd_sc_hd__fill_2
XFILLER_92_491 VGND VGND VPWR VPWR sky130_fd_sc_hd__decap_3
XFILLER_52_377 VGND VGND VPWR VPWR sky130_fd_sc_hd__fill_1
X_8764_ _8764_/CLK _8764_/D fanout566/X VGND VGND VPWR VPWR _8764_/Q sky130_fd_sc_hd__dfrtp_2
X_5976_ _8056_/Q _4956_/A _5990_/S VGND VGND VPWR VPWR _5977_/A sky130_fd_sc_hd__mux2_2
XFILLER_100_35 VGND VGND VPWR VPWR sky130_fd_sc_hd__decap_3
XFILLER_52_399 VGND VGND VPWR VPWR sky130_fd_sc_hd__fill_2
X_8695_ _8695_/CLK _8695_/D load_slew733/X VGND VGND VPWR VPWR _8695_/Q sky130_fd_sc_hd__dfrtp_2
X_7715_ _8697_/CLK _7715_/D fanout723/X VGND VGND VPWR VPWR _7715_/Q sky130_fd_sc_hd__dfrtp_2
X_4927_ _4927_/A VGND VGND VPWR VPWR _7553_/D sky130_fd_sc_hd__buf_1
XFILLER_100_79 VGND VGND VPWR VPWR sky130_fd_sc_hd__decap_3
X_7646_ _8709_/CLK _7646_/D fanout672/X VGND VGND VPWR VPWR _7646_/Q sky130_fd_sc_hd__dfrtp_2
X_4858_ _4857_/X _7537_/Q _4862_/S VGND VGND VPWR VPWR _4859_/A sky130_fd_sc_hd__mux2_2
X_3809_ _7561_/Q _4660_/A2 _3808_/X VGND VGND VPWR VPWR _3809_/X sky130_fd_sc_hd__o21a_2
XTAP_TAPCELL_ROW_99_1680 VGND VPWR sky130_fd_sc_hd__tapvpwrvgnd_1
X_7577_ _8802_/CLK _7577_/D load_slew579/X VGND VGND VPWR VPWR _7577_/Q sky130_fd_sc_hd__dfrtp_2
X_4789_ _4789_/A VGND VGND VPWR VPWR _7520_/D sky130_fd_sc_hd__buf_1
XFILLER_118_162 VGND VGND VPWR VPWR sky130_fd_sc_hd__decap_3
XFILLER_119_685 VGND VGND VPWR VPWR sky130_fd_sc_hd__fill_1
Xclkbuf_leaf_80_CLK clkload10/A VGND VGND VPWR VPWR _8775_/CLK sky130_fd_sc_hd__clkbuf_8
X_6528_ _5027_/X _8316_/Q _6528_/S VGND VGND VPWR VPWR _6529_/A sky130_fd_sc_hd__mux2_2
XFILLER_133_143 VGND VGND VPWR VPWR sky130_fd_sc_hd__decap_3
XFILLER_134_666 VGND VGND VPWR VPWR sky130_fd_sc_hd__decap_3
XFILLER_69_26 VGND VGND VPWR VPWR sky130_fd_sc_hd__decap_3
XFILLER_69_48 VGND VGND VPWR VPWR sky130_fd_sc_hd__fill_2
X_6459_ _4891_/X _8284_/Q _6461_/S VGND VGND VPWR VPWR _6460_/A sky130_fd_sc_hd__mux2_2
XFILLER_0_613 VGND VGND VPWR VPWR sky130_fd_sc_hd__decap_3
XFILLER_106_368 VGND VGND VPWR VPWR sky130_fd_sc_hd__decap_3
XFILLER_134_699 VGND VGND VPWR VPWR sky130_fd_sc_hd__fill_1
XFILLER_79_219 VGND VGND VPWR VPWR sky130_fd_sc_hd__decap_3
XFILLER_114_390 VGND VGND VPWR VPWR sky130_fd_sc_hd__fill_2
XFILLER_125_21 VGND VGND VPWR VPWR sky130_fd_sc_hd__decap_3
XFILLER_133_187 VGND VGND VPWR VPWR sky130_fd_sc_hd__decap_3
XFILLER_88_731 VGND VGND VPWR VPWR sky130_fd_sc_hd__decap_3
XFILLER_88_742 VGND VGND VPWR VPWR sky130_fd_sc_hd__decap_3
X_8129_ _8777_/CLK _8129_/D load_slew750/X VGND VGND VPWR VPWR _8129_/Q sky130_fd_sc_hd__dfrtp_2
XFILLER_0_657 VGND VGND VPWR VPWR sky130_fd_sc_hd__decap_3
XFILLER_0_679 VGND VGND VPWR VPWR sky130_fd_sc_hd__decap_3
XFILLER_125_54 VGND VGND VPWR VPWR sky130_fd_sc_hd__fill_2
XFILLER_87_252 VGND VGND VPWR VPWR sky130_fd_sc_hd__fill_2
XFILLER_125_87 VGND VGND VPWR VPWR sky130_fd_sc_hd__decap_3
XFILLER_47_116 VGND VGND VPWR VPWR sky130_fd_sc_hd__decap_3
XFILLER_85_36 VGND VGND VPWR VPWR sky130_fd_sc_hd__decap_3
XFILLER_87_296 VGND VGND VPWR VPWR sky130_fd_sc_hd__fill_1
XFILLER_18_41 VGND VGND VPWR VPWR sky130_fd_sc_hd__decap_3
XTAP_TAPCELL_ROW_126_2054 VGND VPWR sky130_fd_sc_hd__tapvpwrvgnd_1
XFILLER_16_514 VGND VGND VPWR VPWR sky130_fd_sc_hd__decap_3
XFILLER_18_74 VGND VGND VPWR VPWR sky130_fd_sc_hd__decap_3
XFILLER_18_85 VGND VGND VPWR VPWR sky130_fd_sc_hd__fill_2
XFILLER_55_160 VGND VGND VPWR VPWR sky130_fd_sc_hd__decap_3
XFILLER_43_344 VGND VGND VPWR VPWR sky130_fd_sc_hd__fill_2
XFILLER_31_517 VGND VGND VPWR VPWR sky130_fd_sc_hd__decap_3
XFILLER_43_355 VGND VGND VPWR VPWR sky130_fd_sc_hd__decap_3
XFILLER_43_377 VGND VGND VPWR VPWR sky130_fd_sc_hd__decap_3
XFILLER_129_405 VGND VGND VPWR VPWR sky130_fd_sc_hd__decap_3
XFILLER_12_753 VGND VGND VPWR VPWR sky130_fd_sc_hd__decap_3
XFILLER_34_95 VGND VGND VPWR VPWR sky130_fd_sc_hd__decap_3
XFILLER_8_713 VGND VGND VPWR VPWR sky130_fd_sc_hd__decap_3
XFILLER_129_438 VGND VGND VPWR VPWR sky130_fd_sc_hd__decap_3
XFILLER_129_449 VGND VGND VPWR VPWR sky130_fd_sc_hd__decap_3
XFILLER_12_775 VGND VGND VPWR VPWR sky130_fd_sc_hd__decap_3
XFILLER_8_746 VGND VGND VPWR VPWR sky130_fd_sc_hd__decap_3
XFILLER_8_757 VGND VGND VPWR VPWR sky130_fd_sc_hd__decap_3
XFILLER_125_600 VGND VGND VPWR VPWR sky130_fd_sc_hd__decap_3
XFILLER_50_83 VGND VGND VPWR VPWR sky130_fd_sc_hd__fill_1
XFILLER_50_94 VGND VGND VPWR VPWR sky130_fd_sc_hd__decap_3
Xclkbuf_leaf_71_CLK clkload11/A VGND VGND VPWR VPWR _8781_/CLK sky130_fd_sc_hd__clkbuf_8
XFILLER_125_699 VGND VGND VPWR VPWR sky130_fd_sc_hd__fill_1
XFILLER_98_539 VGND VGND VPWR VPWR sky130_fd_sc_hd__decap_3
XFILLER_112_327 VGND VGND VPWR VPWR sky130_fd_sc_hd__decap_3
XFILLER_112_338 VGND VGND VPWR VPWR sky130_fd_sc_hd__decap_3
XFILLER_3_495 VGND VGND VPWR VPWR sky130_fd_sc_hd__fill_1
XFILLER_39_606 VGND VGND VPWR VPWR sky130_fd_sc_hd__decap_3
XFILLER_78_296 VGND VGND VPWR VPWR sky130_fd_sc_hd__decap_3
XFILLER_120_393 VGND VGND VPWR VPWR sky130_fd_sc_hd__decap_3
XFILLER_93_255 VGND VGND VPWR VPWR sky130_fd_sc_hd__decap_3
XTAP_TAPCELL_ROW_37_807 VGND VPWR sky130_fd_sc_hd__tapvpwrvgnd_1
XFILLER_93_277 VGND VGND VPWR VPWR sky130_fd_sc_hd__decap_3
XFILLER_62_642 VGND VGND VPWR VPWR sky130_fd_sc_hd__fill_2
XFILLER_74_480 VGND VGND VPWR VPWR sky130_fd_sc_hd__fill_2
XFILLER_34_377 VGND VGND VPWR VPWR sky130_fd_sc_hd__decap_3
XFILLER_62_664 VGND VGND VPWR VPWR sky130_fd_sc_hd__decap_3
XTAP_TAPCELL_ROW_17_531 VGND VPWR sky130_fd_sc_hd__tapvpwrvgnd_1
X_5830_ _5830_/A VGND VGND VPWR VPWR _7952_/D sky130_fd_sc_hd__buf_1
XFILLER_61_185 VGND VGND VPWR VPWR sky130_fd_sc_hd__decap_3
X_5761_ _7920_/Q _4765_/A _5763_/S VGND VGND VPWR VPWR _5762_/A sky130_fd_sc_hd__mux2_2
XFILLER_15_591 VGND VGND VPWR VPWR sky130_fd_sc_hd__decap_3
X_8480_ _8804_/CLK _8480_/D fanout492/X VGND VGND VPWR VPWR _8480_/Q sky130_fd_sc_hd__dfrtp_2
X_7500_ _8725_/CLK _7500_/D load_slew491/X VGND VGND VPWR VPWR _7500_/Q sky130_fd_sc_hd__dfrtp_2
X_4712_ _4711_/X _7502_/Q _4736_/S VGND VGND VPWR VPWR _4713_/A sky130_fd_sc_hd__mux2_2
XFILLER_30_572 VGND VGND VPWR VPWR sky130_fd_sc_hd__decap_3
X_7431_ _8772_/Q _4898_/A _7449_/S VGND VGND VPWR VPWR _7432_/A sky130_fd_sc_hd__mux2_2
X_5692_ _7887_/Q _4969_/A _5700_/S VGND VGND VPWR VPWR _5693_/A sky130_fd_sc_hd__mux2_2
X_4643_ _8698_/Q _3969_/X _4642_/X VGND VGND VPWR VPWR _4643_/X sky130_fd_sc_hd__o21a_2
XFILLER_128_460 VGND VGND VPWR VPWR sky130_fd_sc_hd__decap_3
Xclkbuf_leaf_62_CLK clkbuf_leaf_63_CLK/A VGND VGND VPWR VPWR _8759_/CLK sky130_fd_sc_hd__clkbuf_8
X_7362_ _7362_/A VGND VGND VPWR VPWR _8739_/D sky130_fd_sc_hd__buf_1
X_4574_ _7629_/Q _4642_/A2 _4573_/X _4621_/A _4665_/C1 VGND VGND VPWR VPWR _4574_/X
+ sky130_fd_sc_hd__o221a_2
XFILLER_116_633 VGND VGND VPWR VPWR sky130_fd_sc_hd__decap_3
X_7293_ _7293_/A VGND VGND VPWR VPWR _8706_/D sky130_fd_sc_hd__buf_1
X_6313_ _6313_/A VGND VGND VPWR VPWR _8215_/D sky130_fd_sc_hd__buf_1
XFILLER_115_165 VGND VGND VPWR VPWR sky130_fd_sc_hd__decap_3
XFILLER_116_699 VGND VGND VPWR VPWR sky130_fd_sc_hd__fill_1
XFILLER_131_603 VGND VGND VPWR VPWR sky130_fd_sc_hd__decap_3
XPHY_EDGE_ROW_123_Right_123 VGND VGND VPWR VPWR sky130_fd_sc_hd__decap_3
Xhold757 _7980_/Q VGND VGND VPWR VPWR hold757/X sky130_fd_sc_hd__dlygate4sd3_1
Xhold768 _8685_/Q VGND VGND VPWR VPWR hold768/X sky130_fd_sc_hd__dlygate4sd3_1
Xhold779 _8649_/Q VGND VGND VPWR VPWR hold779/X sky130_fd_sc_hd__dlygate4sd3_1
X_6244_ _6244_/A VGND VGND VPWR VPWR _8182_/D sky130_fd_sc_hd__buf_6
XFILLER_130_124 VGND VGND VPWR VPWR sky130_fd_sc_hd__decap_3
XFILLER_131_647 VGND VGND VPWR VPWR sky130_fd_sc_hd__decap_3
XFILLER_130_168 VGND VGND VPWR VPWR sky130_fd_sc_hd__decap_3
XFILLER_97_561 VGND VGND VPWR VPWR sky130_fd_sc_hd__decap_3
X_6175_ _6175_/A VGND VGND VPWR VPWR _8149_/D sky130_fd_sc_hd__buf_6
Xload_slew682 fanout681/X VGND VGND VPWR VPWR load_slew682/X sky130_fd_sc_hd__buf_4
Xload_slew671 fanout670/X VGND VGND VPWR VPWR load_slew671/X sky130_fd_sc_hd__buf_4
X_5126_ _5126_/A VGND VGND VPWR VPWR _7621_/D sky130_fd_sc_hd__buf_1
XFILLER_111_393 VGND VGND VPWR VPWR sky130_fd_sc_hd__decap_3
XFILLER_57_469 VGND VGND VPWR VPWR sky130_fd_sc_hd__fill_2
XFILLER_84_244 VGND VGND VPWR VPWR sky130_fd_sc_hd__decap_3
X_5057_ _5057_/A VGND VGND VPWR VPWR _7588_/D sky130_fd_sc_hd__buf_1
XFILLER_38_683 VGND VGND VPWR VPWR sky130_fd_sc_hd__decap_3
XFILLER_72_406 VGND VGND VPWR VPWR sky130_fd_sc_hd__fill_2
X_4008_ _7982_/Q _4326_/B _4007_/X _4013_/A1 _3988_/A VGND VGND VPWR VPWR _4008_/X
+ sky130_fd_sc_hd__o221a_2
XFILLER_53_642 VGND VGND VPWR VPWR sky130_fd_sc_hd__decap_3
XFILLER_111_34 VGND VGND VPWR VPWR sky130_fd_sc_hd__fill_1
XFILLER_13_517 VGND VGND VPWR VPWR sky130_fd_sc_hd__decap_3
XFILLER_25_355 VGND VGND VPWR VPWR sky130_fd_sc_hd__fill_1
XFILLER_52_141 VGND VGND VPWR VPWR sky130_fd_sc_hd__fill_2
XFILLER_25_388 VGND VGND VPWR VPWR sky130_fd_sc_hd__decap_3
XFILLER_71_38 VGND VGND VPWR VPWR sky130_fd_sc_hd__decap_3
X_8747_ _8747_/CLK _8747_/D fanout652/X VGND VGND VPWR VPWR _8747_/Q sky130_fd_sc_hd__dfrtp_2
X_5959_ _7267_/A VGND VGND VPWR VPWR _5959_/X sky130_fd_sc_hd__clkbuf_1
XFILLER_21_550 VGND VGND VPWR VPWR sky130_fd_sc_hd__fill_1
X_8678_ _8678_/CLK _8678_/D fanout694/X VGND VGND VPWR VPWR _8678_/Q sky130_fd_sc_hd__dfrtp_2
X_7629_ _8773_/CLK _7629_/D load_slew738/X VGND VGND VPWR VPWR _7629_/Q sky130_fd_sc_hd__dfrtp_2
XFILLER_4_215 VGND VGND VPWR VPWR sky130_fd_sc_hd__decap_3
XFILLER_5_727 VGND VGND VPWR VPWR sky130_fd_sc_hd__fill_1
XFILLER_5_738 VGND VGND VPWR VPWR sky130_fd_sc_hd__decap_3
Xclkbuf_leaf_53_CLK clkbuf_leaf_89_CLK/A VGND VGND VPWR VPWR _8712_/CLK sky130_fd_sc_hd__clkbuf_8
XFILLER_105_3 VGND VGND VPWR VPWR sky130_fd_sc_hd__fill_2
XFILLER_106_132 VGND VGND VPWR VPWR sky130_fd_sc_hd__decap_3
XFILLER_107_655 VGND VGND VPWR VPWR sky130_fd_sc_hd__decap_3
XFILLER_134_430 VGND VGND VPWR VPWR sky130_fd_sc_hd__decap_3
XFILLER_134_463 VGND VGND VPWR VPWR sky130_fd_sc_hd__fill_1
XFILLER_20_53 VGND VGND VPWR VPWR sky130_fd_sc_hd__decap_3
Xclkbuf_4_6_0_CLK clkbuf_0_CLK/X VGND VGND VPWR VPWR clkbuf_4_6_0_CLK/X sky130_fd_sc_hd__clkbuf_8
XFILLER_106_187 VGND VGND VPWR VPWR sky130_fd_sc_hd__decap_3
XFILLER_121_113 VGND VGND VPWR VPWR sky130_fd_sc_hd__decap_3
XFILLER_0_465 VGND VGND VPWR VPWR sky130_fd_sc_hd__decap_3
XFILLER_102_371 VGND VGND VPWR VPWR sky130_fd_sc_hd__fill_2
XFILLER_29_51 VGND VGND VPWR VPWR sky130_fd_sc_hd__decap_3
XFILLER_48_403 VGND VGND VPWR VPWR sky130_fd_sc_hd__fill_1
XFILLER_102_393 VGND VGND VPWR VPWR sky130_fd_sc_hd__decap_3
XFILLER_48_469 VGND VGND VPWR VPWR sky130_fd_sc_hd__decap_3
XFILLER_75_222 VGND VGND VPWR VPWR sky130_fd_sc_hd__fill_2
XFILLER_75_244 VGND VGND VPWR VPWR sky130_fd_sc_hd__fill_1
XFILLER_29_694 VGND VGND VPWR VPWR sky130_fd_sc_hd__decap_3
XFILLER_75_299 VGND VGND VPWR VPWR sky130_fd_sc_hd__decap_3
XFILLER_90_236 VGND VGND VPWR VPWR sky130_fd_sc_hd__decap_3
XPHY_EDGE_ROW_11_Left_147 VGND VGND VPWR VPWR sky130_fd_sc_hd__decap_3
XFILLER_43_141 VGND VGND VPWR VPWR sky130_fd_sc_hd__decap_3
XFILLER_44_653 VGND VGND VPWR VPWR sky130_fd_sc_hd__fill_1
XFILLER_45_50 VGND VGND VPWR VPWR sky130_fd_sc_hd__decap_3
XTAP_TAPCELL_ROW_106_1779 VGND VPWR sky130_fd_sc_hd__tapvpwrvgnd_1
XFILLER_16_388 VGND VGND VPWR VPWR sky130_fd_sc_hd__decap_3
XFILLER_31_325 VGND VGND VPWR VPWR sky130_fd_sc_hd__fill_2
XFILLER_45_94 VGND VGND VPWR VPWR sky130_fd_sc_hd__decap_3
XFILLER_71_494 VGND VGND VPWR VPWR sky130_fd_sc_hd__decap_3
XFILLER_129_202 VGND VGND VPWR VPWR sky130_fd_sc_hd__decap_3
XFILLER_12_572 VGND VGND VPWR VPWR sky130_fd_sc_hd__fill_1
XFILLER_61_60 VGND VGND VPWR VPWR sky130_fd_sc_hd__decap_3
XFILLER_8_510 VGND VGND VPWR VPWR sky130_fd_sc_hd__decap_3
XTAP_TAPCELL_ROW_42_876 VGND VPWR sky130_fd_sc_hd__tapvpwrvgnd_1
XTAP_TAPCELL_ROW_42_887 VGND VPWR sky130_fd_sc_hd__tapvpwrvgnd_1
XFILLER_129_246 VGND VGND VPWR VPWR sky130_fd_sc_hd__decap_3
XFILLER_8_554 VGND VGND VPWR VPWR sky130_fd_sc_hd__decap_3
XFILLER_129_279 VGND VGND VPWR VPWR sky130_fd_sc_hd__fill_1
XFILLER_8_598 VGND VGND VPWR VPWR sky130_fd_sc_hd__decap_3
Xclkbuf_leaf_44_CLK clkload5/A VGND VGND VPWR VPWR _8796_/CLK sky130_fd_sc_hd__clkbuf_8
XANTENNA_4 _4335_/A VGND VGND VPWR VPWR sky130_fd_sc_hd__diode_2
XFILLER_125_441 VGND VGND VPWR VPWR sky130_fd_sc_hd__decap_3
XFILLER_6_44 VGND VGND VPWR VPWR sky130_fd_sc_hd__decap_3
XPHY_EDGE_ROW_20_Left_156 VGND VGND VPWR VPWR sky130_fd_sc_hd__decap_3
XFILLER_125_452 VGND VGND VPWR VPWR sky130_fd_sc_hd__fill_1
XFILLER_125_474 VGND VGND VPWR VPWR sky130_fd_sc_hd__decap_3
XFILLER_4_760 VGND VGND VPWR VPWR sky130_fd_sc_hd__decap_3
XFILLER_6_77 VGND VGND VPWR VPWR sky130_fd_sc_hd__decap_3
XFILLER_6_88 VGND VGND VPWR VPWR sky130_fd_sc_hd__decap_3
XFILLER_98_303 VGND VGND VPWR VPWR sky130_fd_sc_hd__decap_3
XFILLER_112_102 VGND VGND VPWR VPWR sky130_fd_sc_hd__decap_3
XFILLER_4_793 VGND VGND VPWR VPWR sky130_fd_sc_hd__decap_3
X_4290_ _7766_/Q _7847_/Q _4314_/S VGND VGND VPWR VPWR _4290_/X sky130_fd_sc_hd__mux2_2
XFILLER_67_701 VGND VGND VPWR VPWR sky130_fd_sc_hd__decap_3
XFILLER_20_3 VGND VGND VPWR VPWR sky130_fd_sc_hd__decap_3
XFILLER_39_425 VGND VGND VPWR VPWR sky130_fd_sc_hd__fill_2
XFILLER_67_712 VGND VGND VPWR VPWR sky130_fd_sc_hd__decap_3
XFILLER_66_233 VGND VGND VPWR VPWR sky130_fd_sc_hd__decap_3
XFILLER_67_778 VGND VGND VPWR VPWR sky130_fd_sc_hd__decap_3
XFILLER_54_417 VGND VGND VPWR VPWR sky130_fd_sc_hd__decap_3
XFILLER_66_288 VGND VGND VPWR VPWR sky130_fd_sc_hd__decap_3
XFILLER_82_704 VGND VGND VPWR VPWR sky130_fd_sc_hd__decap_3
X_7980_ _8470_/CLK _7980_/D fanout590/X VGND VGND VPWR VPWR _7980_/Q sky130_fd_sc_hd__dfrtp_2
XFILLER_81_225 VGND VGND VPWR VPWR sky130_fd_sc_hd__decap_3
X_6931_ _4799_/X _8505_/Q _6937_/S VGND VGND VPWR VPWR _6932_/A sky130_fd_sc_hd__mux2_4
XFILLER_19_193 VGND VGND VPWR VPWR sky130_fd_sc_hd__fill_2
XFILLER_34_141 VGND VGND VPWR VPWR sky130_fd_sc_hd__decap_3
X_6862_ _5003_/X _8472_/Q _6874_/S VGND VGND VPWR VPWR _6863_/A sky130_fd_sc_hd__mux2_4
XFILLER_50_634 VGND VGND VPWR VPWR sky130_fd_sc_hd__fill_1
XFILLER_62_483 VGND VGND VPWR VPWR sky130_fd_sc_hd__decap_3
XTAP_TAPCELL_ROW_81_1429 VGND VPWR sky130_fd_sc_hd__tapvpwrvgnd_1
X_8601_ _8794_/CLK _8601_/D fanout580/X VGND VGND VPWR VPWR _8601_/Q sky130_fd_sc_hd__dfrtp_2
X_5813_ _5813_/A VGND VGND VPWR VPWR _7944_/D sky130_fd_sc_hd__buf_1
XFILLER_22_358 VGND VGND VPWR VPWR sky130_fd_sc_hd__decap_3
XFILLER_50_645 VGND VGND VPWR VPWR sky130_fd_sc_hd__decap_3
X_8532_ _8775_/CLK _8532_/D fanout726/X VGND VGND VPWR VPWR _8532_/Q sky130_fd_sc_hd__dfrtp_2
X_6793_ _8440_/Q _4865_/A _6807_/S VGND VGND VPWR VPWR _6794_/A sky130_fd_sc_hd__mux2_2
X_5744_ _5849_/S VGND VGND VPWR VPWR _5763_/S sky130_fd_sc_hd__buf_2
X_8463_ _8623_/CLK _8463_/D load_slew676/X VGND VGND VPWR VPWR _8463_/Q sky130_fd_sc_hd__dfrtp_2
X_5675_ _7880_/Q _4937_/A _5675_/S VGND VGND VPWR VPWR _5676_/A sky130_fd_sc_hd__mux2_2
XFILLER_129_780 VGND VGND VPWR VPWR sky130_fd_sc_hd__decap_3
Xclkbuf_leaf_35_CLK clkbuf_leaf_35_CLK/A VGND VGND VPWR VPWR _8687_/CLK sky130_fd_sc_hd__clkbuf_8
X_8394_ _8637_/CLK _8394_/D wire603/X VGND VGND VPWR VPWR _8394_/Q sky130_fd_sc_hd__dfrtp_2
X_7414_ _8764_/Q _4865_/A _7428_/S VGND VGND VPWR VPWR _7415_/A sky130_fd_sc_hd__mux2_2
X_4626_ _7795_/Q _7876_/Q _7957_/Q _8038_/Q _4670_/S0 _4651_/A VGND VGND VPWR VPWR
+ _4626_/X sky130_fd_sc_hd__mux4_2
XFILLER_116_430 VGND VGND VPWR VPWR sky130_fd_sc_hd__decap_3
XFILLER_129_791 VGND VGND VPWR VPWR sky130_fd_sc_hd__decap_3
XFILLER_135_249 VGND VGND VPWR VPWR sky130_fd_sc_hd__decap_3
X_7345_ _7345_/A VGND VGND VPWR VPWR _8731_/D sky130_fd_sc_hd__buf_1
XFILLER_116_474 VGND VGND VPWR VPWR sky130_fd_sc_hd__fill_2
XFILLER_2_719 VGND VGND VPWR VPWR sky130_fd_sc_hd__decap_3
Xmax_cap262 _3744_/X VGND VGND VPWR VPWR _4600_/A2 sky130_fd_sc_hd__buf_6
Xmax_cap251 _3799_/X VGND VGND VPWR VPWR _4560_/A2 sky130_fd_sc_hd__buf_6
Xmax_cap240 _3976_/X VGND VGND VPWR VPWR _4617_/B1 sky130_fd_sc_hd__clkbuf_8
X_4557_ _4557_/A1 _4553_/X _4556_/X _4526_/S VGND VGND VPWR VPWR _4557_/X sky130_fd_sc_hd__a211o_2
XFILLER_103_113 VGND VGND VPWR VPWR sky130_fd_sc_hd__decap_3
XFILLER_131_433 VGND VGND VPWR VPWR sky130_fd_sc_hd__decap_3
Xmax_cap273 _4065_/A VGND VGND VPWR VPWR _3880_/A sky130_fd_sc_hd__buf_2
X_7276_ _7267_/X _4921_/X _7280_/A3 _7280_/B1 hold868/X VGND VGND VPWR VPWR _8696_/D
+ sky130_fd_sc_hd__a32o_2
X_4488_ _8117_/Q _8198_/Q _4497_/S VGND VGND VPWR VPWR _4488_/X sky130_fd_sc_hd__mux2_2
XFILLER_131_455 VGND VGND VPWR VPWR sky130_fd_sc_hd__decap_3
XFILLER_58_701 VGND VGND VPWR VPWR sky130_fd_sc_hd__decap_3
X_6227_ _6227_/A VGND VGND VPWR VPWR _8174_/D sky130_fd_sc_hd__buf_6
XFILLER_131_488 VGND VGND VPWR VPWR sky130_fd_sc_hd__decap_3
XFILLER_66_27 VGND VGND VPWR VPWR sky130_fd_sc_hd__fill_1
X_6158_ _6158_/A VGND VGND VPWR VPWR _8141_/D sky130_fd_sc_hd__buf_6
XFILLER_111_190 VGND VGND VPWR VPWR sky130_fd_sc_hd__decap_3
X_5109_ _5109_/A VGND VGND VPWR VPWR _7613_/D sky130_fd_sc_hd__buf_1
XFILLER_122_11 VGND VGND VPWR VPWR sky130_fd_sc_hd__decap_3
XFILLER_17_108 VGND VGND VPWR VPWR sky130_fd_sc_hd__decap_3
XFILLER_85_564 VGND VGND VPWR VPWR sky130_fd_sc_hd__decap_3
XTAP_TAPCELL_ROW_123_2013 VGND VPWR sky130_fd_sc_hd__tapvpwrvgnd_1
X_6089_ _8110_/Q _4840_/A _6095_/S VGND VGND VPWR VPWR _6090_/A sky130_fd_sc_hd__mux2_2
XFILLER_122_55 VGND VGND VPWR VPWR sky130_fd_sc_hd__fill_1
XFILLER_73_737 VGND VGND VPWR VPWR sky130_fd_sc_hd__fill_1
XFILLER_73_759 VGND VGND VPWR VPWR sky130_fd_sc_hd__decap_3
XFILLER_26_642 VGND VGND VPWR VPWR sky130_fd_sc_hd__fill_2
XFILLER_25_185 VGND VGND VPWR VPWR sky130_fd_sc_hd__decap_3
XFILLER_41_601 VGND VGND VPWR VPWR sky130_fd_sc_hd__decap_3
XFILLER_41_634 VGND VGND VPWR VPWR sky130_fd_sc_hd__decap_3
XFILLER_53_494 VGND VGND VPWR VPWR sky130_fd_sc_hd__fill_2
XFILLER_81_770 VGND VGND VPWR VPWR sky130_fd_sc_hd__decap_3
XTAP_TAPCELL_ROW_0_273 VGND VPWR sky130_fd_sc_hd__tapvpwrvgnd_1
XTAP_TAPCELL_ROW_0_284 VGND VPWR sky130_fd_sc_hd__tapvpwrvgnd_1
XTAP_TAPCELL_ROW_0_295 VGND VPWR sky130_fd_sc_hd__tapvpwrvgnd_1
XFILLER_15_42 VGND VGND VPWR VPWR sky130_fd_sc_hd__decap_3
XFILLER_15_75 VGND VGND VPWR VPWR sky130_fd_sc_hd__decap_3
XFILLER_41_667 VGND VGND VPWR VPWR sky130_fd_sc_hd__decap_3
XFILLER_31_41 VGND VGND VPWR VPWR sky130_fd_sc_hd__decap_3
Xclkbuf_leaf_26_CLK clkbuf_5_8__f_CLK/X VGND VGND VPWR VPWR _8608_/CLK sky130_fd_sc_hd__clkbuf_8
XFILLER_119_290 VGND VGND VPWR VPWR sky130_fd_sc_hd__decap_3
XFILLER_5_524 VGND VGND VPWR VPWR sky130_fd_sc_hd__fill_2
XTAP_TAPCELL_ROW_134_2164 VGND VPWR sky130_fd_sc_hd__tapvpwrvgnd_1
XTAP_TAPCELL_ROW_134_2175 VGND VPWR sky130_fd_sc_hd__tapvpwrvgnd_1
XFILLER_135_750 VGND VGND VPWR VPWR sky130_fd_sc_hd__decap_3
XFILLER_135_772 VGND VGND VPWR VPWR sky130_fd_sc_hd__decap_3
XFILLER_134_271 VGND VGND VPWR VPWR sky130_fd_sc_hd__decap_3
XFILLER_135_794 VGND VGND VPWR VPWR sky130_fd_sc_hd__decap_3
XFILLER_1_741 VGND VGND VPWR VPWR sky130_fd_sc_hd__decap_3
XTAP_TAPCELL_ROW_52_1019 VGND VPWR sky130_fd_sc_hd__tapvpwrvgnd_1
Xoutput85 _8053_/Q VGND VGND VPWR VPWR empty sky130_fd_sc_hd__clkdlybuf4s25_1
XFILLER_103_680 VGND VGND VPWR VPWR sky130_fd_sc_hd__fill_1
XFILLER_122_477 VGND VGND VPWR VPWR sky130_fd_sc_hd__fill_1
XFILLER_122_499 VGND VGND VPWR VPWR sky130_fd_sc_hd__decap_3
XFILLER_1_774 VGND VGND VPWR VPWR sky130_fd_sc_hd__decap_3
XFILLER_1_785 VGND VGND VPWR VPWR sky130_fd_sc_hd__decap_3
Xoutput96 _4003_/X VGND VGND VPWR VPWR rdata[18] sky130_fd_sc_hd__clkdlybuf4s25_1
XFILLER_0_284 VGND VGND VPWR VPWR sky130_fd_sc_hd__fill_1
XFILLER_36_406 VGND VGND VPWR VPWR sky130_fd_sc_hd__decap_3
XFILLER_36_417 VGND VGND VPWR VPWR sky130_fd_sc_hd__decap_3
XFILLER_64_704 VGND VGND VPWR VPWR sky130_fd_sc_hd__decap_3
XFILLER_76_575 VGND VGND VPWR VPWR sky130_fd_sc_hd__decap_3
XTAP_TAPCELL_ROW_108_1808 VGND VPWR sky130_fd_sc_hd__tapvpwrvgnd_1
XFILLER_17_620 VGND VGND VPWR VPWR sky130_fd_sc_hd__decap_3
XFILLER_63_225 VGND VGND VPWR VPWR sky130_fd_sc_hd__fill_1
XFILLER_91_523 VGND VGND VPWR VPWR sky130_fd_sc_hd__decap_3
XTAP_TAPCELL_ROW_47_946 VGND VPWR sky130_fd_sc_hd__tapvpwrvgnd_1
XTAP_TAPCELL_ROW_47_957 VGND VPWR sky130_fd_sc_hd__tapvpwrvgnd_1
XFILLER_16_141 VGND VGND VPWR VPWR sky130_fd_sc_hd__decap_3
XFILLER_17_642 VGND VGND VPWR VPWR sky130_fd_sc_hd__decap_3
XFILLER_91_567 VGND VGND VPWR VPWR sky130_fd_sc_hd__fill_2
XTAP_TAPCELL_ROW_27_670 VGND VPWR sky130_fd_sc_hd__tapvpwrvgnd_1
XFILLER_31_133 VGND VGND VPWR VPWR sky130_fd_sc_hd__fill_2
XFILLER_32_634 VGND VGND VPWR VPWR sky130_fd_sc_hd__decap_3
X_3790_ _3890_/A VGND VGND VPWR VPWR _3791_/A sky130_fd_sc_hd__clkbuf_2
XTAP_TAPCELL_ROW_119_1959 VGND VPWR sky130_fd_sc_hd__tapvpwrvgnd_1
Xclkbuf_leaf_17_CLK clkbuf_leaf_52_CLK/A VGND VGND VPWR VPWR _8802_/CLK sky130_fd_sc_hd__clkbuf_8
X_5460_ _5460_/A VGND VGND VPWR VPWR _7778_/D sky130_fd_sc_hd__buf_1
XFILLER_133_709 VGND VGND VPWR VPWR sky130_fd_sc_hd__decap_3
X_4411_ _8434_/Q _8515_/Q _4414_/S VGND VGND VPWR VPWR _4411_/X sky130_fd_sc_hd__mux2_2
XFILLER_126_750 VGND VGND VPWR VPWR sky130_fd_sc_hd__decap_3
XTAP_TAPCELL_ROW_78_1380 VGND VPWR sky130_fd_sc_hd__tapvpwrvgnd_1
X_5391_ _5391_/A VGND VGND VPWR VPWR _7745_/D sky130_fd_sc_hd__buf_1
XFILLER_113_411 VGND VGND VPWR VPWR sky130_fd_sc_hd__fill_1
XFILLER_99_623 VGND VGND VPWR VPWR sky130_fd_sc_hd__fill_2
XTAP_TAPCELL_ROW_78_1391 VGND VPWR sky130_fd_sc_hd__tapvpwrvgnd_1
X_7130_ _4853_/X _8599_/Q _7130_/S VGND VGND VPWR VPWR _7131_/A sky130_fd_sc_hd__mux2_2
X_4342_ _4339_/X _4340_/X _4341_/X _4342_/B2 VGND VGND VPWR VPWR _4342_/X sky130_fd_sc_hd__a22o_2
XFILLER_113_433 VGND VGND VPWR VPWR sky130_fd_sc_hd__decap_3
XFILLER_113_455 VGND VGND VPWR VPWR sky130_fd_sc_hd__decap_3
XFILLER_98_144 VGND VGND VPWR VPWR sky130_fd_sc_hd__decap_3
Xfanout319 _4672_/S VGND VGND VPWR VPWR _3827_/A1 sky130_fd_sc_hd__clkdlybuf4s25_1
X_7061_ _4715_/X _8566_/Q _7067_/S VGND VGND VPWR VPWR _7062_/A sky130_fd_sc_hd__mux2_1
X_4273_ _4273_/A _4273_/B VGND VGND VPWR VPWR _4273_/X sky130_fd_sc_hd__or2_2
XFILLER_86_328 VGND VGND VPWR VPWR sky130_fd_sc_hd__fill_1
X_6012_ _6012_/A VGND VGND VPWR VPWR _8073_/D sky130_fd_sc_hd__buf_1
.ends
